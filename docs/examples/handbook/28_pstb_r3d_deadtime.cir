* 28_pstb_r3d_deadtime.cir -- handbook example (card #534): periodic loop gain (.pstb) of R3d, same circuit as
* 26_pss_r3d_deadtime.cir. Body of tests/fixtures/rd_pstb_r3d.cir. NOT validated against an independent reference in
* this handbook (card #531 is open: the R3d PAC/PSTB-vs-FRA comparisons in tests/test_r3d_r4d.py do not pass yet).
.param vin_v=12 fs=500k tclk={1/fs}
.param lval=10u rdcr=10m cval=100u esrval=10m rload=3.3
.param ra=2300 rb=1000 vref=1
.param r1=10k r2=27.51k r3=101.7 c1=36.35p c2=2.299n c3=6.261n
.param vramp=2
.param gm_oa=1000 ro_oa=100 co_oa=100p
.param gon=70 goff=1e-6 kc=100
.param rdt=430 rdisch=60 cdt=100p kswd=150
* kswd raised from a first trial's 15 (hand-estimated for a ~15ns
* transition, see the derivation above) to 150: found empirically (card
* #479) that gon=70 is large enough that even a small residual gate
* fraction (kswd=15's tail at, e.g., dly 0.19 away from the 0.5 threshold)
* still gives amp-scale conductance*V, so a genuine current-based overlap
* check (independently re-deriving I_hs/I_ls from the same B-source
* formulas ngspice itself evaluates, as tools/loss.py does) found up to
* ~0.78A of simultaneous hs/ls current with kswd=15 -- comparable to the
* ~1A load, failing the <1% bound outright, even though the two gate
* nodes' own 0.5-crossings were cleanly separated by ~20ns. kswd=150
* makes the tanh's tail fall off fast enough (conductance within ~1e-5 of
* goff by ~0.1 away from the 0.5 crossing, well inside the dead-time gap)
* that the residual current in the gap is negligible -- see MEASURED
* below and tests/test_refs_d.py's dead-time/overlap check. This does
* make the switch's own transition faster than the 10-20ns example the
* task gave (the RC network's own slew, times the now-much-narrower
* tanh window, works out to ~1-2ns -- still a genuine smooth/finite
* transition, just faster than the suggestion; a slower transition and a
* clean (<1% of load) dead-time gap turned out to be in tension for a
* single-stage tanh fed by this RC network's slew, and correctness (no
* shoot-through) was prioritised, per the task's own ranked pass/fail
* list).
* kc raised from R3's 30 to 100: found empirically (card #479) that the
* PWM comparator's own falling edge (which happens during the sawtooth
* ramp's SLOW rise portion, not its fast retrace) has an intrinsic width
* of ~1/kc/(ramp slew) -- at kc=30 that is ~32ns, comparable to (not much
* faster than) the dead-time network's own RC_on=43ns, so the dead-time
* network was NOT the dominant delay on that edge and the two switches'
* gate nodes crossed 0.5 at nearly the same instant (near-zero effective
* dead time on that edge, confirmed by a first trial: i(vin) showed a
* -210A shoot-through spike). kc=100 shrinks that intrinsic width to
* ~10ns, well under RC_on, so the RC network is what actually sets the
* delay on both edges. The OTHER edge (pwm's rising edge, at the ramp's
* fast retrace) was already fast at kc=30 and stays fast here.

Vin vin 0 DC {vin_v}

* smooth high-side (vin->sw) and low-side (sw->0) switches, driven by the
* dead-time-delayed gate nodes dly_hs/dly_ls (NOT directly by pwm/1-pwm,
* which is what R3 does and is exactly the missing-dead-time gap this deck
* fixes)
Bhs vin sw I = (V(vin)-V(sw)) * ({goff}+({gon}-{goff})*0.5*(1+tanh({kswd}*(V(dly_hs)-0.5))))
Bls sw 0   I = V(sw)              * ({goff}+({gon}-{goff})*0.5*(1+tanh({kswd}*(V(dly_ls)-0.5))))

* body/freewheel diode for the low side during the dead zone. Built as a
* smooth B-source (soft-knee: ~zero below vfbody, ~linear with an
* effective 1/gbody=20 mOhm "on-resistance" above it) rather than a native
* ngspice `D` device: found empirically (card #479) that tools/loss.py
* (used to check the 85%-efficiency/0.5%-energy-balance pass/fail bounds,
* per the task) has no handling for device kind `D` at all -- a native
* diode's dissipated power is silently excluded from its sum, and this
* device carries enough current during the dead-time interval (the
* inductor current freewheeling through it) that the resulting energy-
* balance residual came out to 0.5249% with a native D device, just over
* the 0.5% bound. loss.py DOES handle `B, I=expr` devices correctly (its
* own documented "bexpr" method, re-deriving current from the parsed
* expression -- see docs/loss.md), so rebuilding the body diode as one
* fixes the accounting without changing its physical behaviour: still a
* smooth, continuous function of Vd (no event, no ideal switch), just not
* ngspice's own exponential diode primitive. vfbody=0.6V, gbody=50 (1/
* gbody=20 mOhm, comparable to the switches' own Ron), kbody=50 (a
* deliberately soft ~20mV knee, since this is a control-style smooth
* model, not an attempt to match a real body diode's exponential I-V).
.param vfbody=0.6 gbody=50 kbody=50
Bbody 0 sw I = {gbody}*(-V(sw)-{vfbody})*0.5*(1+tanh({kbody}*(-V(sw)-{vfbody})))

Csw sw 0 100p
L1 sw swl {lval} IC=0
Rdcr swl vout {rdcr}
Resr vout cx {esrval}
Cout cx 0 {cval} IC=0
Rload vout 0 {rload}

* feedback: probe, divider, error amp (type-III, identical to R3), PWM comparator
Vprobe fbtop vout DC 0
Ra fbtop fbnode {ra}
Rb fbnode 0 {rb}

Vrefsrc vrefnode 0 DC {vref}
Goa 0 opout vrefnode compin {gm_oa}
Roa opout 0 {ro_oa}
Coa opout 0 {co_oa}

R1in fbnode compin {r1}
R3in fbnode n3 {r3}
C3in n3 compin {c3}
C1f compin opout {c1}
R2f compin n2 {r2}
C2f n2 opout {c2}

Vramp ramp 0 PULSE(0 {vramp} 0 {0.97*tclk} {0.03*tclk} 1n {tclk})
Bcmp pwm 0 V = 0.5*(1+tanh({kc}*(V(opout)-V(ramp))))

* dead-time steering network: pwm_inv is a separate B-source complement
* (not a wire tap) so it has the same zero-output-impedance drive as pwm
* itself and can source/sink the Rchg/Rdis branch currents cleanly
Bpwminv pwm_inv 0 V = 1-V(pwm)

* IS raised to 1e-6 (from a first trial's 1e-14, a "normal" ~0.6-0.7V-knee
* Si diode model): found empirically (card #479) that a normal diode knee
* is enormous relative to the 0-1V control-signal swing here, so the
* "fast discharge" path barely conducted for most of the transition and
* dly_hs/dly_ls ended up crossing 0.5 almost together anyway (a first
* trial's i(vin) showed a -159A spike). IS=1e-6 (Schottky-like, low knee)
* lets this small-signal steering diode actually turn on within the
* available ~1V swing.
.model ddt D(IS=1e-6 N=1.0)

Rchg_hs pwm dly_hs {rdt}
Ddis_hs dly_hs dis_hs ddt
Rdis_hs dis_hs pwm {rdisch}
Cdly_hs dly_hs 0 {cdt} IC=0

Rchg_ls pwm_inv dly_ls {rdt}
Ddis_ls dly_ls dis_ls ddt
Rdis_ls dis_ls pwm_inv {rdisch}
Cdly_ls dly_ls 0 {cdt} IC=0

.pstb 500e3 300e-6 vout 200 10 150 1e-6 dec 5 500 200000 probe="Vprobe" method="shoot"
.control
set filetype=ascii
set wr_singlescale
set wr_vecnames
set numdgt=15
run
wrdata pstb_r3d.txt t
.endc
.end
