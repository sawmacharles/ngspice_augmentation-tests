* 05_stb_instant.cir -- .stb ... instant, linearising at a REAL transient
* time point instead of a fresh DC operating point (docs/stb.md "Instant
* mode"). LDO-style loop with a soft-start ramp (Vss) driving a nonlinear
* pass device (Bpass, tanh) -- loop gain genuinely depends on how far the
* ramp has gotten. .tran's own tstop IS the instant time t_k (100us,
* 1/5 of the way through the 500us soft-start ramp); .tran and .stb run
* together via one `run`, per docs/stb.md's "Both must be top-level
* netlist cards, run together" requirement.
.param vin_v=5
.param gm1=2m rp1=200k cp1=50p
.param gm2=0.15 vth2=0 k2=3
.param rout=30 esr=20m cout=10u
.param rf1=68k rf2=12k
.param tss=500u vref_final=0.45

Vin vin 0 DC {vin_v}
Vss vss 0 PWL(0 0 {tss} {vref_final} 2m {vref_final})
G1 0 ea vss fb {gm1}
Rp1 ea 0 {rp1}
Cp1 ea 0 {cp1}

Bpass vin vout I = {gm2}*tanh({k2}*(V(ea)-{vth2}))

Rout vout 0 {rout}
Cout vout esrnode {cout}
Resr esrnode 0 {esr}

Rf1 vout fbtop {rf1}
Rf2 fbtop 0 {rf2}

Vprobe fb fbtop DC 0

.tran 50n 100u 0 uic
.stb dec 30 1 1e8 probe=Vprobe instant
.control
run
print stb2.phasemargin stb2.phasemarginfreq
quit
.endc
.end
