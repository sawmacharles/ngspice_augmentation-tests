* e_pex_tree -- PEX-sized synchronous buck, synthetic
* (ngspice_augmentation card #467/#478, plan T9.1/T9.2; generated by
* bench/gen_pex_buck.py --topology tree -- do not hand-edit,
* regenerate instead). Not derived from any real deck.
*
* Power stage / compensator topology as refs/r3_vm_buck.cir (12V->3.3V,
* fs=500kHz; see that file for the full compensator design derivation) but:
*  - HS/LS switches are 30/30-finger BSIM4 (level=54)
*    arrays instead of smooth B-source ideal switches (device-eval load).
*  - a tree-shaped synthetic PEX net (11111 nodes: branch=10, depth=4, plus local-mesh loops and cross-subtree coupling caps -- see bench/gen_pex_buck.py's tree_lines() docstring) is coupled onto vout
*    (matrix-size load; ~11111 extra unknowns, sparse).
* run: ngspice -b <this file>  (writes to
*  ~/Work/data/ngspice_augmentation/accel/bench/<deck>/, never into the repo)

.param vin_v=12 fs=500k tclk={1/fs}
.param lval=10u rdcr=10m cval=100u esrval=10m rload=3.3
.param ra=2300 rb=1000 vref=1
.param r1=10k r2=27.51k r3=101.7 c1=36.35p c2=2.299n c3=6.261n
.param vramp=2
.param gm_oa=1000 ro_oa=100 co_oa=100p
.param kc=30
.param vgate=5

* --- plausible inline BSIM4 model, NOT calibrated to any real process
* (deliberately simple: capmod=0, most extra-term flags off, same
* minimisation style as tests/fixtures/stb3_bsim4_cgd.cir) ---
.model nch4 nmos level=54 version=4.8.2
+ mobmod=0 capmod=0 igcmod=0 igbmod=0 rdsmod=0 rbodymod=0 rgatemod=0 acnqsmod=0
+ toxe=5e-9 toxp=5e-9 toxm=5e-9
+ vth0=0.7 k1=0.4 k2=0 k3=0 w0=2.5e-6
+ u0=300 vsat=1.1e5
+ cgso=2e-10 cgdo=2e-10 cgbo=0 cgsl=0 cgdl=0
+ cf=0 cjs=1e-4 cjd=1e-4 cjswd=1e-10 cjswgd=1e-10

Vin vin 0 DC {vin_v}

* --- PWM comparator (as r3): pwm in [0,1], high = HS on ---
Vramp ramp 0 PULSE(0 {vramp} 0 {0.97*tclk} {0.03*tclk} 1n {tclk})
Bcmp pwm 0 V = 0.5*(1+tanh({kc}*(V(opout)-V(ramp))))
Bpwmls pwm_ls 0 V = 1-V(pwm)

* --- gate drive: ideal bootstrap-style level shifters (not BSIM4 -- the
* driver itself is not the device-eval target here) ---
Ehsgate hsgate_bus sw pwm 0 {vgate}
Elsgate lsgate_bus 0 pwm_ls 0 {vgate}

* --- HS switch: 30-finger BSIM4 array, drain=vin bus, source=sw bus ---
Mhs0 hs_d0 hs_g0 hs_s0 hs_s0 nch4 w=0.002 l=0.35u
Rfdhs0 vin hs_d0 0.02
Rfghs0 hsgate_bus hs_g0 0.02
Rfshs0 sw hs_s0 0.02
Mhs1 hs_d1 hs_g1 hs_s1 hs_s1 nch4 w=0.002 l=0.35u
Rfdhs1 vin hs_d1 0.02
Rfghs1 hsgate_bus hs_g1 0.02
Rfshs1 sw hs_s1 0.02
Mhs2 hs_d2 hs_g2 hs_s2 hs_s2 nch4 w=0.002 l=0.35u
Rfdhs2 vin hs_d2 0.02
Rfghs2 hsgate_bus hs_g2 0.02
Rfshs2 sw hs_s2 0.02
Mhs3 hs_d3 hs_g3 hs_s3 hs_s3 nch4 w=0.002 l=0.35u
Rfdhs3 vin hs_d3 0.02
Rfghs3 hsgate_bus hs_g3 0.02
Rfshs3 sw hs_s3 0.02
Mhs4 hs_d4 hs_g4 hs_s4 hs_s4 nch4 w=0.002 l=0.35u
Rfdhs4 vin hs_d4 0.02
Rfghs4 hsgate_bus hs_g4 0.02
Rfshs4 sw hs_s4 0.02
Mhs5 hs_d5 hs_g5 hs_s5 hs_s5 nch4 w=0.002 l=0.35u
Rfdhs5 vin hs_d5 0.02
Rfghs5 hsgate_bus hs_g5 0.02
Rfshs5 sw hs_s5 0.02
Mhs6 hs_d6 hs_g6 hs_s6 hs_s6 nch4 w=0.002 l=0.35u
Rfdhs6 vin hs_d6 0.02
Rfghs6 hsgate_bus hs_g6 0.02
Rfshs6 sw hs_s6 0.02
Mhs7 hs_d7 hs_g7 hs_s7 hs_s7 nch4 w=0.002 l=0.35u
Rfdhs7 vin hs_d7 0.02
Rfghs7 hsgate_bus hs_g7 0.02
Rfshs7 sw hs_s7 0.02
Mhs8 hs_d8 hs_g8 hs_s8 hs_s8 nch4 w=0.002 l=0.35u
Rfdhs8 vin hs_d8 0.02
Rfghs8 hsgate_bus hs_g8 0.02
Rfshs8 sw hs_s8 0.02
Mhs9 hs_d9 hs_g9 hs_s9 hs_s9 nch4 w=0.002 l=0.35u
Rfdhs9 vin hs_d9 0.02
Rfghs9 hsgate_bus hs_g9 0.02
Rfshs9 sw hs_s9 0.02
Mhs10 hs_d10 hs_g10 hs_s10 hs_s10 nch4 w=0.002 l=0.35u
Rfdhs10 vin hs_d10 0.02
Rfghs10 hsgate_bus hs_g10 0.02
Rfshs10 sw hs_s10 0.02
Mhs11 hs_d11 hs_g11 hs_s11 hs_s11 nch4 w=0.002 l=0.35u
Rfdhs11 vin hs_d11 0.02
Rfghs11 hsgate_bus hs_g11 0.02
Rfshs11 sw hs_s11 0.02
Mhs12 hs_d12 hs_g12 hs_s12 hs_s12 nch4 w=0.002 l=0.35u
Rfdhs12 vin hs_d12 0.02
Rfghs12 hsgate_bus hs_g12 0.02
Rfshs12 sw hs_s12 0.02
Mhs13 hs_d13 hs_g13 hs_s13 hs_s13 nch4 w=0.002 l=0.35u
Rfdhs13 vin hs_d13 0.02
Rfghs13 hsgate_bus hs_g13 0.02
Rfshs13 sw hs_s13 0.02
Mhs14 hs_d14 hs_g14 hs_s14 hs_s14 nch4 w=0.002 l=0.35u
Rfdhs14 vin hs_d14 0.02
Rfghs14 hsgate_bus hs_g14 0.02
Rfshs14 sw hs_s14 0.02
Mhs15 hs_d15 hs_g15 hs_s15 hs_s15 nch4 w=0.002 l=0.35u
Rfdhs15 vin hs_d15 0.02
Rfghs15 hsgate_bus hs_g15 0.02
Rfshs15 sw hs_s15 0.02
Mhs16 hs_d16 hs_g16 hs_s16 hs_s16 nch4 w=0.002 l=0.35u
Rfdhs16 vin hs_d16 0.02
Rfghs16 hsgate_bus hs_g16 0.02
Rfshs16 sw hs_s16 0.02
Mhs17 hs_d17 hs_g17 hs_s17 hs_s17 nch4 w=0.002 l=0.35u
Rfdhs17 vin hs_d17 0.02
Rfghs17 hsgate_bus hs_g17 0.02
Rfshs17 sw hs_s17 0.02
Mhs18 hs_d18 hs_g18 hs_s18 hs_s18 nch4 w=0.002 l=0.35u
Rfdhs18 vin hs_d18 0.02
Rfghs18 hsgate_bus hs_g18 0.02
Rfshs18 sw hs_s18 0.02
Mhs19 hs_d19 hs_g19 hs_s19 hs_s19 nch4 w=0.002 l=0.35u
Rfdhs19 vin hs_d19 0.02
Rfghs19 hsgate_bus hs_g19 0.02
Rfshs19 sw hs_s19 0.02
Mhs20 hs_d20 hs_g20 hs_s20 hs_s20 nch4 w=0.002 l=0.35u
Rfdhs20 vin hs_d20 0.02
Rfghs20 hsgate_bus hs_g20 0.02
Rfshs20 sw hs_s20 0.02
Mhs21 hs_d21 hs_g21 hs_s21 hs_s21 nch4 w=0.002 l=0.35u
Rfdhs21 vin hs_d21 0.02
Rfghs21 hsgate_bus hs_g21 0.02
Rfshs21 sw hs_s21 0.02
Mhs22 hs_d22 hs_g22 hs_s22 hs_s22 nch4 w=0.002 l=0.35u
Rfdhs22 vin hs_d22 0.02
Rfghs22 hsgate_bus hs_g22 0.02
Rfshs22 sw hs_s22 0.02
Mhs23 hs_d23 hs_g23 hs_s23 hs_s23 nch4 w=0.002 l=0.35u
Rfdhs23 vin hs_d23 0.02
Rfghs23 hsgate_bus hs_g23 0.02
Rfshs23 sw hs_s23 0.02
Mhs24 hs_d24 hs_g24 hs_s24 hs_s24 nch4 w=0.002 l=0.35u
Rfdhs24 vin hs_d24 0.02
Rfghs24 hsgate_bus hs_g24 0.02
Rfshs24 sw hs_s24 0.02
Mhs25 hs_d25 hs_g25 hs_s25 hs_s25 nch4 w=0.002 l=0.35u
Rfdhs25 vin hs_d25 0.02
Rfghs25 hsgate_bus hs_g25 0.02
Rfshs25 sw hs_s25 0.02
Mhs26 hs_d26 hs_g26 hs_s26 hs_s26 nch4 w=0.002 l=0.35u
Rfdhs26 vin hs_d26 0.02
Rfghs26 hsgate_bus hs_g26 0.02
Rfshs26 sw hs_s26 0.02
Mhs27 hs_d27 hs_g27 hs_s27 hs_s27 nch4 w=0.002 l=0.35u
Rfdhs27 vin hs_d27 0.02
Rfghs27 hsgate_bus hs_g27 0.02
Rfshs27 sw hs_s27 0.02
Mhs28 hs_d28 hs_g28 hs_s28 hs_s28 nch4 w=0.002 l=0.35u
Rfdhs28 vin hs_d28 0.02
Rfghs28 hsgate_bus hs_g28 0.02
Rfshs28 sw hs_s28 0.02
Mhs29 hs_d29 hs_g29 hs_s29 hs_s29 nch4 w=0.002 l=0.35u
Rfdhs29 vin hs_d29 0.02
Rfghs29 hsgate_bus hs_g29 0.02
Rfshs29 sw hs_s29 0.02

* --- LS switch: 30-finger BSIM4 array, drain=sw bus, source=gnd ---
Mls0 ls_d0 ls_g0 ls_s0 ls_s0 nch4 w=0.002 l=0.35u
Rfdls0 sw ls_d0 0.02
Rfgls0 lsgate_bus ls_g0 0.02
Rfsls0 0 ls_s0 0.02
Mls1 ls_d1 ls_g1 ls_s1 ls_s1 nch4 w=0.002 l=0.35u
Rfdls1 sw ls_d1 0.02
Rfgls1 lsgate_bus ls_g1 0.02
Rfsls1 0 ls_s1 0.02
Mls2 ls_d2 ls_g2 ls_s2 ls_s2 nch4 w=0.002 l=0.35u
Rfdls2 sw ls_d2 0.02
Rfgls2 lsgate_bus ls_g2 0.02
Rfsls2 0 ls_s2 0.02
Mls3 ls_d3 ls_g3 ls_s3 ls_s3 nch4 w=0.002 l=0.35u
Rfdls3 sw ls_d3 0.02
Rfgls3 lsgate_bus ls_g3 0.02
Rfsls3 0 ls_s3 0.02
Mls4 ls_d4 ls_g4 ls_s4 ls_s4 nch4 w=0.002 l=0.35u
Rfdls4 sw ls_d4 0.02
Rfgls4 lsgate_bus ls_g4 0.02
Rfsls4 0 ls_s4 0.02
Mls5 ls_d5 ls_g5 ls_s5 ls_s5 nch4 w=0.002 l=0.35u
Rfdls5 sw ls_d5 0.02
Rfgls5 lsgate_bus ls_g5 0.02
Rfsls5 0 ls_s5 0.02
Mls6 ls_d6 ls_g6 ls_s6 ls_s6 nch4 w=0.002 l=0.35u
Rfdls6 sw ls_d6 0.02
Rfgls6 lsgate_bus ls_g6 0.02
Rfsls6 0 ls_s6 0.02
Mls7 ls_d7 ls_g7 ls_s7 ls_s7 nch4 w=0.002 l=0.35u
Rfdls7 sw ls_d7 0.02
Rfgls7 lsgate_bus ls_g7 0.02
Rfsls7 0 ls_s7 0.02
Mls8 ls_d8 ls_g8 ls_s8 ls_s8 nch4 w=0.002 l=0.35u
Rfdls8 sw ls_d8 0.02
Rfgls8 lsgate_bus ls_g8 0.02
Rfsls8 0 ls_s8 0.02
Mls9 ls_d9 ls_g9 ls_s9 ls_s9 nch4 w=0.002 l=0.35u
Rfdls9 sw ls_d9 0.02
Rfgls9 lsgate_bus ls_g9 0.02
Rfsls9 0 ls_s9 0.02
Mls10 ls_d10 ls_g10 ls_s10 ls_s10 nch4 w=0.002 l=0.35u
Rfdls10 sw ls_d10 0.02
Rfgls10 lsgate_bus ls_g10 0.02
Rfsls10 0 ls_s10 0.02
Mls11 ls_d11 ls_g11 ls_s11 ls_s11 nch4 w=0.002 l=0.35u
Rfdls11 sw ls_d11 0.02
Rfgls11 lsgate_bus ls_g11 0.02
Rfsls11 0 ls_s11 0.02
Mls12 ls_d12 ls_g12 ls_s12 ls_s12 nch4 w=0.002 l=0.35u
Rfdls12 sw ls_d12 0.02
Rfgls12 lsgate_bus ls_g12 0.02
Rfsls12 0 ls_s12 0.02
Mls13 ls_d13 ls_g13 ls_s13 ls_s13 nch4 w=0.002 l=0.35u
Rfdls13 sw ls_d13 0.02
Rfgls13 lsgate_bus ls_g13 0.02
Rfsls13 0 ls_s13 0.02
Mls14 ls_d14 ls_g14 ls_s14 ls_s14 nch4 w=0.002 l=0.35u
Rfdls14 sw ls_d14 0.02
Rfgls14 lsgate_bus ls_g14 0.02
Rfsls14 0 ls_s14 0.02
Mls15 ls_d15 ls_g15 ls_s15 ls_s15 nch4 w=0.002 l=0.35u
Rfdls15 sw ls_d15 0.02
Rfgls15 lsgate_bus ls_g15 0.02
Rfsls15 0 ls_s15 0.02
Mls16 ls_d16 ls_g16 ls_s16 ls_s16 nch4 w=0.002 l=0.35u
Rfdls16 sw ls_d16 0.02
Rfgls16 lsgate_bus ls_g16 0.02
Rfsls16 0 ls_s16 0.02
Mls17 ls_d17 ls_g17 ls_s17 ls_s17 nch4 w=0.002 l=0.35u
Rfdls17 sw ls_d17 0.02
Rfgls17 lsgate_bus ls_g17 0.02
Rfsls17 0 ls_s17 0.02
Mls18 ls_d18 ls_g18 ls_s18 ls_s18 nch4 w=0.002 l=0.35u
Rfdls18 sw ls_d18 0.02
Rfgls18 lsgate_bus ls_g18 0.02
Rfsls18 0 ls_s18 0.02
Mls19 ls_d19 ls_g19 ls_s19 ls_s19 nch4 w=0.002 l=0.35u
Rfdls19 sw ls_d19 0.02
Rfgls19 lsgate_bus ls_g19 0.02
Rfsls19 0 ls_s19 0.02
Mls20 ls_d20 ls_g20 ls_s20 ls_s20 nch4 w=0.002 l=0.35u
Rfdls20 sw ls_d20 0.02
Rfgls20 lsgate_bus ls_g20 0.02
Rfsls20 0 ls_s20 0.02
Mls21 ls_d21 ls_g21 ls_s21 ls_s21 nch4 w=0.002 l=0.35u
Rfdls21 sw ls_d21 0.02
Rfgls21 lsgate_bus ls_g21 0.02
Rfsls21 0 ls_s21 0.02
Mls22 ls_d22 ls_g22 ls_s22 ls_s22 nch4 w=0.002 l=0.35u
Rfdls22 sw ls_d22 0.02
Rfgls22 lsgate_bus ls_g22 0.02
Rfsls22 0 ls_s22 0.02
Mls23 ls_d23 ls_g23 ls_s23 ls_s23 nch4 w=0.002 l=0.35u
Rfdls23 sw ls_d23 0.02
Rfgls23 lsgate_bus ls_g23 0.02
Rfsls23 0 ls_s23 0.02
Mls24 ls_d24 ls_g24 ls_s24 ls_s24 nch4 w=0.002 l=0.35u
Rfdls24 sw ls_d24 0.02
Rfgls24 lsgate_bus ls_g24 0.02
Rfsls24 0 ls_s24 0.02
Mls25 ls_d25 ls_g25 ls_s25 ls_s25 nch4 w=0.002 l=0.35u
Rfdls25 sw ls_d25 0.02
Rfgls25 lsgate_bus ls_g25 0.02
Rfsls25 0 ls_s25 0.02
Mls26 ls_d26 ls_g26 ls_s26 ls_s26 nch4 w=0.002 l=0.35u
Rfdls26 sw ls_d26 0.02
Rfgls26 lsgate_bus ls_g26 0.02
Rfsls26 0 ls_s26 0.02
Mls27 ls_d27 ls_g27 ls_s27 ls_s27 nch4 w=0.002 l=0.35u
Rfdls27 sw ls_d27 0.02
Rfgls27 lsgate_bus ls_g27 0.02
Rfsls27 0 ls_s27 0.02
Mls28 ls_d28 ls_g28 ls_s28 ls_s28 nch4 w=0.002 l=0.35u
Rfdls28 sw ls_d28 0.02
Rfgls28 lsgate_bus ls_g28 0.02
Rfsls28 0 ls_s28 0.02
Mls29 ls_d29 ls_g29 ls_s29 ls_s29 nch4 w=0.002 l=0.35u
Rfdls29 sw ls_d29 0.02
Rfgls29 lsgate_bus ls_g29 0.02
Rfsls29 0 ls_s29 0.02

Csw sw 0 100p
L1 sw swl {lval} IC=0
Rdcr swl vout {rdcr}
Resr vout cx {esrval}
Cout cx 0 {cval} IC=0
Rload vout 0 {rload}

* --- feedback divider + type-III error amp (as r3, inline op-amp) ---
Ra vout fbnode {ra}
Rb fbnode 0 {rb}

Vrefsrc vrefnode 0 DC {vref}
Goa opout 0 vrefnode compin {gm_oa}
Roa opout 0 {ro_oa}
Coa opout 0 {co_oa}

R1in fbnode compin {r1}
R3in fbnode n3 {r3}
C3in n3 compin {c3}
C1f compin opout {c1}
R2f compin n2 {r2}
C2f n2 opout {c2}

* --- synthetic PEX net: tree topology, 11111 nodes, coupled onto vout ---
Rtreecouple vout tree_0 10
* tree-shaped synthetic PEX net: branch=10 depth=4, rtrace0=0.2 (x1.6/level), cplane0=2e-14 (x0.6/level), local-mesh-stride=3, coupling-caps=40
Cp_0 tree_0 0 2e-14
Rtr_0_1 tree_0 tree_1 0.2
Cp_1 tree_1 0 1.2e-14
Rtr_0_2 tree_0 tree_2 0.2
Cp_2 tree_2 0 1.2e-14
Rtr_0_3 tree_0 tree_3 0.2
Cp_3 tree_3 0 1.2e-14
Rtr_0_4 tree_0 tree_4 0.2
Cp_4 tree_4 0 1.2e-14
Rtr_0_5 tree_0 tree_5 0.2
Cp_5 tree_5 0 1.2e-14
Rtr_0_6 tree_0 tree_6 0.2
Cp_6 tree_6 0 1.2e-14
Rtr_0_7 tree_0 tree_7 0.2
Cp_7 tree_7 0 1.2e-14
Rtr_0_8 tree_0 tree_8 0.2
Cp_8 tree_8 0 1.2e-14
Rtr_0_9 tree_0 tree_9 0.2
Cp_9 tree_9 0 1.2e-14
Rtr_0_10 tree_0 tree_10 0.2
Cp_10 tree_10 0 1.2e-14
Rtr_1_11 tree_1 tree_11 0.32
Cp_11 tree_11 0 7.2e-15
Rtr_1_12 tree_1 tree_12 0.32
Cp_12 tree_12 0 7.2e-15
Rtr_1_13 tree_1 tree_13 0.32
Cp_13 tree_13 0 7.2e-15
Rtr_1_14 tree_1 tree_14 0.32
Cp_14 tree_14 0 7.2e-15
Rtr_1_15 tree_1 tree_15 0.32
Cp_15 tree_15 0 7.2e-15
Rtr_1_16 tree_1 tree_16 0.32
Cp_16 tree_16 0 7.2e-15
Rtr_1_17 tree_1 tree_17 0.32
Cp_17 tree_17 0 7.2e-15
Rtr_1_18 tree_1 tree_18 0.32
Cp_18 tree_18 0 7.2e-15
Rtr_1_19 tree_1 tree_19 0.32
Cp_19 tree_19 0 7.2e-15
Rtr_1_20 tree_1 tree_20 0.32
Cp_20 tree_20 0 7.2e-15
Rtr_2_21 tree_2 tree_21 0.32
Cp_21 tree_21 0 7.2e-15
Rtr_2_22 tree_2 tree_22 0.32
Cp_22 tree_22 0 7.2e-15
Rtr_2_23 tree_2 tree_23 0.32
Cp_23 tree_23 0 7.2e-15
Rtr_2_24 tree_2 tree_24 0.32
Cp_24 tree_24 0 7.2e-15
Rtr_2_25 tree_2 tree_25 0.32
Cp_25 tree_25 0 7.2e-15
Rtr_2_26 tree_2 tree_26 0.32
Cp_26 tree_26 0 7.2e-15
Rtr_2_27 tree_2 tree_27 0.32
Cp_27 tree_27 0 7.2e-15
Rtr_2_28 tree_2 tree_28 0.32
Cp_28 tree_28 0 7.2e-15
Rtr_2_29 tree_2 tree_29 0.32
Cp_29 tree_29 0 7.2e-15
Rtr_2_30 tree_2 tree_30 0.32
Cp_30 tree_30 0 7.2e-15
Rtr_3_31 tree_3 tree_31 0.32
Cp_31 tree_31 0 7.2e-15
Rtr_3_32 tree_3 tree_32 0.32
Cp_32 tree_32 0 7.2e-15
Rtr_3_33 tree_3 tree_33 0.32
Cp_33 tree_33 0 7.2e-15
Rtr_3_34 tree_3 tree_34 0.32
Cp_34 tree_34 0 7.2e-15
Rtr_3_35 tree_3 tree_35 0.32
Cp_35 tree_35 0 7.2e-15
Rtr_3_36 tree_3 tree_36 0.32
Cp_36 tree_36 0 7.2e-15
Rtr_3_37 tree_3 tree_37 0.32
Cp_37 tree_37 0 7.2e-15
Rtr_3_38 tree_3 tree_38 0.32
Cp_38 tree_38 0 7.2e-15
Rtr_3_39 tree_3 tree_39 0.32
Cp_39 tree_39 0 7.2e-15
Rtr_3_40 tree_3 tree_40 0.32
Cp_40 tree_40 0 7.2e-15
Rtr_4_41 tree_4 tree_41 0.32
Cp_41 tree_41 0 7.2e-15
Rtr_4_42 tree_4 tree_42 0.32
Cp_42 tree_42 0 7.2e-15
Rtr_4_43 tree_4 tree_43 0.32
Cp_43 tree_43 0 7.2e-15
Rtr_4_44 tree_4 tree_44 0.32
Cp_44 tree_44 0 7.2e-15
Rtr_4_45 tree_4 tree_45 0.32
Cp_45 tree_45 0 7.2e-15
Rtr_4_46 tree_4 tree_46 0.32
Cp_46 tree_46 0 7.2e-15
Rtr_4_47 tree_4 tree_47 0.32
Cp_47 tree_47 0 7.2e-15
Rtr_4_48 tree_4 tree_48 0.32
Cp_48 tree_48 0 7.2e-15
Rtr_4_49 tree_4 tree_49 0.32
Cp_49 tree_49 0 7.2e-15
Rtr_4_50 tree_4 tree_50 0.32
Cp_50 tree_50 0 7.2e-15
Rtr_5_51 tree_5 tree_51 0.32
Cp_51 tree_51 0 7.2e-15
Rtr_5_52 tree_5 tree_52 0.32
Cp_52 tree_52 0 7.2e-15
Rtr_5_53 tree_5 tree_53 0.32
Cp_53 tree_53 0 7.2e-15
Rtr_5_54 tree_5 tree_54 0.32
Cp_54 tree_54 0 7.2e-15
Rtr_5_55 tree_5 tree_55 0.32
Cp_55 tree_55 0 7.2e-15
Rtr_5_56 tree_5 tree_56 0.32
Cp_56 tree_56 0 7.2e-15
Rtr_5_57 tree_5 tree_57 0.32
Cp_57 tree_57 0 7.2e-15
Rtr_5_58 tree_5 tree_58 0.32
Cp_58 tree_58 0 7.2e-15
Rtr_5_59 tree_5 tree_59 0.32
Cp_59 tree_59 0 7.2e-15
Rtr_5_60 tree_5 tree_60 0.32
Cp_60 tree_60 0 7.2e-15
Rtr_6_61 tree_6 tree_61 0.32
Cp_61 tree_61 0 7.2e-15
Rtr_6_62 tree_6 tree_62 0.32
Cp_62 tree_62 0 7.2e-15
Rtr_6_63 tree_6 tree_63 0.32
Cp_63 tree_63 0 7.2e-15
Rtr_6_64 tree_6 tree_64 0.32
Cp_64 tree_64 0 7.2e-15
Rtr_6_65 tree_6 tree_65 0.32
Cp_65 tree_65 0 7.2e-15
Rtr_6_66 tree_6 tree_66 0.32
Cp_66 tree_66 0 7.2e-15
Rtr_6_67 tree_6 tree_67 0.32
Cp_67 tree_67 0 7.2e-15
Rtr_6_68 tree_6 tree_68 0.32
Cp_68 tree_68 0 7.2e-15
Rtr_6_69 tree_6 tree_69 0.32
Cp_69 tree_69 0 7.2e-15
Rtr_6_70 tree_6 tree_70 0.32
Cp_70 tree_70 0 7.2e-15
Rtr_7_71 tree_7 tree_71 0.32
Cp_71 tree_71 0 7.2e-15
Rtr_7_72 tree_7 tree_72 0.32
Cp_72 tree_72 0 7.2e-15
Rtr_7_73 tree_7 tree_73 0.32
Cp_73 tree_73 0 7.2e-15
Rtr_7_74 tree_7 tree_74 0.32
Cp_74 tree_74 0 7.2e-15
Rtr_7_75 tree_7 tree_75 0.32
Cp_75 tree_75 0 7.2e-15
Rtr_7_76 tree_7 tree_76 0.32
Cp_76 tree_76 0 7.2e-15
Rtr_7_77 tree_7 tree_77 0.32
Cp_77 tree_77 0 7.2e-15
Rtr_7_78 tree_7 tree_78 0.32
Cp_78 tree_78 0 7.2e-15
Rtr_7_79 tree_7 tree_79 0.32
Cp_79 tree_79 0 7.2e-15
Rtr_7_80 tree_7 tree_80 0.32
Cp_80 tree_80 0 7.2e-15
Rtr_8_81 tree_8 tree_81 0.32
Cp_81 tree_81 0 7.2e-15
Rtr_8_82 tree_8 tree_82 0.32
Cp_82 tree_82 0 7.2e-15
Rtr_8_83 tree_8 tree_83 0.32
Cp_83 tree_83 0 7.2e-15
Rtr_8_84 tree_8 tree_84 0.32
Cp_84 tree_84 0 7.2e-15
Rtr_8_85 tree_8 tree_85 0.32
Cp_85 tree_85 0 7.2e-15
Rtr_8_86 tree_8 tree_86 0.32
Cp_86 tree_86 0 7.2e-15
Rtr_8_87 tree_8 tree_87 0.32
Cp_87 tree_87 0 7.2e-15
Rtr_8_88 tree_8 tree_88 0.32
Cp_88 tree_88 0 7.2e-15
Rtr_8_89 tree_8 tree_89 0.32
Cp_89 tree_89 0 7.2e-15
Rtr_8_90 tree_8 tree_90 0.32
Cp_90 tree_90 0 7.2e-15
Rtr_9_91 tree_9 tree_91 0.32
Cp_91 tree_91 0 7.2e-15
Rtr_9_92 tree_9 tree_92 0.32
Cp_92 tree_92 0 7.2e-15
Rtr_9_93 tree_9 tree_93 0.32
Cp_93 tree_93 0 7.2e-15
Rtr_9_94 tree_9 tree_94 0.32
Cp_94 tree_94 0 7.2e-15
Rtr_9_95 tree_9 tree_95 0.32
Cp_95 tree_95 0 7.2e-15
Rtr_9_96 tree_9 tree_96 0.32
Cp_96 tree_96 0 7.2e-15
Rtr_9_97 tree_9 tree_97 0.32
Cp_97 tree_97 0 7.2e-15
Rtr_9_98 tree_9 tree_98 0.32
Cp_98 tree_98 0 7.2e-15
Rtr_9_99 tree_9 tree_99 0.32
Cp_99 tree_99 0 7.2e-15
Rtr_9_100 tree_9 tree_100 0.32
Cp_100 tree_100 0 7.2e-15
Rtr_10_101 tree_10 tree_101 0.32
Cp_101 tree_101 0 7.2e-15
Rtr_10_102 tree_10 tree_102 0.32
Cp_102 tree_102 0 7.2e-15
Rtr_10_103 tree_10 tree_103 0.32
Cp_103 tree_103 0 7.2e-15
Rtr_10_104 tree_10 tree_104 0.32
Cp_104 tree_104 0 7.2e-15
Rtr_10_105 tree_10 tree_105 0.32
Cp_105 tree_105 0 7.2e-15
Rtr_10_106 tree_10 tree_106 0.32
Cp_106 tree_106 0 7.2e-15
Rtr_10_107 tree_10 tree_107 0.32
Cp_107 tree_107 0 7.2e-15
Rtr_10_108 tree_10 tree_108 0.32
Cp_108 tree_108 0 7.2e-15
Rtr_10_109 tree_10 tree_109 0.32
Cp_109 tree_109 0 7.2e-15
Rtr_10_110 tree_10 tree_110 0.32
Cp_110 tree_110 0 7.2e-15
Rtr_11_111 tree_11 tree_111 0.512
Cp_111 tree_111 0 4.32e-15
Rtr_11_112 tree_11 tree_112 0.512
Cp_112 tree_112 0 4.32e-15
Rtr_11_113 tree_11 tree_113 0.512
Cp_113 tree_113 0 4.32e-15
Rtr_11_114 tree_11 tree_114 0.512
Cp_114 tree_114 0 4.32e-15
Rtr_11_115 tree_11 tree_115 0.512
Cp_115 tree_115 0 4.32e-15
Rtr_11_116 tree_11 tree_116 0.512
Cp_116 tree_116 0 4.32e-15
Rtr_11_117 tree_11 tree_117 0.512
Cp_117 tree_117 0 4.32e-15
Rtr_11_118 tree_11 tree_118 0.512
Cp_118 tree_118 0 4.32e-15
Rtr_11_119 tree_11 tree_119 0.512
Cp_119 tree_119 0 4.32e-15
Rtr_11_120 tree_11 tree_120 0.512
Cp_120 tree_120 0 4.32e-15
Rtr_12_121 tree_12 tree_121 0.512
Cp_121 tree_121 0 4.32e-15
Rtr_12_122 tree_12 tree_122 0.512
Cp_122 tree_122 0 4.32e-15
Rtr_12_123 tree_12 tree_123 0.512
Cp_123 tree_123 0 4.32e-15
Rtr_12_124 tree_12 tree_124 0.512
Cp_124 tree_124 0 4.32e-15
Rtr_12_125 tree_12 tree_125 0.512
Cp_125 tree_125 0 4.32e-15
Rtr_12_126 tree_12 tree_126 0.512
Cp_126 tree_126 0 4.32e-15
Rtr_12_127 tree_12 tree_127 0.512
Cp_127 tree_127 0 4.32e-15
Rtr_12_128 tree_12 tree_128 0.512
Cp_128 tree_128 0 4.32e-15
Rtr_12_129 tree_12 tree_129 0.512
Cp_129 tree_129 0 4.32e-15
Rtr_12_130 tree_12 tree_130 0.512
Cp_130 tree_130 0 4.32e-15
Rtr_13_131 tree_13 tree_131 0.512
Cp_131 tree_131 0 4.32e-15
Rtr_13_132 tree_13 tree_132 0.512
Cp_132 tree_132 0 4.32e-15
Rtr_13_133 tree_13 tree_133 0.512
Cp_133 tree_133 0 4.32e-15
Rtr_13_134 tree_13 tree_134 0.512
Cp_134 tree_134 0 4.32e-15
Rtr_13_135 tree_13 tree_135 0.512
Cp_135 tree_135 0 4.32e-15
Rtr_13_136 tree_13 tree_136 0.512
Cp_136 tree_136 0 4.32e-15
Rtr_13_137 tree_13 tree_137 0.512
Cp_137 tree_137 0 4.32e-15
Rtr_13_138 tree_13 tree_138 0.512
Cp_138 tree_138 0 4.32e-15
Rtr_13_139 tree_13 tree_139 0.512
Cp_139 tree_139 0 4.32e-15
Rtr_13_140 tree_13 tree_140 0.512
Cp_140 tree_140 0 4.32e-15
Rtr_14_141 tree_14 tree_141 0.512
Cp_141 tree_141 0 4.32e-15
Rtr_14_142 tree_14 tree_142 0.512
Cp_142 tree_142 0 4.32e-15
Rtr_14_143 tree_14 tree_143 0.512
Cp_143 tree_143 0 4.32e-15
Rtr_14_144 tree_14 tree_144 0.512
Cp_144 tree_144 0 4.32e-15
Rtr_14_145 tree_14 tree_145 0.512
Cp_145 tree_145 0 4.32e-15
Rtr_14_146 tree_14 tree_146 0.512
Cp_146 tree_146 0 4.32e-15
Rtr_14_147 tree_14 tree_147 0.512
Cp_147 tree_147 0 4.32e-15
Rtr_14_148 tree_14 tree_148 0.512
Cp_148 tree_148 0 4.32e-15
Rtr_14_149 tree_14 tree_149 0.512
Cp_149 tree_149 0 4.32e-15
Rtr_14_150 tree_14 tree_150 0.512
Cp_150 tree_150 0 4.32e-15
Rtr_15_151 tree_15 tree_151 0.512
Cp_151 tree_151 0 4.32e-15
Rtr_15_152 tree_15 tree_152 0.512
Cp_152 tree_152 0 4.32e-15
Rtr_15_153 tree_15 tree_153 0.512
Cp_153 tree_153 0 4.32e-15
Rtr_15_154 tree_15 tree_154 0.512
Cp_154 tree_154 0 4.32e-15
Rtr_15_155 tree_15 tree_155 0.512
Cp_155 tree_155 0 4.32e-15
Rtr_15_156 tree_15 tree_156 0.512
Cp_156 tree_156 0 4.32e-15
Rtr_15_157 tree_15 tree_157 0.512
Cp_157 tree_157 0 4.32e-15
Rtr_15_158 tree_15 tree_158 0.512
Cp_158 tree_158 0 4.32e-15
Rtr_15_159 tree_15 tree_159 0.512
Cp_159 tree_159 0 4.32e-15
Rtr_15_160 tree_15 tree_160 0.512
Cp_160 tree_160 0 4.32e-15
Rtr_16_161 tree_16 tree_161 0.512
Cp_161 tree_161 0 4.32e-15
Rtr_16_162 tree_16 tree_162 0.512
Cp_162 tree_162 0 4.32e-15
Rtr_16_163 tree_16 tree_163 0.512
Cp_163 tree_163 0 4.32e-15
Rtr_16_164 tree_16 tree_164 0.512
Cp_164 tree_164 0 4.32e-15
Rtr_16_165 tree_16 tree_165 0.512
Cp_165 tree_165 0 4.32e-15
Rtr_16_166 tree_16 tree_166 0.512
Cp_166 tree_166 0 4.32e-15
Rtr_16_167 tree_16 tree_167 0.512
Cp_167 tree_167 0 4.32e-15
Rtr_16_168 tree_16 tree_168 0.512
Cp_168 tree_168 0 4.32e-15
Rtr_16_169 tree_16 tree_169 0.512
Cp_169 tree_169 0 4.32e-15
Rtr_16_170 tree_16 tree_170 0.512
Cp_170 tree_170 0 4.32e-15
Rtr_17_171 tree_17 tree_171 0.512
Cp_171 tree_171 0 4.32e-15
Rtr_17_172 tree_17 tree_172 0.512
Cp_172 tree_172 0 4.32e-15
Rtr_17_173 tree_17 tree_173 0.512
Cp_173 tree_173 0 4.32e-15
Rtr_17_174 tree_17 tree_174 0.512
Cp_174 tree_174 0 4.32e-15
Rtr_17_175 tree_17 tree_175 0.512
Cp_175 tree_175 0 4.32e-15
Rtr_17_176 tree_17 tree_176 0.512
Cp_176 tree_176 0 4.32e-15
Rtr_17_177 tree_17 tree_177 0.512
Cp_177 tree_177 0 4.32e-15
Rtr_17_178 tree_17 tree_178 0.512
Cp_178 tree_178 0 4.32e-15
Rtr_17_179 tree_17 tree_179 0.512
Cp_179 tree_179 0 4.32e-15
Rtr_17_180 tree_17 tree_180 0.512
Cp_180 tree_180 0 4.32e-15
Rtr_18_181 tree_18 tree_181 0.512
Cp_181 tree_181 0 4.32e-15
Rtr_18_182 tree_18 tree_182 0.512
Cp_182 tree_182 0 4.32e-15
Rtr_18_183 tree_18 tree_183 0.512
Cp_183 tree_183 0 4.32e-15
Rtr_18_184 tree_18 tree_184 0.512
Cp_184 tree_184 0 4.32e-15
Rtr_18_185 tree_18 tree_185 0.512
Cp_185 tree_185 0 4.32e-15
Rtr_18_186 tree_18 tree_186 0.512
Cp_186 tree_186 0 4.32e-15
Rtr_18_187 tree_18 tree_187 0.512
Cp_187 tree_187 0 4.32e-15
Rtr_18_188 tree_18 tree_188 0.512
Cp_188 tree_188 0 4.32e-15
Rtr_18_189 tree_18 tree_189 0.512
Cp_189 tree_189 0 4.32e-15
Rtr_18_190 tree_18 tree_190 0.512
Cp_190 tree_190 0 4.32e-15
Rtr_19_191 tree_19 tree_191 0.512
Cp_191 tree_191 0 4.32e-15
Rtr_19_192 tree_19 tree_192 0.512
Cp_192 tree_192 0 4.32e-15
Rtr_19_193 tree_19 tree_193 0.512
Cp_193 tree_193 0 4.32e-15
Rtr_19_194 tree_19 tree_194 0.512
Cp_194 tree_194 0 4.32e-15
Rtr_19_195 tree_19 tree_195 0.512
Cp_195 tree_195 0 4.32e-15
Rtr_19_196 tree_19 tree_196 0.512
Cp_196 tree_196 0 4.32e-15
Rtr_19_197 tree_19 tree_197 0.512
Cp_197 tree_197 0 4.32e-15
Rtr_19_198 tree_19 tree_198 0.512
Cp_198 tree_198 0 4.32e-15
Rtr_19_199 tree_19 tree_199 0.512
Cp_199 tree_199 0 4.32e-15
Rtr_19_200 tree_19 tree_200 0.512
Cp_200 tree_200 0 4.32e-15
Rtr_20_201 tree_20 tree_201 0.512
Cp_201 tree_201 0 4.32e-15
Rtr_20_202 tree_20 tree_202 0.512
Cp_202 tree_202 0 4.32e-15
Rtr_20_203 tree_20 tree_203 0.512
Cp_203 tree_203 0 4.32e-15
Rtr_20_204 tree_20 tree_204 0.512
Cp_204 tree_204 0 4.32e-15
Rtr_20_205 tree_20 tree_205 0.512
Cp_205 tree_205 0 4.32e-15
Rtr_20_206 tree_20 tree_206 0.512
Cp_206 tree_206 0 4.32e-15
Rtr_20_207 tree_20 tree_207 0.512
Cp_207 tree_207 0 4.32e-15
Rtr_20_208 tree_20 tree_208 0.512
Cp_208 tree_208 0 4.32e-15
Rtr_20_209 tree_20 tree_209 0.512
Cp_209 tree_209 0 4.32e-15
Rtr_20_210 tree_20 tree_210 0.512
Cp_210 tree_210 0 4.32e-15
Rtr_21_211 tree_21 tree_211 0.512
Cp_211 tree_211 0 4.32e-15
Rtr_21_212 tree_21 tree_212 0.512
Cp_212 tree_212 0 4.32e-15
Rtr_21_213 tree_21 tree_213 0.512
Cp_213 tree_213 0 4.32e-15
Rtr_21_214 tree_21 tree_214 0.512
Cp_214 tree_214 0 4.32e-15
Rtr_21_215 tree_21 tree_215 0.512
Cp_215 tree_215 0 4.32e-15
Rtr_21_216 tree_21 tree_216 0.512
Cp_216 tree_216 0 4.32e-15
Rtr_21_217 tree_21 tree_217 0.512
Cp_217 tree_217 0 4.32e-15
Rtr_21_218 tree_21 tree_218 0.512
Cp_218 tree_218 0 4.32e-15
Rtr_21_219 tree_21 tree_219 0.512
Cp_219 tree_219 0 4.32e-15
Rtr_21_220 tree_21 tree_220 0.512
Cp_220 tree_220 0 4.32e-15
Rtr_22_221 tree_22 tree_221 0.512
Cp_221 tree_221 0 4.32e-15
Rtr_22_222 tree_22 tree_222 0.512
Cp_222 tree_222 0 4.32e-15
Rtr_22_223 tree_22 tree_223 0.512
Cp_223 tree_223 0 4.32e-15
Rtr_22_224 tree_22 tree_224 0.512
Cp_224 tree_224 0 4.32e-15
Rtr_22_225 tree_22 tree_225 0.512
Cp_225 tree_225 0 4.32e-15
Rtr_22_226 tree_22 tree_226 0.512
Cp_226 tree_226 0 4.32e-15
Rtr_22_227 tree_22 tree_227 0.512
Cp_227 tree_227 0 4.32e-15
Rtr_22_228 tree_22 tree_228 0.512
Cp_228 tree_228 0 4.32e-15
Rtr_22_229 tree_22 tree_229 0.512
Cp_229 tree_229 0 4.32e-15
Rtr_22_230 tree_22 tree_230 0.512
Cp_230 tree_230 0 4.32e-15
Rtr_23_231 tree_23 tree_231 0.512
Cp_231 tree_231 0 4.32e-15
Rtr_23_232 tree_23 tree_232 0.512
Cp_232 tree_232 0 4.32e-15
Rtr_23_233 tree_23 tree_233 0.512
Cp_233 tree_233 0 4.32e-15
Rtr_23_234 tree_23 tree_234 0.512
Cp_234 tree_234 0 4.32e-15
Rtr_23_235 tree_23 tree_235 0.512
Cp_235 tree_235 0 4.32e-15
Rtr_23_236 tree_23 tree_236 0.512
Cp_236 tree_236 0 4.32e-15
Rtr_23_237 tree_23 tree_237 0.512
Cp_237 tree_237 0 4.32e-15
Rtr_23_238 tree_23 tree_238 0.512
Cp_238 tree_238 0 4.32e-15
Rtr_23_239 tree_23 tree_239 0.512
Cp_239 tree_239 0 4.32e-15
Rtr_23_240 tree_23 tree_240 0.512
Cp_240 tree_240 0 4.32e-15
Rtr_24_241 tree_24 tree_241 0.512
Cp_241 tree_241 0 4.32e-15
Rtr_24_242 tree_24 tree_242 0.512
Cp_242 tree_242 0 4.32e-15
Rtr_24_243 tree_24 tree_243 0.512
Cp_243 tree_243 0 4.32e-15
Rtr_24_244 tree_24 tree_244 0.512
Cp_244 tree_244 0 4.32e-15
Rtr_24_245 tree_24 tree_245 0.512
Cp_245 tree_245 0 4.32e-15
Rtr_24_246 tree_24 tree_246 0.512
Cp_246 tree_246 0 4.32e-15
Rtr_24_247 tree_24 tree_247 0.512
Cp_247 tree_247 0 4.32e-15
Rtr_24_248 tree_24 tree_248 0.512
Cp_248 tree_248 0 4.32e-15
Rtr_24_249 tree_24 tree_249 0.512
Cp_249 tree_249 0 4.32e-15
Rtr_24_250 tree_24 tree_250 0.512
Cp_250 tree_250 0 4.32e-15
Rtr_25_251 tree_25 tree_251 0.512
Cp_251 tree_251 0 4.32e-15
Rtr_25_252 tree_25 tree_252 0.512
Cp_252 tree_252 0 4.32e-15
Rtr_25_253 tree_25 tree_253 0.512
Cp_253 tree_253 0 4.32e-15
Rtr_25_254 tree_25 tree_254 0.512
Cp_254 tree_254 0 4.32e-15
Rtr_25_255 tree_25 tree_255 0.512
Cp_255 tree_255 0 4.32e-15
Rtr_25_256 tree_25 tree_256 0.512
Cp_256 tree_256 0 4.32e-15
Rtr_25_257 tree_25 tree_257 0.512
Cp_257 tree_257 0 4.32e-15
Rtr_25_258 tree_25 tree_258 0.512
Cp_258 tree_258 0 4.32e-15
Rtr_25_259 tree_25 tree_259 0.512
Cp_259 tree_259 0 4.32e-15
Rtr_25_260 tree_25 tree_260 0.512
Cp_260 tree_260 0 4.32e-15
Rtr_26_261 tree_26 tree_261 0.512
Cp_261 tree_261 0 4.32e-15
Rtr_26_262 tree_26 tree_262 0.512
Cp_262 tree_262 0 4.32e-15
Rtr_26_263 tree_26 tree_263 0.512
Cp_263 tree_263 0 4.32e-15
Rtr_26_264 tree_26 tree_264 0.512
Cp_264 tree_264 0 4.32e-15
Rtr_26_265 tree_26 tree_265 0.512
Cp_265 tree_265 0 4.32e-15
Rtr_26_266 tree_26 tree_266 0.512
Cp_266 tree_266 0 4.32e-15
Rtr_26_267 tree_26 tree_267 0.512
Cp_267 tree_267 0 4.32e-15
Rtr_26_268 tree_26 tree_268 0.512
Cp_268 tree_268 0 4.32e-15
Rtr_26_269 tree_26 tree_269 0.512
Cp_269 tree_269 0 4.32e-15
Rtr_26_270 tree_26 tree_270 0.512
Cp_270 tree_270 0 4.32e-15
Rtr_27_271 tree_27 tree_271 0.512
Cp_271 tree_271 0 4.32e-15
Rtr_27_272 tree_27 tree_272 0.512
Cp_272 tree_272 0 4.32e-15
Rtr_27_273 tree_27 tree_273 0.512
Cp_273 tree_273 0 4.32e-15
Rtr_27_274 tree_27 tree_274 0.512
Cp_274 tree_274 0 4.32e-15
Rtr_27_275 tree_27 tree_275 0.512
Cp_275 tree_275 0 4.32e-15
Rtr_27_276 tree_27 tree_276 0.512
Cp_276 tree_276 0 4.32e-15
Rtr_27_277 tree_27 tree_277 0.512
Cp_277 tree_277 0 4.32e-15
Rtr_27_278 tree_27 tree_278 0.512
Cp_278 tree_278 0 4.32e-15
Rtr_27_279 tree_27 tree_279 0.512
Cp_279 tree_279 0 4.32e-15
Rtr_27_280 tree_27 tree_280 0.512
Cp_280 tree_280 0 4.32e-15
Rtr_28_281 tree_28 tree_281 0.512
Cp_281 tree_281 0 4.32e-15
Rtr_28_282 tree_28 tree_282 0.512
Cp_282 tree_282 0 4.32e-15
Rtr_28_283 tree_28 tree_283 0.512
Cp_283 tree_283 0 4.32e-15
Rtr_28_284 tree_28 tree_284 0.512
Cp_284 tree_284 0 4.32e-15
Rtr_28_285 tree_28 tree_285 0.512
Cp_285 tree_285 0 4.32e-15
Rtr_28_286 tree_28 tree_286 0.512
Cp_286 tree_286 0 4.32e-15
Rtr_28_287 tree_28 tree_287 0.512
Cp_287 tree_287 0 4.32e-15
Rtr_28_288 tree_28 tree_288 0.512
Cp_288 tree_288 0 4.32e-15
Rtr_28_289 tree_28 tree_289 0.512
Cp_289 tree_289 0 4.32e-15
Rtr_28_290 tree_28 tree_290 0.512
Cp_290 tree_290 0 4.32e-15
Rtr_29_291 tree_29 tree_291 0.512
Cp_291 tree_291 0 4.32e-15
Rtr_29_292 tree_29 tree_292 0.512
Cp_292 tree_292 0 4.32e-15
Rtr_29_293 tree_29 tree_293 0.512
Cp_293 tree_293 0 4.32e-15
Rtr_29_294 tree_29 tree_294 0.512
Cp_294 tree_294 0 4.32e-15
Rtr_29_295 tree_29 tree_295 0.512
Cp_295 tree_295 0 4.32e-15
Rtr_29_296 tree_29 tree_296 0.512
Cp_296 tree_296 0 4.32e-15
Rtr_29_297 tree_29 tree_297 0.512
Cp_297 tree_297 0 4.32e-15
Rtr_29_298 tree_29 tree_298 0.512
Cp_298 tree_298 0 4.32e-15
Rtr_29_299 tree_29 tree_299 0.512
Cp_299 tree_299 0 4.32e-15
Rtr_29_300 tree_29 tree_300 0.512
Cp_300 tree_300 0 4.32e-15
Rtr_30_301 tree_30 tree_301 0.512
Cp_301 tree_301 0 4.32e-15
Rtr_30_302 tree_30 tree_302 0.512
Cp_302 tree_302 0 4.32e-15
Rtr_30_303 tree_30 tree_303 0.512
Cp_303 tree_303 0 4.32e-15
Rtr_30_304 tree_30 tree_304 0.512
Cp_304 tree_304 0 4.32e-15
Rtr_30_305 tree_30 tree_305 0.512
Cp_305 tree_305 0 4.32e-15
Rtr_30_306 tree_30 tree_306 0.512
Cp_306 tree_306 0 4.32e-15
Rtr_30_307 tree_30 tree_307 0.512
Cp_307 tree_307 0 4.32e-15
Rtr_30_308 tree_30 tree_308 0.512
Cp_308 tree_308 0 4.32e-15
Rtr_30_309 tree_30 tree_309 0.512
Cp_309 tree_309 0 4.32e-15
Rtr_30_310 tree_30 tree_310 0.512
Cp_310 tree_310 0 4.32e-15
Rtr_31_311 tree_31 tree_311 0.512
Cp_311 tree_311 0 4.32e-15
Rtr_31_312 tree_31 tree_312 0.512
Cp_312 tree_312 0 4.32e-15
Rtr_31_313 tree_31 tree_313 0.512
Cp_313 tree_313 0 4.32e-15
Rtr_31_314 tree_31 tree_314 0.512
Cp_314 tree_314 0 4.32e-15
Rtr_31_315 tree_31 tree_315 0.512
Cp_315 tree_315 0 4.32e-15
Rtr_31_316 tree_31 tree_316 0.512
Cp_316 tree_316 0 4.32e-15
Rtr_31_317 tree_31 tree_317 0.512
Cp_317 tree_317 0 4.32e-15
Rtr_31_318 tree_31 tree_318 0.512
Cp_318 tree_318 0 4.32e-15
Rtr_31_319 tree_31 tree_319 0.512
Cp_319 tree_319 0 4.32e-15
Rtr_31_320 tree_31 tree_320 0.512
Cp_320 tree_320 0 4.32e-15
Rtr_32_321 tree_32 tree_321 0.512
Cp_321 tree_321 0 4.32e-15
Rtr_32_322 tree_32 tree_322 0.512
Cp_322 tree_322 0 4.32e-15
Rtr_32_323 tree_32 tree_323 0.512
Cp_323 tree_323 0 4.32e-15
Rtr_32_324 tree_32 tree_324 0.512
Cp_324 tree_324 0 4.32e-15
Rtr_32_325 tree_32 tree_325 0.512
Cp_325 tree_325 0 4.32e-15
Rtr_32_326 tree_32 tree_326 0.512
Cp_326 tree_326 0 4.32e-15
Rtr_32_327 tree_32 tree_327 0.512
Cp_327 tree_327 0 4.32e-15
Rtr_32_328 tree_32 tree_328 0.512
Cp_328 tree_328 0 4.32e-15
Rtr_32_329 tree_32 tree_329 0.512
Cp_329 tree_329 0 4.32e-15
Rtr_32_330 tree_32 tree_330 0.512
Cp_330 tree_330 0 4.32e-15
Rtr_33_331 tree_33 tree_331 0.512
Cp_331 tree_331 0 4.32e-15
Rtr_33_332 tree_33 tree_332 0.512
Cp_332 tree_332 0 4.32e-15
Rtr_33_333 tree_33 tree_333 0.512
Cp_333 tree_333 0 4.32e-15
Rtr_33_334 tree_33 tree_334 0.512
Cp_334 tree_334 0 4.32e-15
Rtr_33_335 tree_33 tree_335 0.512
Cp_335 tree_335 0 4.32e-15
Rtr_33_336 tree_33 tree_336 0.512
Cp_336 tree_336 0 4.32e-15
Rtr_33_337 tree_33 tree_337 0.512
Cp_337 tree_337 0 4.32e-15
Rtr_33_338 tree_33 tree_338 0.512
Cp_338 tree_338 0 4.32e-15
Rtr_33_339 tree_33 tree_339 0.512
Cp_339 tree_339 0 4.32e-15
Rtr_33_340 tree_33 tree_340 0.512
Cp_340 tree_340 0 4.32e-15
Rtr_34_341 tree_34 tree_341 0.512
Cp_341 tree_341 0 4.32e-15
Rtr_34_342 tree_34 tree_342 0.512
Cp_342 tree_342 0 4.32e-15
Rtr_34_343 tree_34 tree_343 0.512
Cp_343 tree_343 0 4.32e-15
Rtr_34_344 tree_34 tree_344 0.512
Cp_344 tree_344 0 4.32e-15
Rtr_34_345 tree_34 tree_345 0.512
Cp_345 tree_345 0 4.32e-15
Rtr_34_346 tree_34 tree_346 0.512
Cp_346 tree_346 0 4.32e-15
Rtr_34_347 tree_34 tree_347 0.512
Cp_347 tree_347 0 4.32e-15
Rtr_34_348 tree_34 tree_348 0.512
Cp_348 tree_348 0 4.32e-15
Rtr_34_349 tree_34 tree_349 0.512
Cp_349 tree_349 0 4.32e-15
Rtr_34_350 tree_34 tree_350 0.512
Cp_350 tree_350 0 4.32e-15
Rtr_35_351 tree_35 tree_351 0.512
Cp_351 tree_351 0 4.32e-15
Rtr_35_352 tree_35 tree_352 0.512
Cp_352 tree_352 0 4.32e-15
Rtr_35_353 tree_35 tree_353 0.512
Cp_353 tree_353 0 4.32e-15
Rtr_35_354 tree_35 tree_354 0.512
Cp_354 tree_354 0 4.32e-15
Rtr_35_355 tree_35 tree_355 0.512
Cp_355 tree_355 0 4.32e-15
Rtr_35_356 tree_35 tree_356 0.512
Cp_356 tree_356 0 4.32e-15
Rtr_35_357 tree_35 tree_357 0.512
Cp_357 tree_357 0 4.32e-15
Rtr_35_358 tree_35 tree_358 0.512
Cp_358 tree_358 0 4.32e-15
Rtr_35_359 tree_35 tree_359 0.512
Cp_359 tree_359 0 4.32e-15
Rtr_35_360 tree_35 tree_360 0.512
Cp_360 tree_360 0 4.32e-15
Rtr_36_361 tree_36 tree_361 0.512
Cp_361 tree_361 0 4.32e-15
Rtr_36_362 tree_36 tree_362 0.512
Cp_362 tree_362 0 4.32e-15
Rtr_36_363 tree_36 tree_363 0.512
Cp_363 tree_363 0 4.32e-15
Rtr_36_364 tree_36 tree_364 0.512
Cp_364 tree_364 0 4.32e-15
Rtr_36_365 tree_36 tree_365 0.512
Cp_365 tree_365 0 4.32e-15
Rtr_36_366 tree_36 tree_366 0.512
Cp_366 tree_366 0 4.32e-15
Rtr_36_367 tree_36 tree_367 0.512
Cp_367 tree_367 0 4.32e-15
Rtr_36_368 tree_36 tree_368 0.512
Cp_368 tree_368 0 4.32e-15
Rtr_36_369 tree_36 tree_369 0.512
Cp_369 tree_369 0 4.32e-15
Rtr_36_370 tree_36 tree_370 0.512
Cp_370 tree_370 0 4.32e-15
Rtr_37_371 tree_37 tree_371 0.512
Cp_371 tree_371 0 4.32e-15
Rtr_37_372 tree_37 tree_372 0.512
Cp_372 tree_372 0 4.32e-15
Rtr_37_373 tree_37 tree_373 0.512
Cp_373 tree_373 0 4.32e-15
Rtr_37_374 tree_37 tree_374 0.512
Cp_374 tree_374 0 4.32e-15
Rtr_37_375 tree_37 tree_375 0.512
Cp_375 tree_375 0 4.32e-15
Rtr_37_376 tree_37 tree_376 0.512
Cp_376 tree_376 0 4.32e-15
Rtr_37_377 tree_37 tree_377 0.512
Cp_377 tree_377 0 4.32e-15
Rtr_37_378 tree_37 tree_378 0.512
Cp_378 tree_378 0 4.32e-15
Rtr_37_379 tree_37 tree_379 0.512
Cp_379 tree_379 0 4.32e-15
Rtr_37_380 tree_37 tree_380 0.512
Cp_380 tree_380 0 4.32e-15
Rtr_38_381 tree_38 tree_381 0.512
Cp_381 tree_381 0 4.32e-15
Rtr_38_382 tree_38 tree_382 0.512
Cp_382 tree_382 0 4.32e-15
Rtr_38_383 tree_38 tree_383 0.512
Cp_383 tree_383 0 4.32e-15
Rtr_38_384 tree_38 tree_384 0.512
Cp_384 tree_384 0 4.32e-15
Rtr_38_385 tree_38 tree_385 0.512
Cp_385 tree_385 0 4.32e-15
Rtr_38_386 tree_38 tree_386 0.512
Cp_386 tree_386 0 4.32e-15
Rtr_38_387 tree_38 tree_387 0.512
Cp_387 tree_387 0 4.32e-15
Rtr_38_388 tree_38 tree_388 0.512
Cp_388 tree_388 0 4.32e-15
Rtr_38_389 tree_38 tree_389 0.512
Cp_389 tree_389 0 4.32e-15
Rtr_38_390 tree_38 tree_390 0.512
Cp_390 tree_390 0 4.32e-15
Rtr_39_391 tree_39 tree_391 0.512
Cp_391 tree_391 0 4.32e-15
Rtr_39_392 tree_39 tree_392 0.512
Cp_392 tree_392 0 4.32e-15
Rtr_39_393 tree_39 tree_393 0.512
Cp_393 tree_393 0 4.32e-15
Rtr_39_394 tree_39 tree_394 0.512
Cp_394 tree_394 0 4.32e-15
Rtr_39_395 tree_39 tree_395 0.512
Cp_395 tree_395 0 4.32e-15
Rtr_39_396 tree_39 tree_396 0.512
Cp_396 tree_396 0 4.32e-15
Rtr_39_397 tree_39 tree_397 0.512
Cp_397 tree_397 0 4.32e-15
Rtr_39_398 tree_39 tree_398 0.512
Cp_398 tree_398 0 4.32e-15
Rtr_39_399 tree_39 tree_399 0.512
Cp_399 tree_399 0 4.32e-15
Rtr_39_400 tree_39 tree_400 0.512
Cp_400 tree_400 0 4.32e-15
Rtr_40_401 tree_40 tree_401 0.512
Cp_401 tree_401 0 4.32e-15
Rtr_40_402 tree_40 tree_402 0.512
Cp_402 tree_402 0 4.32e-15
Rtr_40_403 tree_40 tree_403 0.512
Cp_403 tree_403 0 4.32e-15
Rtr_40_404 tree_40 tree_404 0.512
Cp_404 tree_404 0 4.32e-15
Rtr_40_405 tree_40 tree_405 0.512
Cp_405 tree_405 0 4.32e-15
Rtr_40_406 tree_40 tree_406 0.512
Cp_406 tree_406 0 4.32e-15
Rtr_40_407 tree_40 tree_407 0.512
Cp_407 tree_407 0 4.32e-15
Rtr_40_408 tree_40 tree_408 0.512
Cp_408 tree_408 0 4.32e-15
Rtr_40_409 tree_40 tree_409 0.512
Cp_409 tree_409 0 4.32e-15
Rtr_40_410 tree_40 tree_410 0.512
Cp_410 tree_410 0 4.32e-15
Rtr_41_411 tree_41 tree_411 0.512
Cp_411 tree_411 0 4.32e-15
Rtr_41_412 tree_41 tree_412 0.512
Cp_412 tree_412 0 4.32e-15
Rtr_41_413 tree_41 tree_413 0.512
Cp_413 tree_413 0 4.32e-15
Rtr_41_414 tree_41 tree_414 0.512
Cp_414 tree_414 0 4.32e-15
Rtr_41_415 tree_41 tree_415 0.512
Cp_415 tree_415 0 4.32e-15
Rtr_41_416 tree_41 tree_416 0.512
Cp_416 tree_416 0 4.32e-15
Rtr_41_417 tree_41 tree_417 0.512
Cp_417 tree_417 0 4.32e-15
Rtr_41_418 tree_41 tree_418 0.512
Cp_418 tree_418 0 4.32e-15
Rtr_41_419 tree_41 tree_419 0.512
Cp_419 tree_419 0 4.32e-15
Rtr_41_420 tree_41 tree_420 0.512
Cp_420 tree_420 0 4.32e-15
Rtr_42_421 tree_42 tree_421 0.512
Cp_421 tree_421 0 4.32e-15
Rtr_42_422 tree_42 tree_422 0.512
Cp_422 tree_422 0 4.32e-15
Rtr_42_423 tree_42 tree_423 0.512
Cp_423 tree_423 0 4.32e-15
Rtr_42_424 tree_42 tree_424 0.512
Cp_424 tree_424 0 4.32e-15
Rtr_42_425 tree_42 tree_425 0.512
Cp_425 tree_425 0 4.32e-15
Rtr_42_426 tree_42 tree_426 0.512
Cp_426 tree_426 0 4.32e-15
Rtr_42_427 tree_42 tree_427 0.512
Cp_427 tree_427 0 4.32e-15
Rtr_42_428 tree_42 tree_428 0.512
Cp_428 tree_428 0 4.32e-15
Rtr_42_429 tree_42 tree_429 0.512
Cp_429 tree_429 0 4.32e-15
Rtr_42_430 tree_42 tree_430 0.512
Cp_430 tree_430 0 4.32e-15
Rtr_43_431 tree_43 tree_431 0.512
Cp_431 tree_431 0 4.32e-15
Rtr_43_432 tree_43 tree_432 0.512
Cp_432 tree_432 0 4.32e-15
Rtr_43_433 tree_43 tree_433 0.512
Cp_433 tree_433 0 4.32e-15
Rtr_43_434 tree_43 tree_434 0.512
Cp_434 tree_434 0 4.32e-15
Rtr_43_435 tree_43 tree_435 0.512
Cp_435 tree_435 0 4.32e-15
Rtr_43_436 tree_43 tree_436 0.512
Cp_436 tree_436 0 4.32e-15
Rtr_43_437 tree_43 tree_437 0.512
Cp_437 tree_437 0 4.32e-15
Rtr_43_438 tree_43 tree_438 0.512
Cp_438 tree_438 0 4.32e-15
Rtr_43_439 tree_43 tree_439 0.512
Cp_439 tree_439 0 4.32e-15
Rtr_43_440 tree_43 tree_440 0.512
Cp_440 tree_440 0 4.32e-15
Rtr_44_441 tree_44 tree_441 0.512
Cp_441 tree_441 0 4.32e-15
Rtr_44_442 tree_44 tree_442 0.512
Cp_442 tree_442 0 4.32e-15
Rtr_44_443 tree_44 tree_443 0.512
Cp_443 tree_443 0 4.32e-15
Rtr_44_444 tree_44 tree_444 0.512
Cp_444 tree_444 0 4.32e-15
Rtr_44_445 tree_44 tree_445 0.512
Cp_445 tree_445 0 4.32e-15
Rtr_44_446 tree_44 tree_446 0.512
Cp_446 tree_446 0 4.32e-15
Rtr_44_447 tree_44 tree_447 0.512
Cp_447 tree_447 0 4.32e-15
Rtr_44_448 tree_44 tree_448 0.512
Cp_448 tree_448 0 4.32e-15
Rtr_44_449 tree_44 tree_449 0.512
Cp_449 tree_449 0 4.32e-15
Rtr_44_450 tree_44 tree_450 0.512
Cp_450 tree_450 0 4.32e-15
Rtr_45_451 tree_45 tree_451 0.512
Cp_451 tree_451 0 4.32e-15
Rtr_45_452 tree_45 tree_452 0.512
Cp_452 tree_452 0 4.32e-15
Rtr_45_453 tree_45 tree_453 0.512
Cp_453 tree_453 0 4.32e-15
Rtr_45_454 tree_45 tree_454 0.512
Cp_454 tree_454 0 4.32e-15
Rtr_45_455 tree_45 tree_455 0.512
Cp_455 tree_455 0 4.32e-15
Rtr_45_456 tree_45 tree_456 0.512
Cp_456 tree_456 0 4.32e-15
Rtr_45_457 tree_45 tree_457 0.512
Cp_457 tree_457 0 4.32e-15
Rtr_45_458 tree_45 tree_458 0.512
Cp_458 tree_458 0 4.32e-15
Rtr_45_459 tree_45 tree_459 0.512
Cp_459 tree_459 0 4.32e-15
Rtr_45_460 tree_45 tree_460 0.512
Cp_460 tree_460 0 4.32e-15
Rtr_46_461 tree_46 tree_461 0.512
Cp_461 tree_461 0 4.32e-15
Rtr_46_462 tree_46 tree_462 0.512
Cp_462 tree_462 0 4.32e-15
Rtr_46_463 tree_46 tree_463 0.512
Cp_463 tree_463 0 4.32e-15
Rtr_46_464 tree_46 tree_464 0.512
Cp_464 tree_464 0 4.32e-15
Rtr_46_465 tree_46 tree_465 0.512
Cp_465 tree_465 0 4.32e-15
Rtr_46_466 tree_46 tree_466 0.512
Cp_466 tree_466 0 4.32e-15
Rtr_46_467 tree_46 tree_467 0.512
Cp_467 tree_467 0 4.32e-15
Rtr_46_468 tree_46 tree_468 0.512
Cp_468 tree_468 0 4.32e-15
Rtr_46_469 tree_46 tree_469 0.512
Cp_469 tree_469 0 4.32e-15
Rtr_46_470 tree_46 tree_470 0.512
Cp_470 tree_470 0 4.32e-15
Rtr_47_471 tree_47 tree_471 0.512
Cp_471 tree_471 0 4.32e-15
Rtr_47_472 tree_47 tree_472 0.512
Cp_472 tree_472 0 4.32e-15
Rtr_47_473 tree_47 tree_473 0.512
Cp_473 tree_473 0 4.32e-15
Rtr_47_474 tree_47 tree_474 0.512
Cp_474 tree_474 0 4.32e-15
Rtr_47_475 tree_47 tree_475 0.512
Cp_475 tree_475 0 4.32e-15
Rtr_47_476 tree_47 tree_476 0.512
Cp_476 tree_476 0 4.32e-15
Rtr_47_477 tree_47 tree_477 0.512
Cp_477 tree_477 0 4.32e-15
Rtr_47_478 tree_47 tree_478 0.512
Cp_478 tree_478 0 4.32e-15
Rtr_47_479 tree_47 tree_479 0.512
Cp_479 tree_479 0 4.32e-15
Rtr_47_480 tree_47 tree_480 0.512
Cp_480 tree_480 0 4.32e-15
Rtr_48_481 tree_48 tree_481 0.512
Cp_481 tree_481 0 4.32e-15
Rtr_48_482 tree_48 tree_482 0.512
Cp_482 tree_482 0 4.32e-15
Rtr_48_483 tree_48 tree_483 0.512
Cp_483 tree_483 0 4.32e-15
Rtr_48_484 tree_48 tree_484 0.512
Cp_484 tree_484 0 4.32e-15
Rtr_48_485 tree_48 tree_485 0.512
Cp_485 tree_485 0 4.32e-15
Rtr_48_486 tree_48 tree_486 0.512
Cp_486 tree_486 0 4.32e-15
Rtr_48_487 tree_48 tree_487 0.512
Cp_487 tree_487 0 4.32e-15
Rtr_48_488 tree_48 tree_488 0.512
Cp_488 tree_488 0 4.32e-15
Rtr_48_489 tree_48 tree_489 0.512
Cp_489 tree_489 0 4.32e-15
Rtr_48_490 tree_48 tree_490 0.512
Cp_490 tree_490 0 4.32e-15
Rtr_49_491 tree_49 tree_491 0.512
Cp_491 tree_491 0 4.32e-15
Rtr_49_492 tree_49 tree_492 0.512
Cp_492 tree_492 0 4.32e-15
Rtr_49_493 tree_49 tree_493 0.512
Cp_493 tree_493 0 4.32e-15
Rtr_49_494 tree_49 tree_494 0.512
Cp_494 tree_494 0 4.32e-15
Rtr_49_495 tree_49 tree_495 0.512
Cp_495 tree_495 0 4.32e-15
Rtr_49_496 tree_49 tree_496 0.512
Cp_496 tree_496 0 4.32e-15
Rtr_49_497 tree_49 tree_497 0.512
Cp_497 tree_497 0 4.32e-15
Rtr_49_498 tree_49 tree_498 0.512
Cp_498 tree_498 0 4.32e-15
Rtr_49_499 tree_49 tree_499 0.512
Cp_499 tree_499 0 4.32e-15
Rtr_49_500 tree_49 tree_500 0.512
Cp_500 tree_500 0 4.32e-15
Rtr_50_501 tree_50 tree_501 0.512
Cp_501 tree_501 0 4.32e-15
Rtr_50_502 tree_50 tree_502 0.512
Cp_502 tree_502 0 4.32e-15
Rtr_50_503 tree_50 tree_503 0.512
Cp_503 tree_503 0 4.32e-15
Rtr_50_504 tree_50 tree_504 0.512
Cp_504 tree_504 0 4.32e-15
Rtr_50_505 tree_50 tree_505 0.512
Cp_505 tree_505 0 4.32e-15
Rtr_50_506 tree_50 tree_506 0.512
Cp_506 tree_506 0 4.32e-15
Rtr_50_507 tree_50 tree_507 0.512
Cp_507 tree_507 0 4.32e-15
Rtr_50_508 tree_50 tree_508 0.512
Cp_508 tree_508 0 4.32e-15
Rtr_50_509 tree_50 tree_509 0.512
Cp_509 tree_509 0 4.32e-15
Rtr_50_510 tree_50 tree_510 0.512
Cp_510 tree_510 0 4.32e-15
Rtr_51_511 tree_51 tree_511 0.512
Cp_511 tree_511 0 4.32e-15
Rtr_51_512 tree_51 tree_512 0.512
Cp_512 tree_512 0 4.32e-15
Rtr_51_513 tree_51 tree_513 0.512
Cp_513 tree_513 0 4.32e-15
Rtr_51_514 tree_51 tree_514 0.512
Cp_514 tree_514 0 4.32e-15
Rtr_51_515 tree_51 tree_515 0.512
Cp_515 tree_515 0 4.32e-15
Rtr_51_516 tree_51 tree_516 0.512
Cp_516 tree_516 0 4.32e-15
Rtr_51_517 tree_51 tree_517 0.512
Cp_517 tree_517 0 4.32e-15
Rtr_51_518 tree_51 tree_518 0.512
Cp_518 tree_518 0 4.32e-15
Rtr_51_519 tree_51 tree_519 0.512
Cp_519 tree_519 0 4.32e-15
Rtr_51_520 tree_51 tree_520 0.512
Cp_520 tree_520 0 4.32e-15
Rtr_52_521 tree_52 tree_521 0.512
Cp_521 tree_521 0 4.32e-15
Rtr_52_522 tree_52 tree_522 0.512
Cp_522 tree_522 0 4.32e-15
Rtr_52_523 tree_52 tree_523 0.512
Cp_523 tree_523 0 4.32e-15
Rtr_52_524 tree_52 tree_524 0.512
Cp_524 tree_524 0 4.32e-15
Rtr_52_525 tree_52 tree_525 0.512
Cp_525 tree_525 0 4.32e-15
Rtr_52_526 tree_52 tree_526 0.512
Cp_526 tree_526 0 4.32e-15
Rtr_52_527 tree_52 tree_527 0.512
Cp_527 tree_527 0 4.32e-15
Rtr_52_528 tree_52 tree_528 0.512
Cp_528 tree_528 0 4.32e-15
Rtr_52_529 tree_52 tree_529 0.512
Cp_529 tree_529 0 4.32e-15
Rtr_52_530 tree_52 tree_530 0.512
Cp_530 tree_530 0 4.32e-15
Rtr_53_531 tree_53 tree_531 0.512
Cp_531 tree_531 0 4.32e-15
Rtr_53_532 tree_53 tree_532 0.512
Cp_532 tree_532 0 4.32e-15
Rtr_53_533 tree_53 tree_533 0.512
Cp_533 tree_533 0 4.32e-15
Rtr_53_534 tree_53 tree_534 0.512
Cp_534 tree_534 0 4.32e-15
Rtr_53_535 tree_53 tree_535 0.512
Cp_535 tree_535 0 4.32e-15
Rtr_53_536 tree_53 tree_536 0.512
Cp_536 tree_536 0 4.32e-15
Rtr_53_537 tree_53 tree_537 0.512
Cp_537 tree_537 0 4.32e-15
Rtr_53_538 tree_53 tree_538 0.512
Cp_538 tree_538 0 4.32e-15
Rtr_53_539 tree_53 tree_539 0.512
Cp_539 tree_539 0 4.32e-15
Rtr_53_540 tree_53 tree_540 0.512
Cp_540 tree_540 0 4.32e-15
Rtr_54_541 tree_54 tree_541 0.512
Cp_541 tree_541 0 4.32e-15
Rtr_54_542 tree_54 tree_542 0.512
Cp_542 tree_542 0 4.32e-15
Rtr_54_543 tree_54 tree_543 0.512
Cp_543 tree_543 0 4.32e-15
Rtr_54_544 tree_54 tree_544 0.512
Cp_544 tree_544 0 4.32e-15
Rtr_54_545 tree_54 tree_545 0.512
Cp_545 tree_545 0 4.32e-15
Rtr_54_546 tree_54 tree_546 0.512
Cp_546 tree_546 0 4.32e-15
Rtr_54_547 tree_54 tree_547 0.512
Cp_547 tree_547 0 4.32e-15
Rtr_54_548 tree_54 tree_548 0.512
Cp_548 tree_548 0 4.32e-15
Rtr_54_549 tree_54 tree_549 0.512
Cp_549 tree_549 0 4.32e-15
Rtr_54_550 tree_54 tree_550 0.512
Cp_550 tree_550 0 4.32e-15
Rtr_55_551 tree_55 tree_551 0.512
Cp_551 tree_551 0 4.32e-15
Rtr_55_552 tree_55 tree_552 0.512
Cp_552 tree_552 0 4.32e-15
Rtr_55_553 tree_55 tree_553 0.512
Cp_553 tree_553 0 4.32e-15
Rtr_55_554 tree_55 tree_554 0.512
Cp_554 tree_554 0 4.32e-15
Rtr_55_555 tree_55 tree_555 0.512
Cp_555 tree_555 0 4.32e-15
Rtr_55_556 tree_55 tree_556 0.512
Cp_556 tree_556 0 4.32e-15
Rtr_55_557 tree_55 tree_557 0.512
Cp_557 tree_557 0 4.32e-15
Rtr_55_558 tree_55 tree_558 0.512
Cp_558 tree_558 0 4.32e-15
Rtr_55_559 tree_55 tree_559 0.512
Cp_559 tree_559 0 4.32e-15
Rtr_55_560 tree_55 tree_560 0.512
Cp_560 tree_560 0 4.32e-15
Rtr_56_561 tree_56 tree_561 0.512
Cp_561 tree_561 0 4.32e-15
Rtr_56_562 tree_56 tree_562 0.512
Cp_562 tree_562 0 4.32e-15
Rtr_56_563 tree_56 tree_563 0.512
Cp_563 tree_563 0 4.32e-15
Rtr_56_564 tree_56 tree_564 0.512
Cp_564 tree_564 0 4.32e-15
Rtr_56_565 tree_56 tree_565 0.512
Cp_565 tree_565 0 4.32e-15
Rtr_56_566 tree_56 tree_566 0.512
Cp_566 tree_566 0 4.32e-15
Rtr_56_567 tree_56 tree_567 0.512
Cp_567 tree_567 0 4.32e-15
Rtr_56_568 tree_56 tree_568 0.512
Cp_568 tree_568 0 4.32e-15
Rtr_56_569 tree_56 tree_569 0.512
Cp_569 tree_569 0 4.32e-15
Rtr_56_570 tree_56 tree_570 0.512
Cp_570 tree_570 0 4.32e-15
Rtr_57_571 tree_57 tree_571 0.512
Cp_571 tree_571 0 4.32e-15
Rtr_57_572 tree_57 tree_572 0.512
Cp_572 tree_572 0 4.32e-15
Rtr_57_573 tree_57 tree_573 0.512
Cp_573 tree_573 0 4.32e-15
Rtr_57_574 tree_57 tree_574 0.512
Cp_574 tree_574 0 4.32e-15
Rtr_57_575 tree_57 tree_575 0.512
Cp_575 tree_575 0 4.32e-15
Rtr_57_576 tree_57 tree_576 0.512
Cp_576 tree_576 0 4.32e-15
Rtr_57_577 tree_57 tree_577 0.512
Cp_577 tree_577 0 4.32e-15
Rtr_57_578 tree_57 tree_578 0.512
Cp_578 tree_578 0 4.32e-15
Rtr_57_579 tree_57 tree_579 0.512
Cp_579 tree_579 0 4.32e-15
Rtr_57_580 tree_57 tree_580 0.512
Cp_580 tree_580 0 4.32e-15
Rtr_58_581 tree_58 tree_581 0.512
Cp_581 tree_581 0 4.32e-15
Rtr_58_582 tree_58 tree_582 0.512
Cp_582 tree_582 0 4.32e-15
Rtr_58_583 tree_58 tree_583 0.512
Cp_583 tree_583 0 4.32e-15
Rtr_58_584 tree_58 tree_584 0.512
Cp_584 tree_584 0 4.32e-15
Rtr_58_585 tree_58 tree_585 0.512
Cp_585 tree_585 0 4.32e-15
Rtr_58_586 tree_58 tree_586 0.512
Cp_586 tree_586 0 4.32e-15
Rtr_58_587 tree_58 tree_587 0.512
Cp_587 tree_587 0 4.32e-15
Rtr_58_588 tree_58 tree_588 0.512
Cp_588 tree_588 0 4.32e-15
Rtr_58_589 tree_58 tree_589 0.512
Cp_589 tree_589 0 4.32e-15
Rtr_58_590 tree_58 tree_590 0.512
Cp_590 tree_590 0 4.32e-15
Rtr_59_591 tree_59 tree_591 0.512
Cp_591 tree_591 0 4.32e-15
Rtr_59_592 tree_59 tree_592 0.512
Cp_592 tree_592 0 4.32e-15
Rtr_59_593 tree_59 tree_593 0.512
Cp_593 tree_593 0 4.32e-15
Rtr_59_594 tree_59 tree_594 0.512
Cp_594 tree_594 0 4.32e-15
Rtr_59_595 tree_59 tree_595 0.512
Cp_595 tree_595 0 4.32e-15
Rtr_59_596 tree_59 tree_596 0.512
Cp_596 tree_596 0 4.32e-15
Rtr_59_597 tree_59 tree_597 0.512
Cp_597 tree_597 0 4.32e-15
Rtr_59_598 tree_59 tree_598 0.512
Cp_598 tree_598 0 4.32e-15
Rtr_59_599 tree_59 tree_599 0.512
Cp_599 tree_599 0 4.32e-15
Rtr_59_600 tree_59 tree_600 0.512
Cp_600 tree_600 0 4.32e-15
Rtr_60_601 tree_60 tree_601 0.512
Cp_601 tree_601 0 4.32e-15
Rtr_60_602 tree_60 tree_602 0.512
Cp_602 tree_602 0 4.32e-15
Rtr_60_603 tree_60 tree_603 0.512
Cp_603 tree_603 0 4.32e-15
Rtr_60_604 tree_60 tree_604 0.512
Cp_604 tree_604 0 4.32e-15
Rtr_60_605 tree_60 tree_605 0.512
Cp_605 tree_605 0 4.32e-15
Rtr_60_606 tree_60 tree_606 0.512
Cp_606 tree_606 0 4.32e-15
Rtr_60_607 tree_60 tree_607 0.512
Cp_607 tree_607 0 4.32e-15
Rtr_60_608 tree_60 tree_608 0.512
Cp_608 tree_608 0 4.32e-15
Rtr_60_609 tree_60 tree_609 0.512
Cp_609 tree_609 0 4.32e-15
Rtr_60_610 tree_60 tree_610 0.512
Cp_610 tree_610 0 4.32e-15
Rtr_61_611 tree_61 tree_611 0.512
Cp_611 tree_611 0 4.32e-15
Rtr_61_612 tree_61 tree_612 0.512
Cp_612 tree_612 0 4.32e-15
Rtr_61_613 tree_61 tree_613 0.512
Cp_613 tree_613 0 4.32e-15
Rtr_61_614 tree_61 tree_614 0.512
Cp_614 tree_614 0 4.32e-15
Rtr_61_615 tree_61 tree_615 0.512
Cp_615 tree_615 0 4.32e-15
Rtr_61_616 tree_61 tree_616 0.512
Cp_616 tree_616 0 4.32e-15
Rtr_61_617 tree_61 tree_617 0.512
Cp_617 tree_617 0 4.32e-15
Rtr_61_618 tree_61 tree_618 0.512
Cp_618 tree_618 0 4.32e-15
Rtr_61_619 tree_61 tree_619 0.512
Cp_619 tree_619 0 4.32e-15
Rtr_61_620 tree_61 tree_620 0.512
Cp_620 tree_620 0 4.32e-15
Rtr_62_621 tree_62 tree_621 0.512
Cp_621 tree_621 0 4.32e-15
Rtr_62_622 tree_62 tree_622 0.512
Cp_622 tree_622 0 4.32e-15
Rtr_62_623 tree_62 tree_623 0.512
Cp_623 tree_623 0 4.32e-15
Rtr_62_624 tree_62 tree_624 0.512
Cp_624 tree_624 0 4.32e-15
Rtr_62_625 tree_62 tree_625 0.512
Cp_625 tree_625 0 4.32e-15
Rtr_62_626 tree_62 tree_626 0.512
Cp_626 tree_626 0 4.32e-15
Rtr_62_627 tree_62 tree_627 0.512
Cp_627 tree_627 0 4.32e-15
Rtr_62_628 tree_62 tree_628 0.512
Cp_628 tree_628 0 4.32e-15
Rtr_62_629 tree_62 tree_629 0.512
Cp_629 tree_629 0 4.32e-15
Rtr_62_630 tree_62 tree_630 0.512
Cp_630 tree_630 0 4.32e-15
Rtr_63_631 tree_63 tree_631 0.512
Cp_631 tree_631 0 4.32e-15
Rtr_63_632 tree_63 tree_632 0.512
Cp_632 tree_632 0 4.32e-15
Rtr_63_633 tree_63 tree_633 0.512
Cp_633 tree_633 0 4.32e-15
Rtr_63_634 tree_63 tree_634 0.512
Cp_634 tree_634 0 4.32e-15
Rtr_63_635 tree_63 tree_635 0.512
Cp_635 tree_635 0 4.32e-15
Rtr_63_636 tree_63 tree_636 0.512
Cp_636 tree_636 0 4.32e-15
Rtr_63_637 tree_63 tree_637 0.512
Cp_637 tree_637 0 4.32e-15
Rtr_63_638 tree_63 tree_638 0.512
Cp_638 tree_638 0 4.32e-15
Rtr_63_639 tree_63 tree_639 0.512
Cp_639 tree_639 0 4.32e-15
Rtr_63_640 tree_63 tree_640 0.512
Cp_640 tree_640 0 4.32e-15
Rtr_64_641 tree_64 tree_641 0.512
Cp_641 tree_641 0 4.32e-15
Rtr_64_642 tree_64 tree_642 0.512
Cp_642 tree_642 0 4.32e-15
Rtr_64_643 tree_64 tree_643 0.512
Cp_643 tree_643 0 4.32e-15
Rtr_64_644 tree_64 tree_644 0.512
Cp_644 tree_644 0 4.32e-15
Rtr_64_645 tree_64 tree_645 0.512
Cp_645 tree_645 0 4.32e-15
Rtr_64_646 tree_64 tree_646 0.512
Cp_646 tree_646 0 4.32e-15
Rtr_64_647 tree_64 tree_647 0.512
Cp_647 tree_647 0 4.32e-15
Rtr_64_648 tree_64 tree_648 0.512
Cp_648 tree_648 0 4.32e-15
Rtr_64_649 tree_64 tree_649 0.512
Cp_649 tree_649 0 4.32e-15
Rtr_64_650 tree_64 tree_650 0.512
Cp_650 tree_650 0 4.32e-15
Rtr_65_651 tree_65 tree_651 0.512
Cp_651 tree_651 0 4.32e-15
Rtr_65_652 tree_65 tree_652 0.512
Cp_652 tree_652 0 4.32e-15
Rtr_65_653 tree_65 tree_653 0.512
Cp_653 tree_653 0 4.32e-15
Rtr_65_654 tree_65 tree_654 0.512
Cp_654 tree_654 0 4.32e-15
Rtr_65_655 tree_65 tree_655 0.512
Cp_655 tree_655 0 4.32e-15
Rtr_65_656 tree_65 tree_656 0.512
Cp_656 tree_656 0 4.32e-15
Rtr_65_657 tree_65 tree_657 0.512
Cp_657 tree_657 0 4.32e-15
Rtr_65_658 tree_65 tree_658 0.512
Cp_658 tree_658 0 4.32e-15
Rtr_65_659 tree_65 tree_659 0.512
Cp_659 tree_659 0 4.32e-15
Rtr_65_660 tree_65 tree_660 0.512
Cp_660 tree_660 0 4.32e-15
Rtr_66_661 tree_66 tree_661 0.512
Cp_661 tree_661 0 4.32e-15
Rtr_66_662 tree_66 tree_662 0.512
Cp_662 tree_662 0 4.32e-15
Rtr_66_663 tree_66 tree_663 0.512
Cp_663 tree_663 0 4.32e-15
Rtr_66_664 tree_66 tree_664 0.512
Cp_664 tree_664 0 4.32e-15
Rtr_66_665 tree_66 tree_665 0.512
Cp_665 tree_665 0 4.32e-15
Rtr_66_666 tree_66 tree_666 0.512
Cp_666 tree_666 0 4.32e-15
Rtr_66_667 tree_66 tree_667 0.512
Cp_667 tree_667 0 4.32e-15
Rtr_66_668 tree_66 tree_668 0.512
Cp_668 tree_668 0 4.32e-15
Rtr_66_669 tree_66 tree_669 0.512
Cp_669 tree_669 0 4.32e-15
Rtr_66_670 tree_66 tree_670 0.512
Cp_670 tree_670 0 4.32e-15
Rtr_67_671 tree_67 tree_671 0.512
Cp_671 tree_671 0 4.32e-15
Rtr_67_672 tree_67 tree_672 0.512
Cp_672 tree_672 0 4.32e-15
Rtr_67_673 tree_67 tree_673 0.512
Cp_673 tree_673 0 4.32e-15
Rtr_67_674 tree_67 tree_674 0.512
Cp_674 tree_674 0 4.32e-15
Rtr_67_675 tree_67 tree_675 0.512
Cp_675 tree_675 0 4.32e-15
Rtr_67_676 tree_67 tree_676 0.512
Cp_676 tree_676 0 4.32e-15
Rtr_67_677 tree_67 tree_677 0.512
Cp_677 tree_677 0 4.32e-15
Rtr_67_678 tree_67 tree_678 0.512
Cp_678 tree_678 0 4.32e-15
Rtr_67_679 tree_67 tree_679 0.512
Cp_679 tree_679 0 4.32e-15
Rtr_67_680 tree_67 tree_680 0.512
Cp_680 tree_680 0 4.32e-15
Rtr_68_681 tree_68 tree_681 0.512
Cp_681 tree_681 0 4.32e-15
Rtr_68_682 tree_68 tree_682 0.512
Cp_682 tree_682 0 4.32e-15
Rtr_68_683 tree_68 tree_683 0.512
Cp_683 tree_683 0 4.32e-15
Rtr_68_684 tree_68 tree_684 0.512
Cp_684 tree_684 0 4.32e-15
Rtr_68_685 tree_68 tree_685 0.512
Cp_685 tree_685 0 4.32e-15
Rtr_68_686 tree_68 tree_686 0.512
Cp_686 tree_686 0 4.32e-15
Rtr_68_687 tree_68 tree_687 0.512
Cp_687 tree_687 0 4.32e-15
Rtr_68_688 tree_68 tree_688 0.512
Cp_688 tree_688 0 4.32e-15
Rtr_68_689 tree_68 tree_689 0.512
Cp_689 tree_689 0 4.32e-15
Rtr_68_690 tree_68 tree_690 0.512
Cp_690 tree_690 0 4.32e-15
Rtr_69_691 tree_69 tree_691 0.512
Cp_691 tree_691 0 4.32e-15
Rtr_69_692 tree_69 tree_692 0.512
Cp_692 tree_692 0 4.32e-15
Rtr_69_693 tree_69 tree_693 0.512
Cp_693 tree_693 0 4.32e-15
Rtr_69_694 tree_69 tree_694 0.512
Cp_694 tree_694 0 4.32e-15
Rtr_69_695 tree_69 tree_695 0.512
Cp_695 tree_695 0 4.32e-15
Rtr_69_696 tree_69 tree_696 0.512
Cp_696 tree_696 0 4.32e-15
Rtr_69_697 tree_69 tree_697 0.512
Cp_697 tree_697 0 4.32e-15
Rtr_69_698 tree_69 tree_698 0.512
Cp_698 tree_698 0 4.32e-15
Rtr_69_699 tree_69 tree_699 0.512
Cp_699 tree_699 0 4.32e-15
Rtr_69_700 tree_69 tree_700 0.512
Cp_700 tree_700 0 4.32e-15
Rtr_70_701 tree_70 tree_701 0.512
Cp_701 tree_701 0 4.32e-15
Rtr_70_702 tree_70 tree_702 0.512
Cp_702 tree_702 0 4.32e-15
Rtr_70_703 tree_70 tree_703 0.512
Cp_703 tree_703 0 4.32e-15
Rtr_70_704 tree_70 tree_704 0.512
Cp_704 tree_704 0 4.32e-15
Rtr_70_705 tree_70 tree_705 0.512
Cp_705 tree_705 0 4.32e-15
Rtr_70_706 tree_70 tree_706 0.512
Cp_706 tree_706 0 4.32e-15
Rtr_70_707 tree_70 tree_707 0.512
Cp_707 tree_707 0 4.32e-15
Rtr_70_708 tree_70 tree_708 0.512
Cp_708 tree_708 0 4.32e-15
Rtr_70_709 tree_70 tree_709 0.512
Cp_709 tree_709 0 4.32e-15
Rtr_70_710 tree_70 tree_710 0.512
Cp_710 tree_710 0 4.32e-15
Rtr_71_711 tree_71 tree_711 0.512
Cp_711 tree_711 0 4.32e-15
Rtr_71_712 tree_71 tree_712 0.512
Cp_712 tree_712 0 4.32e-15
Rtr_71_713 tree_71 tree_713 0.512
Cp_713 tree_713 0 4.32e-15
Rtr_71_714 tree_71 tree_714 0.512
Cp_714 tree_714 0 4.32e-15
Rtr_71_715 tree_71 tree_715 0.512
Cp_715 tree_715 0 4.32e-15
Rtr_71_716 tree_71 tree_716 0.512
Cp_716 tree_716 0 4.32e-15
Rtr_71_717 tree_71 tree_717 0.512
Cp_717 tree_717 0 4.32e-15
Rtr_71_718 tree_71 tree_718 0.512
Cp_718 tree_718 0 4.32e-15
Rtr_71_719 tree_71 tree_719 0.512
Cp_719 tree_719 0 4.32e-15
Rtr_71_720 tree_71 tree_720 0.512
Cp_720 tree_720 0 4.32e-15
Rtr_72_721 tree_72 tree_721 0.512
Cp_721 tree_721 0 4.32e-15
Rtr_72_722 tree_72 tree_722 0.512
Cp_722 tree_722 0 4.32e-15
Rtr_72_723 tree_72 tree_723 0.512
Cp_723 tree_723 0 4.32e-15
Rtr_72_724 tree_72 tree_724 0.512
Cp_724 tree_724 0 4.32e-15
Rtr_72_725 tree_72 tree_725 0.512
Cp_725 tree_725 0 4.32e-15
Rtr_72_726 tree_72 tree_726 0.512
Cp_726 tree_726 0 4.32e-15
Rtr_72_727 tree_72 tree_727 0.512
Cp_727 tree_727 0 4.32e-15
Rtr_72_728 tree_72 tree_728 0.512
Cp_728 tree_728 0 4.32e-15
Rtr_72_729 tree_72 tree_729 0.512
Cp_729 tree_729 0 4.32e-15
Rtr_72_730 tree_72 tree_730 0.512
Cp_730 tree_730 0 4.32e-15
Rtr_73_731 tree_73 tree_731 0.512
Cp_731 tree_731 0 4.32e-15
Rtr_73_732 tree_73 tree_732 0.512
Cp_732 tree_732 0 4.32e-15
Rtr_73_733 tree_73 tree_733 0.512
Cp_733 tree_733 0 4.32e-15
Rtr_73_734 tree_73 tree_734 0.512
Cp_734 tree_734 0 4.32e-15
Rtr_73_735 tree_73 tree_735 0.512
Cp_735 tree_735 0 4.32e-15
Rtr_73_736 tree_73 tree_736 0.512
Cp_736 tree_736 0 4.32e-15
Rtr_73_737 tree_73 tree_737 0.512
Cp_737 tree_737 0 4.32e-15
Rtr_73_738 tree_73 tree_738 0.512
Cp_738 tree_738 0 4.32e-15
Rtr_73_739 tree_73 tree_739 0.512
Cp_739 tree_739 0 4.32e-15
Rtr_73_740 tree_73 tree_740 0.512
Cp_740 tree_740 0 4.32e-15
Rtr_74_741 tree_74 tree_741 0.512
Cp_741 tree_741 0 4.32e-15
Rtr_74_742 tree_74 tree_742 0.512
Cp_742 tree_742 0 4.32e-15
Rtr_74_743 tree_74 tree_743 0.512
Cp_743 tree_743 0 4.32e-15
Rtr_74_744 tree_74 tree_744 0.512
Cp_744 tree_744 0 4.32e-15
Rtr_74_745 tree_74 tree_745 0.512
Cp_745 tree_745 0 4.32e-15
Rtr_74_746 tree_74 tree_746 0.512
Cp_746 tree_746 0 4.32e-15
Rtr_74_747 tree_74 tree_747 0.512
Cp_747 tree_747 0 4.32e-15
Rtr_74_748 tree_74 tree_748 0.512
Cp_748 tree_748 0 4.32e-15
Rtr_74_749 tree_74 tree_749 0.512
Cp_749 tree_749 0 4.32e-15
Rtr_74_750 tree_74 tree_750 0.512
Cp_750 tree_750 0 4.32e-15
Rtr_75_751 tree_75 tree_751 0.512
Cp_751 tree_751 0 4.32e-15
Rtr_75_752 tree_75 tree_752 0.512
Cp_752 tree_752 0 4.32e-15
Rtr_75_753 tree_75 tree_753 0.512
Cp_753 tree_753 0 4.32e-15
Rtr_75_754 tree_75 tree_754 0.512
Cp_754 tree_754 0 4.32e-15
Rtr_75_755 tree_75 tree_755 0.512
Cp_755 tree_755 0 4.32e-15
Rtr_75_756 tree_75 tree_756 0.512
Cp_756 tree_756 0 4.32e-15
Rtr_75_757 tree_75 tree_757 0.512
Cp_757 tree_757 0 4.32e-15
Rtr_75_758 tree_75 tree_758 0.512
Cp_758 tree_758 0 4.32e-15
Rtr_75_759 tree_75 tree_759 0.512
Cp_759 tree_759 0 4.32e-15
Rtr_75_760 tree_75 tree_760 0.512
Cp_760 tree_760 0 4.32e-15
Rtr_76_761 tree_76 tree_761 0.512
Cp_761 tree_761 0 4.32e-15
Rtr_76_762 tree_76 tree_762 0.512
Cp_762 tree_762 0 4.32e-15
Rtr_76_763 tree_76 tree_763 0.512
Cp_763 tree_763 0 4.32e-15
Rtr_76_764 tree_76 tree_764 0.512
Cp_764 tree_764 0 4.32e-15
Rtr_76_765 tree_76 tree_765 0.512
Cp_765 tree_765 0 4.32e-15
Rtr_76_766 tree_76 tree_766 0.512
Cp_766 tree_766 0 4.32e-15
Rtr_76_767 tree_76 tree_767 0.512
Cp_767 tree_767 0 4.32e-15
Rtr_76_768 tree_76 tree_768 0.512
Cp_768 tree_768 0 4.32e-15
Rtr_76_769 tree_76 tree_769 0.512
Cp_769 tree_769 0 4.32e-15
Rtr_76_770 tree_76 tree_770 0.512
Cp_770 tree_770 0 4.32e-15
Rtr_77_771 tree_77 tree_771 0.512
Cp_771 tree_771 0 4.32e-15
Rtr_77_772 tree_77 tree_772 0.512
Cp_772 tree_772 0 4.32e-15
Rtr_77_773 tree_77 tree_773 0.512
Cp_773 tree_773 0 4.32e-15
Rtr_77_774 tree_77 tree_774 0.512
Cp_774 tree_774 0 4.32e-15
Rtr_77_775 tree_77 tree_775 0.512
Cp_775 tree_775 0 4.32e-15
Rtr_77_776 tree_77 tree_776 0.512
Cp_776 tree_776 0 4.32e-15
Rtr_77_777 tree_77 tree_777 0.512
Cp_777 tree_777 0 4.32e-15
Rtr_77_778 tree_77 tree_778 0.512
Cp_778 tree_778 0 4.32e-15
Rtr_77_779 tree_77 tree_779 0.512
Cp_779 tree_779 0 4.32e-15
Rtr_77_780 tree_77 tree_780 0.512
Cp_780 tree_780 0 4.32e-15
Rtr_78_781 tree_78 tree_781 0.512
Cp_781 tree_781 0 4.32e-15
Rtr_78_782 tree_78 tree_782 0.512
Cp_782 tree_782 0 4.32e-15
Rtr_78_783 tree_78 tree_783 0.512
Cp_783 tree_783 0 4.32e-15
Rtr_78_784 tree_78 tree_784 0.512
Cp_784 tree_784 0 4.32e-15
Rtr_78_785 tree_78 tree_785 0.512
Cp_785 tree_785 0 4.32e-15
Rtr_78_786 tree_78 tree_786 0.512
Cp_786 tree_786 0 4.32e-15
Rtr_78_787 tree_78 tree_787 0.512
Cp_787 tree_787 0 4.32e-15
Rtr_78_788 tree_78 tree_788 0.512
Cp_788 tree_788 0 4.32e-15
Rtr_78_789 tree_78 tree_789 0.512
Cp_789 tree_789 0 4.32e-15
Rtr_78_790 tree_78 tree_790 0.512
Cp_790 tree_790 0 4.32e-15
Rtr_79_791 tree_79 tree_791 0.512
Cp_791 tree_791 0 4.32e-15
Rtr_79_792 tree_79 tree_792 0.512
Cp_792 tree_792 0 4.32e-15
Rtr_79_793 tree_79 tree_793 0.512
Cp_793 tree_793 0 4.32e-15
Rtr_79_794 tree_79 tree_794 0.512
Cp_794 tree_794 0 4.32e-15
Rtr_79_795 tree_79 tree_795 0.512
Cp_795 tree_795 0 4.32e-15
Rtr_79_796 tree_79 tree_796 0.512
Cp_796 tree_796 0 4.32e-15
Rtr_79_797 tree_79 tree_797 0.512
Cp_797 tree_797 0 4.32e-15
Rtr_79_798 tree_79 tree_798 0.512
Cp_798 tree_798 0 4.32e-15
Rtr_79_799 tree_79 tree_799 0.512
Cp_799 tree_799 0 4.32e-15
Rtr_79_800 tree_79 tree_800 0.512
Cp_800 tree_800 0 4.32e-15
Rtr_80_801 tree_80 tree_801 0.512
Cp_801 tree_801 0 4.32e-15
Rtr_80_802 tree_80 tree_802 0.512
Cp_802 tree_802 0 4.32e-15
Rtr_80_803 tree_80 tree_803 0.512
Cp_803 tree_803 0 4.32e-15
Rtr_80_804 tree_80 tree_804 0.512
Cp_804 tree_804 0 4.32e-15
Rtr_80_805 tree_80 tree_805 0.512
Cp_805 tree_805 0 4.32e-15
Rtr_80_806 tree_80 tree_806 0.512
Cp_806 tree_806 0 4.32e-15
Rtr_80_807 tree_80 tree_807 0.512
Cp_807 tree_807 0 4.32e-15
Rtr_80_808 tree_80 tree_808 0.512
Cp_808 tree_808 0 4.32e-15
Rtr_80_809 tree_80 tree_809 0.512
Cp_809 tree_809 0 4.32e-15
Rtr_80_810 tree_80 tree_810 0.512
Cp_810 tree_810 0 4.32e-15
Rtr_81_811 tree_81 tree_811 0.512
Cp_811 tree_811 0 4.32e-15
Rtr_81_812 tree_81 tree_812 0.512
Cp_812 tree_812 0 4.32e-15
Rtr_81_813 tree_81 tree_813 0.512
Cp_813 tree_813 0 4.32e-15
Rtr_81_814 tree_81 tree_814 0.512
Cp_814 tree_814 0 4.32e-15
Rtr_81_815 tree_81 tree_815 0.512
Cp_815 tree_815 0 4.32e-15
Rtr_81_816 tree_81 tree_816 0.512
Cp_816 tree_816 0 4.32e-15
Rtr_81_817 tree_81 tree_817 0.512
Cp_817 tree_817 0 4.32e-15
Rtr_81_818 tree_81 tree_818 0.512
Cp_818 tree_818 0 4.32e-15
Rtr_81_819 tree_81 tree_819 0.512
Cp_819 tree_819 0 4.32e-15
Rtr_81_820 tree_81 tree_820 0.512
Cp_820 tree_820 0 4.32e-15
Rtr_82_821 tree_82 tree_821 0.512
Cp_821 tree_821 0 4.32e-15
Rtr_82_822 tree_82 tree_822 0.512
Cp_822 tree_822 0 4.32e-15
Rtr_82_823 tree_82 tree_823 0.512
Cp_823 tree_823 0 4.32e-15
Rtr_82_824 tree_82 tree_824 0.512
Cp_824 tree_824 0 4.32e-15
Rtr_82_825 tree_82 tree_825 0.512
Cp_825 tree_825 0 4.32e-15
Rtr_82_826 tree_82 tree_826 0.512
Cp_826 tree_826 0 4.32e-15
Rtr_82_827 tree_82 tree_827 0.512
Cp_827 tree_827 0 4.32e-15
Rtr_82_828 tree_82 tree_828 0.512
Cp_828 tree_828 0 4.32e-15
Rtr_82_829 tree_82 tree_829 0.512
Cp_829 tree_829 0 4.32e-15
Rtr_82_830 tree_82 tree_830 0.512
Cp_830 tree_830 0 4.32e-15
Rtr_83_831 tree_83 tree_831 0.512
Cp_831 tree_831 0 4.32e-15
Rtr_83_832 tree_83 tree_832 0.512
Cp_832 tree_832 0 4.32e-15
Rtr_83_833 tree_83 tree_833 0.512
Cp_833 tree_833 0 4.32e-15
Rtr_83_834 tree_83 tree_834 0.512
Cp_834 tree_834 0 4.32e-15
Rtr_83_835 tree_83 tree_835 0.512
Cp_835 tree_835 0 4.32e-15
Rtr_83_836 tree_83 tree_836 0.512
Cp_836 tree_836 0 4.32e-15
Rtr_83_837 tree_83 tree_837 0.512
Cp_837 tree_837 0 4.32e-15
Rtr_83_838 tree_83 tree_838 0.512
Cp_838 tree_838 0 4.32e-15
Rtr_83_839 tree_83 tree_839 0.512
Cp_839 tree_839 0 4.32e-15
Rtr_83_840 tree_83 tree_840 0.512
Cp_840 tree_840 0 4.32e-15
Rtr_84_841 tree_84 tree_841 0.512
Cp_841 tree_841 0 4.32e-15
Rtr_84_842 tree_84 tree_842 0.512
Cp_842 tree_842 0 4.32e-15
Rtr_84_843 tree_84 tree_843 0.512
Cp_843 tree_843 0 4.32e-15
Rtr_84_844 tree_84 tree_844 0.512
Cp_844 tree_844 0 4.32e-15
Rtr_84_845 tree_84 tree_845 0.512
Cp_845 tree_845 0 4.32e-15
Rtr_84_846 tree_84 tree_846 0.512
Cp_846 tree_846 0 4.32e-15
Rtr_84_847 tree_84 tree_847 0.512
Cp_847 tree_847 0 4.32e-15
Rtr_84_848 tree_84 tree_848 0.512
Cp_848 tree_848 0 4.32e-15
Rtr_84_849 tree_84 tree_849 0.512
Cp_849 tree_849 0 4.32e-15
Rtr_84_850 tree_84 tree_850 0.512
Cp_850 tree_850 0 4.32e-15
Rtr_85_851 tree_85 tree_851 0.512
Cp_851 tree_851 0 4.32e-15
Rtr_85_852 tree_85 tree_852 0.512
Cp_852 tree_852 0 4.32e-15
Rtr_85_853 tree_85 tree_853 0.512
Cp_853 tree_853 0 4.32e-15
Rtr_85_854 tree_85 tree_854 0.512
Cp_854 tree_854 0 4.32e-15
Rtr_85_855 tree_85 tree_855 0.512
Cp_855 tree_855 0 4.32e-15
Rtr_85_856 tree_85 tree_856 0.512
Cp_856 tree_856 0 4.32e-15
Rtr_85_857 tree_85 tree_857 0.512
Cp_857 tree_857 0 4.32e-15
Rtr_85_858 tree_85 tree_858 0.512
Cp_858 tree_858 0 4.32e-15
Rtr_85_859 tree_85 tree_859 0.512
Cp_859 tree_859 0 4.32e-15
Rtr_85_860 tree_85 tree_860 0.512
Cp_860 tree_860 0 4.32e-15
Rtr_86_861 tree_86 tree_861 0.512
Cp_861 tree_861 0 4.32e-15
Rtr_86_862 tree_86 tree_862 0.512
Cp_862 tree_862 0 4.32e-15
Rtr_86_863 tree_86 tree_863 0.512
Cp_863 tree_863 0 4.32e-15
Rtr_86_864 tree_86 tree_864 0.512
Cp_864 tree_864 0 4.32e-15
Rtr_86_865 tree_86 tree_865 0.512
Cp_865 tree_865 0 4.32e-15
Rtr_86_866 tree_86 tree_866 0.512
Cp_866 tree_866 0 4.32e-15
Rtr_86_867 tree_86 tree_867 0.512
Cp_867 tree_867 0 4.32e-15
Rtr_86_868 tree_86 tree_868 0.512
Cp_868 tree_868 0 4.32e-15
Rtr_86_869 tree_86 tree_869 0.512
Cp_869 tree_869 0 4.32e-15
Rtr_86_870 tree_86 tree_870 0.512
Cp_870 tree_870 0 4.32e-15
Rtr_87_871 tree_87 tree_871 0.512
Cp_871 tree_871 0 4.32e-15
Rtr_87_872 tree_87 tree_872 0.512
Cp_872 tree_872 0 4.32e-15
Rtr_87_873 tree_87 tree_873 0.512
Cp_873 tree_873 0 4.32e-15
Rtr_87_874 tree_87 tree_874 0.512
Cp_874 tree_874 0 4.32e-15
Rtr_87_875 tree_87 tree_875 0.512
Cp_875 tree_875 0 4.32e-15
Rtr_87_876 tree_87 tree_876 0.512
Cp_876 tree_876 0 4.32e-15
Rtr_87_877 tree_87 tree_877 0.512
Cp_877 tree_877 0 4.32e-15
Rtr_87_878 tree_87 tree_878 0.512
Cp_878 tree_878 0 4.32e-15
Rtr_87_879 tree_87 tree_879 0.512
Cp_879 tree_879 0 4.32e-15
Rtr_87_880 tree_87 tree_880 0.512
Cp_880 tree_880 0 4.32e-15
Rtr_88_881 tree_88 tree_881 0.512
Cp_881 tree_881 0 4.32e-15
Rtr_88_882 tree_88 tree_882 0.512
Cp_882 tree_882 0 4.32e-15
Rtr_88_883 tree_88 tree_883 0.512
Cp_883 tree_883 0 4.32e-15
Rtr_88_884 tree_88 tree_884 0.512
Cp_884 tree_884 0 4.32e-15
Rtr_88_885 tree_88 tree_885 0.512
Cp_885 tree_885 0 4.32e-15
Rtr_88_886 tree_88 tree_886 0.512
Cp_886 tree_886 0 4.32e-15
Rtr_88_887 tree_88 tree_887 0.512
Cp_887 tree_887 0 4.32e-15
Rtr_88_888 tree_88 tree_888 0.512
Cp_888 tree_888 0 4.32e-15
Rtr_88_889 tree_88 tree_889 0.512
Cp_889 tree_889 0 4.32e-15
Rtr_88_890 tree_88 tree_890 0.512
Cp_890 tree_890 0 4.32e-15
Rtr_89_891 tree_89 tree_891 0.512
Cp_891 tree_891 0 4.32e-15
Rtr_89_892 tree_89 tree_892 0.512
Cp_892 tree_892 0 4.32e-15
Rtr_89_893 tree_89 tree_893 0.512
Cp_893 tree_893 0 4.32e-15
Rtr_89_894 tree_89 tree_894 0.512
Cp_894 tree_894 0 4.32e-15
Rtr_89_895 tree_89 tree_895 0.512
Cp_895 tree_895 0 4.32e-15
Rtr_89_896 tree_89 tree_896 0.512
Cp_896 tree_896 0 4.32e-15
Rtr_89_897 tree_89 tree_897 0.512
Cp_897 tree_897 0 4.32e-15
Rtr_89_898 tree_89 tree_898 0.512
Cp_898 tree_898 0 4.32e-15
Rtr_89_899 tree_89 tree_899 0.512
Cp_899 tree_899 0 4.32e-15
Rtr_89_900 tree_89 tree_900 0.512
Cp_900 tree_900 0 4.32e-15
Rtr_90_901 tree_90 tree_901 0.512
Cp_901 tree_901 0 4.32e-15
Rtr_90_902 tree_90 tree_902 0.512
Cp_902 tree_902 0 4.32e-15
Rtr_90_903 tree_90 tree_903 0.512
Cp_903 tree_903 0 4.32e-15
Rtr_90_904 tree_90 tree_904 0.512
Cp_904 tree_904 0 4.32e-15
Rtr_90_905 tree_90 tree_905 0.512
Cp_905 tree_905 0 4.32e-15
Rtr_90_906 tree_90 tree_906 0.512
Cp_906 tree_906 0 4.32e-15
Rtr_90_907 tree_90 tree_907 0.512
Cp_907 tree_907 0 4.32e-15
Rtr_90_908 tree_90 tree_908 0.512
Cp_908 tree_908 0 4.32e-15
Rtr_90_909 tree_90 tree_909 0.512
Cp_909 tree_909 0 4.32e-15
Rtr_90_910 tree_90 tree_910 0.512
Cp_910 tree_910 0 4.32e-15
Rtr_91_911 tree_91 tree_911 0.512
Cp_911 tree_911 0 4.32e-15
Rtr_91_912 tree_91 tree_912 0.512
Cp_912 tree_912 0 4.32e-15
Rtr_91_913 tree_91 tree_913 0.512
Cp_913 tree_913 0 4.32e-15
Rtr_91_914 tree_91 tree_914 0.512
Cp_914 tree_914 0 4.32e-15
Rtr_91_915 tree_91 tree_915 0.512
Cp_915 tree_915 0 4.32e-15
Rtr_91_916 tree_91 tree_916 0.512
Cp_916 tree_916 0 4.32e-15
Rtr_91_917 tree_91 tree_917 0.512
Cp_917 tree_917 0 4.32e-15
Rtr_91_918 tree_91 tree_918 0.512
Cp_918 tree_918 0 4.32e-15
Rtr_91_919 tree_91 tree_919 0.512
Cp_919 tree_919 0 4.32e-15
Rtr_91_920 tree_91 tree_920 0.512
Cp_920 tree_920 0 4.32e-15
Rtr_92_921 tree_92 tree_921 0.512
Cp_921 tree_921 0 4.32e-15
Rtr_92_922 tree_92 tree_922 0.512
Cp_922 tree_922 0 4.32e-15
Rtr_92_923 tree_92 tree_923 0.512
Cp_923 tree_923 0 4.32e-15
Rtr_92_924 tree_92 tree_924 0.512
Cp_924 tree_924 0 4.32e-15
Rtr_92_925 tree_92 tree_925 0.512
Cp_925 tree_925 0 4.32e-15
Rtr_92_926 tree_92 tree_926 0.512
Cp_926 tree_926 0 4.32e-15
Rtr_92_927 tree_92 tree_927 0.512
Cp_927 tree_927 0 4.32e-15
Rtr_92_928 tree_92 tree_928 0.512
Cp_928 tree_928 0 4.32e-15
Rtr_92_929 tree_92 tree_929 0.512
Cp_929 tree_929 0 4.32e-15
Rtr_92_930 tree_92 tree_930 0.512
Cp_930 tree_930 0 4.32e-15
Rtr_93_931 tree_93 tree_931 0.512
Cp_931 tree_931 0 4.32e-15
Rtr_93_932 tree_93 tree_932 0.512
Cp_932 tree_932 0 4.32e-15
Rtr_93_933 tree_93 tree_933 0.512
Cp_933 tree_933 0 4.32e-15
Rtr_93_934 tree_93 tree_934 0.512
Cp_934 tree_934 0 4.32e-15
Rtr_93_935 tree_93 tree_935 0.512
Cp_935 tree_935 0 4.32e-15
Rtr_93_936 tree_93 tree_936 0.512
Cp_936 tree_936 0 4.32e-15
Rtr_93_937 tree_93 tree_937 0.512
Cp_937 tree_937 0 4.32e-15
Rtr_93_938 tree_93 tree_938 0.512
Cp_938 tree_938 0 4.32e-15
Rtr_93_939 tree_93 tree_939 0.512
Cp_939 tree_939 0 4.32e-15
Rtr_93_940 tree_93 tree_940 0.512
Cp_940 tree_940 0 4.32e-15
Rtr_94_941 tree_94 tree_941 0.512
Cp_941 tree_941 0 4.32e-15
Rtr_94_942 tree_94 tree_942 0.512
Cp_942 tree_942 0 4.32e-15
Rtr_94_943 tree_94 tree_943 0.512
Cp_943 tree_943 0 4.32e-15
Rtr_94_944 tree_94 tree_944 0.512
Cp_944 tree_944 0 4.32e-15
Rtr_94_945 tree_94 tree_945 0.512
Cp_945 tree_945 0 4.32e-15
Rtr_94_946 tree_94 tree_946 0.512
Cp_946 tree_946 0 4.32e-15
Rtr_94_947 tree_94 tree_947 0.512
Cp_947 tree_947 0 4.32e-15
Rtr_94_948 tree_94 tree_948 0.512
Cp_948 tree_948 0 4.32e-15
Rtr_94_949 tree_94 tree_949 0.512
Cp_949 tree_949 0 4.32e-15
Rtr_94_950 tree_94 tree_950 0.512
Cp_950 tree_950 0 4.32e-15
Rtr_95_951 tree_95 tree_951 0.512
Cp_951 tree_951 0 4.32e-15
Rtr_95_952 tree_95 tree_952 0.512
Cp_952 tree_952 0 4.32e-15
Rtr_95_953 tree_95 tree_953 0.512
Cp_953 tree_953 0 4.32e-15
Rtr_95_954 tree_95 tree_954 0.512
Cp_954 tree_954 0 4.32e-15
Rtr_95_955 tree_95 tree_955 0.512
Cp_955 tree_955 0 4.32e-15
Rtr_95_956 tree_95 tree_956 0.512
Cp_956 tree_956 0 4.32e-15
Rtr_95_957 tree_95 tree_957 0.512
Cp_957 tree_957 0 4.32e-15
Rtr_95_958 tree_95 tree_958 0.512
Cp_958 tree_958 0 4.32e-15
Rtr_95_959 tree_95 tree_959 0.512
Cp_959 tree_959 0 4.32e-15
Rtr_95_960 tree_95 tree_960 0.512
Cp_960 tree_960 0 4.32e-15
Rtr_96_961 tree_96 tree_961 0.512
Cp_961 tree_961 0 4.32e-15
Rtr_96_962 tree_96 tree_962 0.512
Cp_962 tree_962 0 4.32e-15
Rtr_96_963 tree_96 tree_963 0.512
Cp_963 tree_963 0 4.32e-15
Rtr_96_964 tree_96 tree_964 0.512
Cp_964 tree_964 0 4.32e-15
Rtr_96_965 tree_96 tree_965 0.512
Cp_965 tree_965 0 4.32e-15
Rtr_96_966 tree_96 tree_966 0.512
Cp_966 tree_966 0 4.32e-15
Rtr_96_967 tree_96 tree_967 0.512
Cp_967 tree_967 0 4.32e-15
Rtr_96_968 tree_96 tree_968 0.512
Cp_968 tree_968 0 4.32e-15
Rtr_96_969 tree_96 tree_969 0.512
Cp_969 tree_969 0 4.32e-15
Rtr_96_970 tree_96 tree_970 0.512
Cp_970 tree_970 0 4.32e-15
Rtr_97_971 tree_97 tree_971 0.512
Cp_971 tree_971 0 4.32e-15
Rtr_97_972 tree_97 tree_972 0.512
Cp_972 tree_972 0 4.32e-15
Rtr_97_973 tree_97 tree_973 0.512
Cp_973 tree_973 0 4.32e-15
Rtr_97_974 tree_97 tree_974 0.512
Cp_974 tree_974 0 4.32e-15
Rtr_97_975 tree_97 tree_975 0.512
Cp_975 tree_975 0 4.32e-15
Rtr_97_976 tree_97 tree_976 0.512
Cp_976 tree_976 0 4.32e-15
Rtr_97_977 tree_97 tree_977 0.512
Cp_977 tree_977 0 4.32e-15
Rtr_97_978 tree_97 tree_978 0.512
Cp_978 tree_978 0 4.32e-15
Rtr_97_979 tree_97 tree_979 0.512
Cp_979 tree_979 0 4.32e-15
Rtr_97_980 tree_97 tree_980 0.512
Cp_980 tree_980 0 4.32e-15
Rtr_98_981 tree_98 tree_981 0.512
Cp_981 tree_981 0 4.32e-15
Rtr_98_982 tree_98 tree_982 0.512
Cp_982 tree_982 0 4.32e-15
Rtr_98_983 tree_98 tree_983 0.512
Cp_983 tree_983 0 4.32e-15
Rtr_98_984 tree_98 tree_984 0.512
Cp_984 tree_984 0 4.32e-15
Rtr_98_985 tree_98 tree_985 0.512
Cp_985 tree_985 0 4.32e-15
Rtr_98_986 tree_98 tree_986 0.512
Cp_986 tree_986 0 4.32e-15
Rtr_98_987 tree_98 tree_987 0.512
Cp_987 tree_987 0 4.32e-15
Rtr_98_988 tree_98 tree_988 0.512
Cp_988 tree_988 0 4.32e-15
Rtr_98_989 tree_98 tree_989 0.512
Cp_989 tree_989 0 4.32e-15
Rtr_98_990 tree_98 tree_990 0.512
Cp_990 tree_990 0 4.32e-15
Rtr_99_991 tree_99 tree_991 0.512
Cp_991 tree_991 0 4.32e-15
Rtr_99_992 tree_99 tree_992 0.512
Cp_992 tree_992 0 4.32e-15
Rtr_99_993 tree_99 tree_993 0.512
Cp_993 tree_993 0 4.32e-15
Rtr_99_994 tree_99 tree_994 0.512
Cp_994 tree_994 0 4.32e-15
Rtr_99_995 tree_99 tree_995 0.512
Cp_995 tree_995 0 4.32e-15
Rtr_99_996 tree_99 tree_996 0.512
Cp_996 tree_996 0 4.32e-15
Rtr_99_997 tree_99 tree_997 0.512
Cp_997 tree_997 0 4.32e-15
Rtr_99_998 tree_99 tree_998 0.512
Cp_998 tree_998 0 4.32e-15
Rtr_99_999 tree_99 tree_999 0.512
Cp_999 tree_999 0 4.32e-15
Rtr_99_1000 tree_99 tree_1000 0.512
Cp_1000 tree_1000 0 4.32e-15
Rtr_100_1001 tree_100 tree_1001 0.512
Cp_1001 tree_1001 0 4.32e-15
Rtr_100_1002 tree_100 tree_1002 0.512
Cp_1002 tree_1002 0 4.32e-15
Rtr_100_1003 tree_100 tree_1003 0.512
Cp_1003 tree_1003 0 4.32e-15
Rtr_100_1004 tree_100 tree_1004 0.512
Cp_1004 tree_1004 0 4.32e-15
Rtr_100_1005 tree_100 tree_1005 0.512
Cp_1005 tree_1005 0 4.32e-15
Rtr_100_1006 tree_100 tree_1006 0.512
Cp_1006 tree_1006 0 4.32e-15
Rtr_100_1007 tree_100 tree_1007 0.512
Cp_1007 tree_1007 0 4.32e-15
Rtr_100_1008 tree_100 tree_1008 0.512
Cp_1008 tree_1008 0 4.32e-15
Rtr_100_1009 tree_100 tree_1009 0.512
Cp_1009 tree_1009 0 4.32e-15
Rtr_100_1010 tree_100 tree_1010 0.512
Cp_1010 tree_1010 0 4.32e-15
Rtr_101_1011 tree_101 tree_1011 0.512
Cp_1011 tree_1011 0 4.32e-15
Rtr_101_1012 tree_101 tree_1012 0.512
Cp_1012 tree_1012 0 4.32e-15
Rtr_101_1013 tree_101 tree_1013 0.512
Cp_1013 tree_1013 0 4.32e-15
Rtr_101_1014 tree_101 tree_1014 0.512
Cp_1014 tree_1014 0 4.32e-15
Rtr_101_1015 tree_101 tree_1015 0.512
Cp_1015 tree_1015 0 4.32e-15
Rtr_101_1016 tree_101 tree_1016 0.512
Cp_1016 tree_1016 0 4.32e-15
Rtr_101_1017 tree_101 tree_1017 0.512
Cp_1017 tree_1017 0 4.32e-15
Rtr_101_1018 tree_101 tree_1018 0.512
Cp_1018 tree_1018 0 4.32e-15
Rtr_101_1019 tree_101 tree_1019 0.512
Cp_1019 tree_1019 0 4.32e-15
Rtr_101_1020 tree_101 tree_1020 0.512
Cp_1020 tree_1020 0 4.32e-15
Rtr_102_1021 tree_102 tree_1021 0.512
Cp_1021 tree_1021 0 4.32e-15
Rtr_102_1022 tree_102 tree_1022 0.512
Cp_1022 tree_1022 0 4.32e-15
Rtr_102_1023 tree_102 tree_1023 0.512
Cp_1023 tree_1023 0 4.32e-15
Rtr_102_1024 tree_102 tree_1024 0.512
Cp_1024 tree_1024 0 4.32e-15
Rtr_102_1025 tree_102 tree_1025 0.512
Cp_1025 tree_1025 0 4.32e-15
Rtr_102_1026 tree_102 tree_1026 0.512
Cp_1026 tree_1026 0 4.32e-15
Rtr_102_1027 tree_102 tree_1027 0.512
Cp_1027 tree_1027 0 4.32e-15
Rtr_102_1028 tree_102 tree_1028 0.512
Cp_1028 tree_1028 0 4.32e-15
Rtr_102_1029 tree_102 tree_1029 0.512
Cp_1029 tree_1029 0 4.32e-15
Rtr_102_1030 tree_102 tree_1030 0.512
Cp_1030 tree_1030 0 4.32e-15
Rtr_103_1031 tree_103 tree_1031 0.512
Cp_1031 tree_1031 0 4.32e-15
Rtr_103_1032 tree_103 tree_1032 0.512
Cp_1032 tree_1032 0 4.32e-15
Rtr_103_1033 tree_103 tree_1033 0.512
Cp_1033 tree_1033 0 4.32e-15
Rtr_103_1034 tree_103 tree_1034 0.512
Cp_1034 tree_1034 0 4.32e-15
Rtr_103_1035 tree_103 tree_1035 0.512
Cp_1035 tree_1035 0 4.32e-15
Rtr_103_1036 tree_103 tree_1036 0.512
Cp_1036 tree_1036 0 4.32e-15
Rtr_103_1037 tree_103 tree_1037 0.512
Cp_1037 tree_1037 0 4.32e-15
Rtr_103_1038 tree_103 tree_1038 0.512
Cp_1038 tree_1038 0 4.32e-15
Rtr_103_1039 tree_103 tree_1039 0.512
Cp_1039 tree_1039 0 4.32e-15
Rtr_103_1040 tree_103 tree_1040 0.512
Cp_1040 tree_1040 0 4.32e-15
Rtr_104_1041 tree_104 tree_1041 0.512
Cp_1041 tree_1041 0 4.32e-15
Rtr_104_1042 tree_104 tree_1042 0.512
Cp_1042 tree_1042 0 4.32e-15
Rtr_104_1043 tree_104 tree_1043 0.512
Cp_1043 tree_1043 0 4.32e-15
Rtr_104_1044 tree_104 tree_1044 0.512
Cp_1044 tree_1044 0 4.32e-15
Rtr_104_1045 tree_104 tree_1045 0.512
Cp_1045 tree_1045 0 4.32e-15
Rtr_104_1046 tree_104 tree_1046 0.512
Cp_1046 tree_1046 0 4.32e-15
Rtr_104_1047 tree_104 tree_1047 0.512
Cp_1047 tree_1047 0 4.32e-15
Rtr_104_1048 tree_104 tree_1048 0.512
Cp_1048 tree_1048 0 4.32e-15
Rtr_104_1049 tree_104 tree_1049 0.512
Cp_1049 tree_1049 0 4.32e-15
Rtr_104_1050 tree_104 tree_1050 0.512
Cp_1050 tree_1050 0 4.32e-15
Rtr_105_1051 tree_105 tree_1051 0.512
Cp_1051 tree_1051 0 4.32e-15
Rtr_105_1052 tree_105 tree_1052 0.512
Cp_1052 tree_1052 0 4.32e-15
Rtr_105_1053 tree_105 tree_1053 0.512
Cp_1053 tree_1053 0 4.32e-15
Rtr_105_1054 tree_105 tree_1054 0.512
Cp_1054 tree_1054 0 4.32e-15
Rtr_105_1055 tree_105 tree_1055 0.512
Cp_1055 tree_1055 0 4.32e-15
Rtr_105_1056 tree_105 tree_1056 0.512
Cp_1056 tree_1056 0 4.32e-15
Rtr_105_1057 tree_105 tree_1057 0.512
Cp_1057 tree_1057 0 4.32e-15
Rtr_105_1058 tree_105 tree_1058 0.512
Cp_1058 tree_1058 0 4.32e-15
Rtr_105_1059 tree_105 tree_1059 0.512
Cp_1059 tree_1059 0 4.32e-15
Rtr_105_1060 tree_105 tree_1060 0.512
Cp_1060 tree_1060 0 4.32e-15
Rtr_106_1061 tree_106 tree_1061 0.512
Cp_1061 tree_1061 0 4.32e-15
Rtr_106_1062 tree_106 tree_1062 0.512
Cp_1062 tree_1062 0 4.32e-15
Rtr_106_1063 tree_106 tree_1063 0.512
Cp_1063 tree_1063 0 4.32e-15
Rtr_106_1064 tree_106 tree_1064 0.512
Cp_1064 tree_1064 0 4.32e-15
Rtr_106_1065 tree_106 tree_1065 0.512
Cp_1065 tree_1065 0 4.32e-15
Rtr_106_1066 tree_106 tree_1066 0.512
Cp_1066 tree_1066 0 4.32e-15
Rtr_106_1067 tree_106 tree_1067 0.512
Cp_1067 tree_1067 0 4.32e-15
Rtr_106_1068 tree_106 tree_1068 0.512
Cp_1068 tree_1068 0 4.32e-15
Rtr_106_1069 tree_106 tree_1069 0.512
Cp_1069 tree_1069 0 4.32e-15
Rtr_106_1070 tree_106 tree_1070 0.512
Cp_1070 tree_1070 0 4.32e-15
Rtr_107_1071 tree_107 tree_1071 0.512
Cp_1071 tree_1071 0 4.32e-15
Rtr_107_1072 tree_107 tree_1072 0.512
Cp_1072 tree_1072 0 4.32e-15
Rtr_107_1073 tree_107 tree_1073 0.512
Cp_1073 tree_1073 0 4.32e-15
Rtr_107_1074 tree_107 tree_1074 0.512
Cp_1074 tree_1074 0 4.32e-15
Rtr_107_1075 tree_107 tree_1075 0.512
Cp_1075 tree_1075 0 4.32e-15
Rtr_107_1076 tree_107 tree_1076 0.512
Cp_1076 tree_1076 0 4.32e-15
Rtr_107_1077 tree_107 tree_1077 0.512
Cp_1077 tree_1077 0 4.32e-15
Rtr_107_1078 tree_107 tree_1078 0.512
Cp_1078 tree_1078 0 4.32e-15
Rtr_107_1079 tree_107 tree_1079 0.512
Cp_1079 tree_1079 0 4.32e-15
Rtr_107_1080 tree_107 tree_1080 0.512
Cp_1080 tree_1080 0 4.32e-15
Rtr_108_1081 tree_108 tree_1081 0.512
Cp_1081 tree_1081 0 4.32e-15
Rtr_108_1082 tree_108 tree_1082 0.512
Cp_1082 tree_1082 0 4.32e-15
Rtr_108_1083 tree_108 tree_1083 0.512
Cp_1083 tree_1083 0 4.32e-15
Rtr_108_1084 tree_108 tree_1084 0.512
Cp_1084 tree_1084 0 4.32e-15
Rtr_108_1085 tree_108 tree_1085 0.512
Cp_1085 tree_1085 0 4.32e-15
Rtr_108_1086 tree_108 tree_1086 0.512
Cp_1086 tree_1086 0 4.32e-15
Rtr_108_1087 tree_108 tree_1087 0.512
Cp_1087 tree_1087 0 4.32e-15
Rtr_108_1088 tree_108 tree_1088 0.512
Cp_1088 tree_1088 0 4.32e-15
Rtr_108_1089 tree_108 tree_1089 0.512
Cp_1089 tree_1089 0 4.32e-15
Rtr_108_1090 tree_108 tree_1090 0.512
Cp_1090 tree_1090 0 4.32e-15
Rtr_109_1091 tree_109 tree_1091 0.512
Cp_1091 tree_1091 0 4.32e-15
Rtr_109_1092 tree_109 tree_1092 0.512
Cp_1092 tree_1092 0 4.32e-15
Rtr_109_1093 tree_109 tree_1093 0.512
Cp_1093 tree_1093 0 4.32e-15
Rtr_109_1094 tree_109 tree_1094 0.512
Cp_1094 tree_1094 0 4.32e-15
Rtr_109_1095 tree_109 tree_1095 0.512
Cp_1095 tree_1095 0 4.32e-15
Rtr_109_1096 tree_109 tree_1096 0.512
Cp_1096 tree_1096 0 4.32e-15
Rtr_109_1097 tree_109 tree_1097 0.512
Cp_1097 tree_1097 0 4.32e-15
Rtr_109_1098 tree_109 tree_1098 0.512
Cp_1098 tree_1098 0 4.32e-15
Rtr_109_1099 tree_109 tree_1099 0.512
Cp_1099 tree_1099 0 4.32e-15
Rtr_109_1100 tree_109 tree_1100 0.512
Cp_1100 tree_1100 0 4.32e-15
Rtr_110_1101 tree_110 tree_1101 0.512
Cp_1101 tree_1101 0 4.32e-15
Rtr_110_1102 tree_110 tree_1102 0.512
Cp_1102 tree_1102 0 4.32e-15
Rtr_110_1103 tree_110 tree_1103 0.512
Cp_1103 tree_1103 0 4.32e-15
Rtr_110_1104 tree_110 tree_1104 0.512
Cp_1104 tree_1104 0 4.32e-15
Rtr_110_1105 tree_110 tree_1105 0.512
Cp_1105 tree_1105 0 4.32e-15
Rtr_110_1106 tree_110 tree_1106 0.512
Cp_1106 tree_1106 0 4.32e-15
Rtr_110_1107 tree_110 tree_1107 0.512
Cp_1107 tree_1107 0 4.32e-15
Rtr_110_1108 tree_110 tree_1108 0.512
Cp_1108 tree_1108 0 4.32e-15
Rtr_110_1109 tree_110 tree_1109 0.512
Cp_1109 tree_1109 0 4.32e-15
Rtr_110_1110 tree_110 tree_1110 0.512
Cp_1110 tree_1110 0 4.32e-15
Rtr_111_1111 tree_111 tree_1111 0.8192
Cp_1111 tree_1111 0 2.592e-15
Rtr_111_1112 tree_111 tree_1112 0.8192
Cp_1112 tree_1112 0 2.592e-15
Rtr_111_1113 tree_111 tree_1113 0.8192
Cp_1113 tree_1113 0 2.592e-15
Rtr_111_1114 tree_111 tree_1114 0.8192
Cp_1114 tree_1114 0 2.592e-15
Rtr_111_1115 tree_111 tree_1115 0.8192
Cp_1115 tree_1115 0 2.592e-15
Rtr_111_1116 tree_111 tree_1116 0.8192
Cp_1116 tree_1116 0 2.592e-15
Rtr_111_1117 tree_111 tree_1117 0.8192
Cp_1117 tree_1117 0 2.592e-15
Rtr_111_1118 tree_111 tree_1118 0.8192
Cp_1118 tree_1118 0 2.592e-15
Rtr_111_1119 tree_111 tree_1119 0.8192
Cp_1119 tree_1119 0 2.592e-15
Rtr_111_1120 tree_111 tree_1120 0.8192
Cp_1120 tree_1120 0 2.592e-15
Rtr_112_1121 tree_112 tree_1121 0.8192
Cp_1121 tree_1121 0 2.592e-15
Rtr_112_1122 tree_112 tree_1122 0.8192
Cp_1122 tree_1122 0 2.592e-15
Rtr_112_1123 tree_112 tree_1123 0.8192
Cp_1123 tree_1123 0 2.592e-15
Rtr_112_1124 tree_112 tree_1124 0.8192
Cp_1124 tree_1124 0 2.592e-15
Rtr_112_1125 tree_112 tree_1125 0.8192
Cp_1125 tree_1125 0 2.592e-15
Rtr_112_1126 tree_112 tree_1126 0.8192
Cp_1126 tree_1126 0 2.592e-15
Rtr_112_1127 tree_112 tree_1127 0.8192
Cp_1127 tree_1127 0 2.592e-15
Rtr_112_1128 tree_112 tree_1128 0.8192
Cp_1128 tree_1128 0 2.592e-15
Rtr_112_1129 tree_112 tree_1129 0.8192
Cp_1129 tree_1129 0 2.592e-15
Rtr_112_1130 tree_112 tree_1130 0.8192
Cp_1130 tree_1130 0 2.592e-15
Rtr_113_1131 tree_113 tree_1131 0.8192
Cp_1131 tree_1131 0 2.592e-15
Rtr_113_1132 tree_113 tree_1132 0.8192
Cp_1132 tree_1132 0 2.592e-15
Rtr_113_1133 tree_113 tree_1133 0.8192
Cp_1133 tree_1133 0 2.592e-15
Rtr_113_1134 tree_113 tree_1134 0.8192
Cp_1134 tree_1134 0 2.592e-15
Rtr_113_1135 tree_113 tree_1135 0.8192
Cp_1135 tree_1135 0 2.592e-15
Rtr_113_1136 tree_113 tree_1136 0.8192
Cp_1136 tree_1136 0 2.592e-15
Rtr_113_1137 tree_113 tree_1137 0.8192
Cp_1137 tree_1137 0 2.592e-15
Rtr_113_1138 tree_113 tree_1138 0.8192
Cp_1138 tree_1138 0 2.592e-15
Rtr_113_1139 tree_113 tree_1139 0.8192
Cp_1139 tree_1139 0 2.592e-15
Rtr_113_1140 tree_113 tree_1140 0.8192
Cp_1140 tree_1140 0 2.592e-15
Rtr_114_1141 tree_114 tree_1141 0.8192
Cp_1141 tree_1141 0 2.592e-15
Rtr_114_1142 tree_114 tree_1142 0.8192
Cp_1142 tree_1142 0 2.592e-15
Rtr_114_1143 tree_114 tree_1143 0.8192
Cp_1143 tree_1143 0 2.592e-15
Rtr_114_1144 tree_114 tree_1144 0.8192
Cp_1144 tree_1144 0 2.592e-15
Rtr_114_1145 tree_114 tree_1145 0.8192
Cp_1145 tree_1145 0 2.592e-15
Rtr_114_1146 tree_114 tree_1146 0.8192
Cp_1146 tree_1146 0 2.592e-15
Rtr_114_1147 tree_114 tree_1147 0.8192
Cp_1147 tree_1147 0 2.592e-15
Rtr_114_1148 tree_114 tree_1148 0.8192
Cp_1148 tree_1148 0 2.592e-15
Rtr_114_1149 tree_114 tree_1149 0.8192
Cp_1149 tree_1149 0 2.592e-15
Rtr_114_1150 tree_114 tree_1150 0.8192
Cp_1150 tree_1150 0 2.592e-15
Rtr_115_1151 tree_115 tree_1151 0.8192
Cp_1151 tree_1151 0 2.592e-15
Rtr_115_1152 tree_115 tree_1152 0.8192
Cp_1152 tree_1152 0 2.592e-15
Rtr_115_1153 tree_115 tree_1153 0.8192
Cp_1153 tree_1153 0 2.592e-15
Rtr_115_1154 tree_115 tree_1154 0.8192
Cp_1154 tree_1154 0 2.592e-15
Rtr_115_1155 tree_115 tree_1155 0.8192
Cp_1155 tree_1155 0 2.592e-15
Rtr_115_1156 tree_115 tree_1156 0.8192
Cp_1156 tree_1156 0 2.592e-15
Rtr_115_1157 tree_115 tree_1157 0.8192
Cp_1157 tree_1157 0 2.592e-15
Rtr_115_1158 tree_115 tree_1158 0.8192
Cp_1158 tree_1158 0 2.592e-15
Rtr_115_1159 tree_115 tree_1159 0.8192
Cp_1159 tree_1159 0 2.592e-15
Rtr_115_1160 tree_115 tree_1160 0.8192
Cp_1160 tree_1160 0 2.592e-15
Rtr_116_1161 tree_116 tree_1161 0.8192
Cp_1161 tree_1161 0 2.592e-15
Rtr_116_1162 tree_116 tree_1162 0.8192
Cp_1162 tree_1162 0 2.592e-15
Rtr_116_1163 tree_116 tree_1163 0.8192
Cp_1163 tree_1163 0 2.592e-15
Rtr_116_1164 tree_116 tree_1164 0.8192
Cp_1164 tree_1164 0 2.592e-15
Rtr_116_1165 tree_116 tree_1165 0.8192
Cp_1165 tree_1165 0 2.592e-15
Rtr_116_1166 tree_116 tree_1166 0.8192
Cp_1166 tree_1166 0 2.592e-15
Rtr_116_1167 tree_116 tree_1167 0.8192
Cp_1167 tree_1167 0 2.592e-15
Rtr_116_1168 tree_116 tree_1168 0.8192
Cp_1168 tree_1168 0 2.592e-15
Rtr_116_1169 tree_116 tree_1169 0.8192
Cp_1169 tree_1169 0 2.592e-15
Rtr_116_1170 tree_116 tree_1170 0.8192
Cp_1170 tree_1170 0 2.592e-15
Rtr_117_1171 tree_117 tree_1171 0.8192
Cp_1171 tree_1171 0 2.592e-15
Rtr_117_1172 tree_117 tree_1172 0.8192
Cp_1172 tree_1172 0 2.592e-15
Rtr_117_1173 tree_117 tree_1173 0.8192
Cp_1173 tree_1173 0 2.592e-15
Rtr_117_1174 tree_117 tree_1174 0.8192
Cp_1174 tree_1174 0 2.592e-15
Rtr_117_1175 tree_117 tree_1175 0.8192
Cp_1175 tree_1175 0 2.592e-15
Rtr_117_1176 tree_117 tree_1176 0.8192
Cp_1176 tree_1176 0 2.592e-15
Rtr_117_1177 tree_117 tree_1177 0.8192
Cp_1177 tree_1177 0 2.592e-15
Rtr_117_1178 tree_117 tree_1178 0.8192
Cp_1178 tree_1178 0 2.592e-15
Rtr_117_1179 tree_117 tree_1179 0.8192
Cp_1179 tree_1179 0 2.592e-15
Rtr_117_1180 tree_117 tree_1180 0.8192
Cp_1180 tree_1180 0 2.592e-15
Rtr_118_1181 tree_118 tree_1181 0.8192
Cp_1181 tree_1181 0 2.592e-15
Rtr_118_1182 tree_118 tree_1182 0.8192
Cp_1182 tree_1182 0 2.592e-15
Rtr_118_1183 tree_118 tree_1183 0.8192
Cp_1183 tree_1183 0 2.592e-15
Rtr_118_1184 tree_118 tree_1184 0.8192
Cp_1184 tree_1184 0 2.592e-15
Rtr_118_1185 tree_118 tree_1185 0.8192
Cp_1185 tree_1185 0 2.592e-15
Rtr_118_1186 tree_118 tree_1186 0.8192
Cp_1186 tree_1186 0 2.592e-15
Rtr_118_1187 tree_118 tree_1187 0.8192
Cp_1187 tree_1187 0 2.592e-15
Rtr_118_1188 tree_118 tree_1188 0.8192
Cp_1188 tree_1188 0 2.592e-15
Rtr_118_1189 tree_118 tree_1189 0.8192
Cp_1189 tree_1189 0 2.592e-15
Rtr_118_1190 tree_118 tree_1190 0.8192
Cp_1190 tree_1190 0 2.592e-15
Rtr_119_1191 tree_119 tree_1191 0.8192
Cp_1191 tree_1191 0 2.592e-15
Rtr_119_1192 tree_119 tree_1192 0.8192
Cp_1192 tree_1192 0 2.592e-15
Rtr_119_1193 tree_119 tree_1193 0.8192
Cp_1193 tree_1193 0 2.592e-15
Rtr_119_1194 tree_119 tree_1194 0.8192
Cp_1194 tree_1194 0 2.592e-15
Rtr_119_1195 tree_119 tree_1195 0.8192
Cp_1195 tree_1195 0 2.592e-15
Rtr_119_1196 tree_119 tree_1196 0.8192
Cp_1196 tree_1196 0 2.592e-15
Rtr_119_1197 tree_119 tree_1197 0.8192
Cp_1197 tree_1197 0 2.592e-15
Rtr_119_1198 tree_119 tree_1198 0.8192
Cp_1198 tree_1198 0 2.592e-15
Rtr_119_1199 tree_119 tree_1199 0.8192
Cp_1199 tree_1199 0 2.592e-15
Rtr_119_1200 tree_119 tree_1200 0.8192
Cp_1200 tree_1200 0 2.592e-15
Rtr_120_1201 tree_120 tree_1201 0.8192
Cp_1201 tree_1201 0 2.592e-15
Rtr_120_1202 tree_120 tree_1202 0.8192
Cp_1202 tree_1202 0 2.592e-15
Rtr_120_1203 tree_120 tree_1203 0.8192
Cp_1203 tree_1203 0 2.592e-15
Rtr_120_1204 tree_120 tree_1204 0.8192
Cp_1204 tree_1204 0 2.592e-15
Rtr_120_1205 tree_120 tree_1205 0.8192
Cp_1205 tree_1205 0 2.592e-15
Rtr_120_1206 tree_120 tree_1206 0.8192
Cp_1206 tree_1206 0 2.592e-15
Rtr_120_1207 tree_120 tree_1207 0.8192
Cp_1207 tree_1207 0 2.592e-15
Rtr_120_1208 tree_120 tree_1208 0.8192
Cp_1208 tree_1208 0 2.592e-15
Rtr_120_1209 tree_120 tree_1209 0.8192
Cp_1209 tree_1209 0 2.592e-15
Rtr_120_1210 tree_120 tree_1210 0.8192
Cp_1210 tree_1210 0 2.592e-15
Rtr_121_1211 tree_121 tree_1211 0.8192
Cp_1211 tree_1211 0 2.592e-15
Rtr_121_1212 tree_121 tree_1212 0.8192
Cp_1212 tree_1212 0 2.592e-15
Rtr_121_1213 tree_121 tree_1213 0.8192
Cp_1213 tree_1213 0 2.592e-15
Rtr_121_1214 tree_121 tree_1214 0.8192
Cp_1214 tree_1214 0 2.592e-15
Rtr_121_1215 tree_121 tree_1215 0.8192
Cp_1215 tree_1215 0 2.592e-15
Rtr_121_1216 tree_121 tree_1216 0.8192
Cp_1216 tree_1216 0 2.592e-15
Rtr_121_1217 tree_121 tree_1217 0.8192
Cp_1217 tree_1217 0 2.592e-15
Rtr_121_1218 tree_121 tree_1218 0.8192
Cp_1218 tree_1218 0 2.592e-15
Rtr_121_1219 tree_121 tree_1219 0.8192
Cp_1219 tree_1219 0 2.592e-15
Rtr_121_1220 tree_121 tree_1220 0.8192
Cp_1220 tree_1220 0 2.592e-15
Rtr_122_1221 tree_122 tree_1221 0.8192
Cp_1221 tree_1221 0 2.592e-15
Rtr_122_1222 tree_122 tree_1222 0.8192
Cp_1222 tree_1222 0 2.592e-15
Rtr_122_1223 tree_122 tree_1223 0.8192
Cp_1223 tree_1223 0 2.592e-15
Rtr_122_1224 tree_122 tree_1224 0.8192
Cp_1224 tree_1224 0 2.592e-15
Rtr_122_1225 tree_122 tree_1225 0.8192
Cp_1225 tree_1225 0 2.592e-15
Rtr_122_1226 tree_122 tree_1226 0.8192
Cp_1226 tree_1226 0 2.592e-15
Rtr_122_1227 tree_122 tree_1227 0.8192
Cp_1227 tree_1227 0 2.592e-15
Rtr_122_1228 tree_122 tree_1228 0.8192
Cp_1228 tree_1228 0 2.592e-15
Rtr_122_1229 tree_122 tree_1229 0.8192
Cp_1229 tree_1229 0 2.592e-15
Rtr_122_1230 tree_122 tree_1230 0.8192
Cp_1230 tree_1230 0 2.592e-15
Rtr_123_1231 tree_123 tree_1231 0.8192
Cp_1231 tree_1231 0 2.592e-15
Rtr_123_1232 tree_123 tree_1232 0.8192
Cp_1232 tree_1232 0 2.592e-15
Rtr_123_1233 tree_123 tree_1233 0.8192
Cp_1233 tree_1233 0 2.592e-15
Rtr_123_1234 tree_123 tree_1234 0.8192
Cp_1234 tree_1234 0 2.592e-15
Rtr_123_1235 tree_123 tree_1235 0.8192
Cp_1235 tree_1235 0 2.592e-15
Rtr_123_1236 tree_123 tree_1236 0.8192
Cp_1236 tree_1236 0 2.592e-15
Rtr_123_1237 tree_123 tree_1237 0.8192
Cp_1237 tree_1237 0 2.592e-15
Rtr_123_1238 tree_123 tree_1238 0.8192
Cp_1238 tree_1238 0 2.592e-15
Rtr_123_1239 tree_123 tree_1239 0.8192
Cp_1239 tree_1239 0 2.592e-15
Rtr_123_1240 tree_123 tree_1240 0.8192
Cp_1240 tree_1240 0 2.592e-15
Rtr_124_1241 tree_124 tree_1241 0.8192
Cp_1241 tree_1241 0 2.592e-15
Rtr_124_1242 tree_124 tree_1242 0.8192
Cp_1242 tree_1242 0 2.592e-15
Rtr_124_1243 tree_124 tree_1243 0.8192
Cp_1243 tree_1243 0 2.592e-15
Rtr_124_1244 tree_124 tree_1244 0.8192
Cp_1244 tree_1244 0 2.592e-15
Rtr_124_1245 tree_124 tree_1245 0.8192
Cp_1245 tree_1245 0 2.592e-15
Rtr_124_1246 tree_124 tree_1246 0.8192
Cp_1246 tree_1246 0 2.592e-15
Rtr_124_1247 tree_124 tree_1247 0.8192
Cp_1247 tree_1247 0 2.592e-15
Rtr_124_1248 tree_124 tree_1248 0.8192
Cp_1248 tree_1248 0 2.592e-15
Rtr_124_1249 tree_124 tree_1249 0.8192
Cp_1249 tree_1249 0 2.592e-15
Rtr_124_1250 tree_124 tree_1250 0.8192
Cp_1250 tree_1250 0 2.592e-15
Rtr_125_1251 tree_125 tree_1251 0.8192
Cp_1251 tree_1251 0 2.592e-15
Rtr_125_1252 tree_125 tree_1252 0.8192
Cp_1252 tree_1252 0 2.592e-15
Rtr_125_1253 tree_125 tree_1253 0.8192
Cp_1253 tree_1253 0 2.592e-15
Rtr_125_1254 tree_125 tree_1254 0.8192
Cp_1254 tree_1254 0 2.592e-15
Rtr_125_1255 tree_125 tree_1255 0.8192
Cp_1255 tree_1255 0 2.592e-15
Rtr_125_1256 tree_125 tree_1256 0.8192
Cp_1256 tree_1256 0 2.592e-15
Rtr_125_1257 tree_125 tree_1257 0.8192
Cp_1257 tree_1257 0 2.592e-15
Rtr_125_1258 tree_125 tree_1258 0.8192
Cp_1258 tree_1258 0 2.592e-15
Rtr_125_1259 tree_125 tree_1259 0.8192
Cp_1259 tree_1259 0 2.592e-15
Rtr_125_1260 tree_125 tree_1260 0.8192
Cp_1260 tree_1260 0 2.592e-15
Rtr_126_1261 tree_126 tree_1261 0.8192
Cp_1261 tree_1261 0 2.592e-15
Rtr_126_1262 tree_126 tree_1262 0.8192
Cp_1262 tree_1262 0 2.592e-15
Rtr_126_1263 tree_126 tree_1263 0.8192
Cp_1263 tree_1263 0 2.592e-15
Rtr_126_1264 tree_126 tree_1264 0.8192
Cp_1264 tree_1264 0 2.592e-15
Rtr_126_1265 tree_126 tree_1265 0.8192
Cp_1265 tree_1265 0 2.592e-15
Rtr_126_1266 tree_126 tree_1266 0.8192
Cp_1266 tree_1266 0 2.592e-15
Rtr_126_1267 tree_126 tree_1267 0.8192
Cp_1267 tree_1267 0 2.592e-15
Rtr_126_1268 tree_126 tree_1268 0.8192
Cp_1268 tree_1268 0 2.592e-15
Rtr_126_1269 tree_126 tree_1269 0.8192
Cp_1269 tree_1269 0 2.592e-15
Rtr_126_1270 tree_126 tree_1270 0.8192
Cp_1270 tree_1270 0 2.592e-15
Rtr_127_1271 tree_127 tree_1271 0.8192
Cp_1271 tree_1271 0 2.592e-15
Rtr_127_1272 tree_127 tree_1272 0.8192
Cp_1272 tree_1272 0 2.592e-15
Rtr_127_1273 tree_127 tree_1273 0.8192
Cp_1273 tree_1273 0 2.592e-15
Rtr_127_1274 tree_127 tree_1274 0.8192
Cp_1274 tree_1274 0 2.592e-15
Rtr_127_1275 tree_127 tree_1275 0.8192
Cp_1275 tree_1275 0 2.592e-15
Rtr_127_1276 tree_127 tree_1276 0.8192
Cp_1276 tree_1276 0 2.592e-15
Rtr_127_1277 tree_127 tree_1277 0.8192
Cp_1277 tree_1277 0 2.592e-15
Rtr_127_1278 tree_127 tree_1278 0.8192
Cp_1278 tree_1278 0 2.592e-15
Rtr_127_1279 tree_127 tree_1279 0.8192
Cp_1279 tree_1279 0 2.592e-15
Rtr_127_1280 tree_127 tree_1280 0.8192
Cp_1280 tree_1280 0 2.592e-15
Rtr_128_1281 tree_128 tree_1281 0.8192
Cp_1281 tree_1281 0 2.592e-15
Rtr_128_1282 tree_128 tree_1282 0.8192
Cp_1282 tree_1282 0 2.592e-15
Rtr_128_1283 tree_128 tree_1283 0.8192
Cp_1283 tree_1283 0 2.592e-15
Rtr_128_1284 tree_128 tree_1284 0.8192
Cp_1284 tree_1284 0 2.592e-15
Rtr_128_1285 tree_128 tree_1285 0.8192
Cp_1285 tree_1285 0 2.592e-15
Rtr_128_1286 tree_128 tree_1286 0.8192
Cp_1286 tree_1286 0 2.592e-15
Rtr_128_1287 tree_128 tree_1287 0.8192
Cp_1287 tree_1287 0 2.592e-15
Rtr_128_1288 tree_128 tree_1288 0.8192
Cp_1288 tree_1288 0 2.592e-15
Rtr_128_1289 tree_128 tree_1289 0.8192
Cp_1289 tree_1289 0 2.592e-15
Rtr_128_1290 tree_128 tree_1290 0.8192
Cp_1290 tree_1290 0 2.592e-15
Rtr_129_1291 tree_129 tree_1291 0.8192
Cp_1291 tree_1291 0 2.592e-15
Rtr_129_1292 tree_129 tree_1292 0.8192
Cp_1292 tree_1292 0 2.592e-15
Rtr_129_1293 tree_129 tree_1293 0.8192
Cp_1293 tree_1293 0 2.592e-15
Rtr_129_1294 tree_129 tree_1294 0.8192
Cp_1294 tree_1294 0 2.592e-15
Rtr_129_1295 tree_129 tree_1295 0.8192
Cp_1295 tree_1295 0 2.592e-15
Rtr_129_1296 tree_129 tree_1296 0.8192
Cp_1296 tree_1296 0 2.592e-15
Rtr_129_1297 tree_129 tree_1297 0.8192
Cp_1297 tree_1297 0 2.592e-15
Rtr_129_1298 tree_129 tree_1298 0.8192
Cp_1298 tree_1298 0 2.592e-15
Rtr_129_1299 tree_129 tree_1299 0.8192
Cp_1299 tree_1299 0 2.592e-15
Rtr_129_1300 tree_129 tree_1300 0.8192
Cp_1300 tree_1300 0 2.592e-15
Rtr_130_1301 tree_130 tree_1301 0.8192
Cp_1301 tree_1301 0 2.592e-15
Rtr_130_1302 tree_130 tree_1302 0.8192
Cp_1302 tree_1302 0 2.592e-15
Rtr_130_1303 tree_130 tree_1303 0.8192
Cp_1303 tree_1303 0 2.592e-15
Rtr_130_1304 tree_130 tree_1304 0.8192
Cp_1304 tree_1304 0 2.592e-15
Rtr_130_1305 tree_130 tree_1305 0.8192
Cp_1305 tree_1305 0 2.592e-15
Rtr_130_1306 tree_130 tree_1306 0.8192
Cp_1306 tree_1306 0 2.592e-15
Rtr_130_1307 tree_130 tree_1307 0.8192
Cp_1307 tree_1307 0 2.592e-15
Rtr_130_1308 tree_130 tree_1308 0.8192
Cp_1308 tree_1308 0 2.592e-15
Rtr_130_1309 tree_130 tree_1309 0.8192
Cp_1309 tree_1309 0 2.592e-15
Rtr_130_1310 tree_130 tree_1310 0.8192
Cp_1310 tree_1310 0 2.592e-15
Rtr_131_1311 tree_131 tree_1311 0.8192
Cp_1311 tree_1311 0 2.592e-15
Rtr_131_1312 tree_131 tree_1312 0.8192
Cp_1312 tree_1312 0 2.592e-15
Rtr_131_1313 tree_131 tree_1313 0.8192
Cp_1313 tree_1313 0 2.592e-15
Rtr_131_1314 tree_131 tree_1314 0.8192
Cp_1314 tree_1314 0 2.592e-15
Rtr_131_1315 tree_131 tree_1315 0.8192
Cp_1315 tree_1315 0 2.592e-15
Rtr_131_1316 tree_131 tree_1316 0.8192
Cp_1316 tree_1316 0 2.592e-15
Rtr_131_1317 tree_131 tree_1317 0.8192
Cp_1317 tree_1317 0 2.592e-15
Rtr_131_1318 tree_131 tree_1318 0.8192
Cp_1318 tree_1318 0 2.592e-15
Rtr_131_1319 tree_131 tree_1319 0.8192
Cp_1319 tree_1319 0 2.592e-15
Rtr_131_1320 tree_131 tree_1320 0.8192
Cp_1320 tree_1320 0 2.592e-15
Rtr_132_1321 tree_132 tree_1321 0.8192
Cp_1321 tree_1321 0 2.592e-15
Rtr_132_1322 tree_132 tree_1322 0.8192
Cp_1322 tree_1322 0 2.592e-15
Rtr_132_1323 tree_132 tree_1323 0.8192
Cp_1323 tree_1323 0 2.592e-15
Rtr_132_1324 tree_132 tree_1324 0.8192
Cp_1324 tree_1324 0 2.592e-15
Rtr_132_1325 tree_132 tree_1325 0.8192
Cp_1325 tree_1325 0 2.592e-15
Rtr_132_1326 tree_132 tree_1326 0.8192
Cp_1326 tree_1326 0 2.592e-15
Rtr_132_1327 tree_132 tree_1327 0.8192
Cp_1327 tree_1327 0 2.592e-15
Rtr_132_1328 tree_132 tree_1328 0.8192
Cp_1328 tree_1328 0 2.592e-15
Rtr_132_1329 tree_132 tree_1329 0.8192
Cp_1329 tree_1329 0 2.592e-15
Rtr_132_1330 tree_132 tree_1330 0.8192
Cp_1330 tree_1330 0 2.592e-15
Rtr_133_1331 tree_133 tree_1331 0.8192
Cp_1331 tree_1331 0 2.592e-15
Rtr_133_1332 tree_133 tree_1332 0.8192
Cp_1332 tree_1332 0 2.592e-15
Rtr_133_1333 tree_133 tree_1333 0.8192
Cp_1333 tree_1333 0 2.592e-15
Rtr_133_1334 tree_133 tree_1334 0.8192
Cp_1334 tree_1334 0 2.592e-15
Rtr_133_1335 tree_133 tree_1335 0.8192
Cp_1335 tree_1335 0 2.592e-15
Rtr_133_1336 tree_133 tree_1336 0.8192
Cp_1336 tree_1336 0 2.592e-15
Rtr_133_1337 tree_133 tree_1337 0.8192
Cp_1337 tree_1337 0 2.592e-15
Rtr_133_1338 tree_133 tree_1338 0.8192
Cp_1338 tree_1338 0 2.592e-15
Rtr_133_1339 tree_133 tree_1339 0.8192
Cp_1339 tree_1339 0 2.592e-15
Rtr_133_1340 tree_133 tree_1340 0.8192
Cp_1340 tree_1340 0 2.592e-15
Rtr_134_1341 tree_134 tree_1341 0.8192
Cp_1341 tree_1341 0 2.592e-15
Rtr_134_1342 tree_134 tree_1342 0.8192
Cp_1342 tree_1342 0 2.592e-15
Rtr_134_1343 tree_134 tree_1343 0.8192
Cp_1343 tree_1343 0 2.592e-15
Rtr_134_1344 tree_134 tree_1344 0.8192
Cp_1344 tree_1344 0 2.592e-15
Rtr_134_1345 tree_134 tree_1345 0.8192
Cp_1345 tree_1345 0 2.592e-15
Rtr_134_1346 tree_134 tree_1346 0.8192
Cp_1346 tree_1346 0 2.592e-15
Rtr_134_1347 tree_134 tree_1347 0.8192
Cp_1347 tree_1347 0 2.592e-15
Rtr_134_1348 tree_134 tree_1348 0.8192
Cp_1348 tree_1348 0 2.592e-15
Rtr_134_1349 tree_134 tree_1349 0.8192
Cp_1349 tree_1349 0 2.592e-15
Rtr_134_1350 tree_134 tree_1350 0.8192
Cp_1350 tree_1350 0 2.592e-15
Rtr_135_1351 tree_135 tree_1351 0.8192
Cp_1351 tree_1351 0 2.592e-15
Rtr_135_1352 tree_135 tree_1352 0.8192
Cp_1352 tree_1352 0 2.592e-15
Rtr_135_1353 tree_135 tree_1353 0.8192
Cp_1353 tree_1353 0 2.592e-15
Rtr_135_1354 tree_135 tree_1354 0.8192
Cp_1354 tree_1354 0 2.592e-15
Rtr_135_1355 tree_135 tree_1355 0.8192
Cp_1355 tree_1355 0 2.592e-15
Rtr_135_1356 tree_135 tree_1356 0.8192
Cp_1356 tree_1356 0 2.592e-15
Rtr_135_1357 tree_135 tree_1357 0.8192
Cp_1357 tree_1357 0 2.592e-15
Rtr_135_1358 tree_135 tree_1358 0.8192
Cp_1358 tree_1358 0 2.592e-15
Rtr_135_1359 tree_135 tree_1359 0.8192
Cp_1359 tree_1359 0 2.592e-15
Rtr_135_1360 tree_135 tree_1360 0.8192
Cp_1360 tree_1360 0 2.592e-15
Rtr_136_1361 tree_136 tree_1361 0.8192
Cp_1361 tree_1361 0 2.592e-15
Rtr_136_1362 tree_136 tree_1362 0.8192
Cp_1362 tree_1362 0 2.592e-15
Rtr_136_1363 tree_136 tree_1363 0.8192
Cp_1363 tree_1363 0 2.592e-15
Rtr_136_1364 tree_136 tree_1364 0.8192
Cp_1364 tree_1364 0 2.592e-15
Rtr_136_1365 tree_136 tree_1365 0.8192
Cp_1365 tree_1365 0 2.592e-15
Rtr_136_1366 tree_136 tree_1366 0.8192
Cp_1366 tree_1366 0 2.592e-15
Rtr_136_1367 tree_136 tree_1367 0.8192
Cp_1367 tree_1367 0 2.592e-15
Rtr_136_1368 tree_136 tree_1368 0.8192
Cp_1368 tree_1368 0 2.592e-15
Rtr_136_1369 tree_136 tree_1369 0.8192
Cp_1369 tree_1369 0 2.592e-15
Rtr_136_1370 tree_136 tree_1370 0.8192
Cp_1370 tree_1370 0 2.592e-15
Rtr_137_1371 tree_137 tree_1371 0.8192
Cp_1371 tree_1371 0 2.592e-15
Rtr_137_1372 tree_137 tree_1372 0.8192
Cp_1372 tree_1372 0 2.592e-15
Rtr_137_1373 tree_137 tree_1373 0.8192
Cp_1373 tree_1373 0 2.592e-15
Rtr_137_1374 tree_137 tree_1374 0.8192
Cp_1374 tree_1374 0 2.592e-15
Rtr_137_1375 tree_137 tree_1375 0.8192
Cp_1375 tree_1375 0 2.592e-15
Rtr_137_1376 tree_137 tree_1376 0.8192
Cp_1376 tree_1376 0 2.592e-15
Rtr_137_1377 tree_137 tree_1377 0.8192
Cp_1377 tree_1377 0 2.592e-15
Rtr_137_1378 tree_137 tree_1378 0.8192
Cp_1378 tree_1378 0 2.592e-15
Rtr_137_1379 tree_137 tree_1379 0.8192
Cp_1379 tree_1379 0 2.592e-15
Rtr_137_1380 tree_137 tree_1380 0.8192
Cp_1380 tree_1380 0 2.592e-15
Rtr_138_1381 tree_138 tree_1381 0.8192
Cp_1381 tree_1381 0 2.592e-15
Rtr_138_1382 tree_138 tree_1382 0.8192
Cp_1382 tree_1382 0 2.592e-15
Rtr_138_1383 tree_138 tree_1383 0.8192
Cp_1383 tree_1383 0 2.592e-15
Rtr_138_1384 tree_138 tree_1384 0.8192
Cp_1384 tree_1384 0 2.592e-15
Rtr_138_1385 tree_138 tree_1385 0.8192
Cp_1385 tree_1385 0 2.592e-15
Rtr_138_1386 tree_138 tree_1386 0.8192
Cp_1386 tree_1386 0 2.592e-15
Rtr_138_1387 tree_138 tree_1387 0.8192
Cp_1387 tree_1387 0 2.592e-15
Rtr_138_1388 tree_138 tree_1388 0.8192
Cp_1388 tree_1388 0 2.592e-15
Rtr_138_1389 tree_138 tree_1389 0.8192
Cp_1389 tree_1389 0 2.592e-15
Rtr_138_1390 tree_138 tree_1390 0.8192
Cp_1390 tree_1390 0 2.592e-15
Rtr_139_1391 tree_139 tree_1391 0.8192
Cp_1391 tree_1391 0 2.592e-15
Rtr_139_1392 tree_139 tree_1392 0.8192
Cp_1392 tree_1392 0 2.592e-15
Rtr_139_1393 tree_139 tree_1393 0.8192
Cp_1393 tree_1393 0 2.592e-15
Rtr_139_1394 tree_139 tree_1394 0.8192
Cp_1394 tree_1394 0 2.592e-15
Rtr_139_1395 tree_139 tree_1395 0.8192
Cp_1395 tree_1395 0 2.592e-15
Rtr_139_1396 tree_139 tree_1396 0.8192
Cp_1396 tree_1396 0 2.592e-15
Rtr_139_1397 tree_139 tree_1397 0.8192
Cp_1397 tree_1397 0 2.592e-15
Rtr_139_1398 tree_139 tree_1398 0.8192
Cp_1398 tree_1398 0 2.592e-15
Rtr_139_1399 tree_139 tree_1399 0.8192
Cp_1399 tree_1399 0 2.592e-15
Rtr_139_1400 tree_139 tree_1400 0.8192
Cp_1400 tree_1400 0 2.592e-15
Rtr_140_1401 tree_140 tree_1401 0.8192
Cp_1401 tree_1401 0 2.592e-15
Rtr_140_1402 tree_140 tree_1402 0.8192
Cp_1402 tree_1402 0 2.592e-15
Rtr_140_1403 tree_140 tree_1403 0.8192
Cp_1403 tree_1403 0 2.592e-15
Rtr_140_1404 tree_140 tree_1404 0.8192
Cp_1404 tree_1404 0 2.592e-15
Rtr_140_1405 tree_140 tree_1405 0.8192
Cp_1405 tree_1405 0 2.592e-15
Rtr_140_1406 tree_140 tree_1406 0.8192
Cp_1406 tree_1406 0 2.592e-15
Rtr_140_1407 tree_140 tree_1407 0.8192
Cp_1407 tree_1407 0 2.592e-15
Rtr_140_1408 tree_140 tree_1408 0.8192
Cp_1408 tree_1408 0 2.592e-15
Rtr_140_1409 tree_140 tree_1409 0.8192
Cp_1409 tree_1409 0 2.592e-15
Rtr_140_1410 tree_140 tree_1410 0.8192
Cp_1410 tree_1410 0 2.592e-15
Rtr_141_1411 tree_141 tree_1411 0.8192
Cp_1411 tree_1411 0 2.592e-15
Rtr_141_1412 tree_141 tree_1412 0.8192
Cp_1412 tree_1412 0 2.592e-15
Rtr_141_1413 tree_141 tree_1413 0.8192
Cp_1413 tree_1413 0 2.592e-15
Rtr_141_1414 tree_141 tree_1414 0.8192
Cp_1414 tree_1414 0 2.592e-15
Rtr_141_1415 tree_141 tree_1415 0.8192
Cp_1415 tree_1415 0 2.592e-15
Rtr_141_1416 tree_141 tree_1416 0.8192
Cp_1416 tree_1416 0 2.592e-15
Rtr_141_1417 tree_141 tree_1417 0.8192
Cp_1417 tree_1417 0 2.592e-15
Rtr_141_1418 tree_141 tree_1418 0.8192
Cp_1418 tree_1418 0 2.592e-15
Rtr_141_1419 tree_141 tree_1419 0.8192
Cp_1419 tree_1419 0 2.592e-15
Rtr_141_1420 tree_141 tree_1420 0.8192
Cp_1420 tree_1420 0 2.592e-15
Rtr_142_1421 tree_142 tree_1421 0.8192
Cp_1421 tree_1421 0 2.592e-15
Rtr_142_1422 tree_142 tree_1422 0.8192
Cp_1422 tree_1422 0 2.592e-15
Rtr_142_1423 tree_142 tree_1423 0.8192
Cp_1423 tree_1423 0 2.592e-15
Rtr_142_1424 tree_142 tree_1424 0.8192
Cp_1424 tree_1424 0 2.592e-15
Rtr_142_1425 tree_142 tree_1425 0.8192
Cp_1425 tree_1425 0 2.592e-15
Rtr_142_1426 tree_142 tree_1426 0.8192
Cp_1426 tree_1426 0 2.592e-15
Rtr_142_1427 tree_142 tree_1427 0.8192
Cp_1427 tree_1427 0 2.592e-15
Rtr_142_1428 tree_142 tree_1428 0.8192
Cp_1428 tree_1428 0 2.592e-15
Rtr_142_1429 tree_142 tree_1429 0.8192
Cp_1429 tree_1429 0 2.592e-15
Rtr_142_1430 tree_142 tree_1430 0.8192
Cp_1430 tree_1430 0 2.592e-15
Rtr_143_1431 tree_143 tree_1431 0.8192
Cp_1431 tree_1431 0 2.592e-15
Rtr_143_1432 tree_143 tree_1432 0.8192
Cp_1432 tree_1432 0 2.592e-15
Rtr_143_1433 tree_143 tree_1433 0.8192
Cp_1433 tree_1433 0 2.592e-15
Rtr_143_1434 tree_143 tree_1434 0.8192
Cp_1434 tree_1434 0 2.592e-15
Rtr_143_1435 tree_143 tree_1435 0.8192
Cp_1435 tree_1435 0 2.592e-15
Rtr_143_1436 tree_143 tree_1436 0.8192
Cp_1436 tree_1436 0 2.592e-15
Rtr_143_1437 tree_143 tree_1437 0.8192
Cp_1437 tree_1437 0 2.592e-15
Rtr_143_1438 tree_143 tree_1438 0.8192
Cp_1438 tree_1438 0 2.592e-15
Rtr_143_1439 tree_143 tree_1439 0.8192
Cp_1439 tree_1439 0 2.592e-15
Rtr_143_1440 tree_143 tree_1440 0.8192
Cp_1440 tree_1440 0 2.592e-15
Rtr_144_1441 tree_144 tree_1441 0.8192
Cp_1441 tree_1441 0 2.592e-15
Rtr_144_1442 tree_144 tree_1442 0.8192
Cp_1442 tree_1442 0 2.592e-15
Rtr_144_1443 tree_144 tree_1443 0.8192
Cp_1443 tree_1443 0 2.592e-15
Rtr_144_1444 tree_144 tree_1444 0.8192
Cp_1444 tree_1444 0 2.592e-15
Rtr_144_1445 tree_144 tree_1445 0.8192
Cp_1445 tree_1445 0 2.592e-15
Rtr_144_1446 tree_144 tree_1446 0.8192
Cp_1446 tree_1446 0 2.592e-15
Rtr_144_1447 tree_144 tree_1447 0.8192
Cp_1447 tree_1447 0 2.592e-15
Rtr_144_1448 tree_144 tree_1448 0.8192
Cp_1448 tree_1448 0 2.592e-15
Rtr_144_1449 tree_144 tree_1449 0.8192
Cp_1449 tree_1449 0 2.592e-15
Rtr_144_1450 tree_144 tree_1450 0.8192
Cp_1450 tree_1450 0 2.592e-15
Rtr_145_1451 tree_145 tree_1451 0.8192
Cp_1451 tree_1451 0 2.592e-15
Rtr_145_1452 tree_145 tree_1452 0.8192
Cp_1452 tree_1452 0 2.592e-15
Rtr_145_1453 tree_145 tree_1453 0.8192
Cp_1453 tree_1453 0 2.592e-15
Rtr_145_1454 tree_145 tree_1454 0.8192
Cp_1454 tree_1454 0 2.592e-15
Rtr_145_1455 tree_145 tree_1455 0.8192
Cp_1455 tree_1455 0 2.592e-15
Rtr_145_1456 tree_145 tree_1456 0.8192
Cp_1456 tree_1456 0 2.592e-15
Rtr_145_1457 tree_145 tree_1457 0.8192
Cp_1457 tree_1457 0 2.592e-15
Rtr_145_1458 tree_145 tree_1458 0.8192
Cp_1458 tree_1458 0 2.592e-15
Rtr_145_1459 tree_145 tree_1459 0.8192
Cp_1459 tree_1459 0 2.592e-15
Rtr_145_1460 tree_145 tree_1460 0.8192
Cp_1460 tree_1460 0 2.592e-15
Rtr_146_1461 tree_146 tree_1461 0.8192
Cp_1461 tree_1461 0 2.592e-15
Rtr_146_1462 tree_146 tree_1462 0.8192
Cp_1462 tree_1462 0 2.592e-15
Rtr_146_1463 tree_146 tree_1463 0.8192
Cp_1463 tree_1463 0 2.592e-15
Rtr_146_1464 tree_146 tree_1464 0.8192
Cp_1464 tree_1464 0 2.592e-15
Rtr_146_1465 tree_146 tree_1465 0.8192
Cp_1465 tree_1465 0 2.592e-15
Rtr_146_1466 tree_146 tree_1466 0.8192
Cp_1466 tree_1466 0 2.592e-15
Rtr_146_1467 tree_146 tree_1467 0.8192
Cp_1467 tree_1467 0 2.592e-15
Rtr_146_1468 tree_146 tree_1468 0.8192
Cp_1468 tree_1468 0 2.592e-15
Rtr_146_1469 tree_146 tree_1469 0.8192
Cp_1469 tree_1469 0 2.592e-15
Rtr_146_1470 tree_146 tree_1470 0.8192
Cp_1470 tree_1470 0 2.592e-15
Rtr_147_1471 tree_147 tree_1471 0.8192
Cp_1471 tree_1471 0 2.592e-15
Rtr_147_1472 tree_147 tree_1472 0.8192
Cp_1472 tree_1472 0 2.592e-15
Rtr_147_1473 tree_147 tree_1473 0.8192
Cp_1473 tree_1473 0 2.592e-15
Rtr_147_1474 tree_147 tree_1474 0.8192
Cp_1474 tree_1474 0 2.592e-15
Rtr_147_1475 tree_147 tree_1475 0.8192
Cp_1475 tree_1475 0 2.592e-15
Rtr_147_1476 tree_147 tree_1476 0.8192
Cp_1476 tree_1476 0 2.592e-15
Rtr_147_1477 tree_147 tree_1477 0.8192
Cp_1477 tree_1477 0 2.592e-15
Rtr_147_1478 tree_147 tree_1478 0.8192
Cp_1478 tree_1478 0 2.592e-15
Rtr_147_1479 tree_147 tree_1479 0.8192
Cp_1479 tree_1479 0 2.592e-15
Rtr_147_1480 tree_147 tree_1480 0.8192
Cp_1480 tree_1480 0 2.592e-15
Rtr_148_1481 tree_148 tree_1481 0.8192
Cp_1481 tree_1481 0 2.592e-15
Rtr_148_1482 tree_148 tree_1482 0.8192
Cp_1482 tree_1482 0 2.592e-15
Rtr_148_1483 tree_148 tree_1483 0.8192
Cp_1483 tree_1483 0 2.592e-15
Rtr_148_1484 tree_148 tree_1484 0.8192
Cp_1484 tree_1484 0 2.592e-15
Rtr_148_1485 tree_148 tree_1485 0.8192
Cp_1485 tree_1485 0 2.592e-15
Rtr_148_1486 tree_148 tree_1486 0.8192
Cp_1486 tree_1486 0 2.592e-15
Rtr_148_1487 tree_148 tree_1487 0.8192
Cp_1487 tree_1487 0 2.592e-15
Rtr_148_1488 tree_148 tree_1488 0.8192
Cp_1488 tree_1488 0 2.592e-15
Rtr_148_1489 tree_148 tree_1489 0.8192
Cp_1489 tree_1489 0 2.592e-15
Rtr_148_1490 tree_148 tree_1490 0.8192
Cp_1490 tree_1490 0 2.592e-15
Rtr_149_1491 tree_149 tree_1491 0.8192
Cp_1491 tree_1491 0 2.592e-15
Rtr_149_1492 tree_149 tree_1492 0.8192
Cp_1492 tree_1492 0 2.592e-15
Rtr_149_1493 tree_149 tree_1493 0.8192
Cp_1493 tree_1493 0 2.592e-15
Rtr_149_1494 tree_149 tree_1494 0.8192
Cp_1494 tree_1494 0 2.592e-15
Rtr_149_1495 tree_149 tree_1495 0.8192
Cp_1495 tree_1495 0 2.592e-15
Rtr_149_1496 tree_149 tree_1496 0.8192
Cp_1496 tree_1496 0 2.592e-15
Rtr_149_1497 tree_149 tree_1497 0.8192
Cp_1497 tree_1497 0 2.592e-15
Rtr_149_1498 tree_149 tree_1498 0.8192
Cp_1498 tree_1498 0 2.592e-15
Rtr_149_1499 tree_149 tree_1499 0.8192
Cp_1499 tree_1499 0 2.592e-15
Rtr_149_1500 tree_149 tree_1500 0.8192
Cp_1500 tree_1500 0 2.592e-15
Rtr_150_1501 tree_150 tree_1501 0.8192
Cp_1501 tree_1501 0 2.592e-15
Rtr_150_1502 tree_150 tree_1502 0.8192
Cp_1502 tree_1502 0 2.592e-15
Rtr_150_1503 tree_150 tree_1503 0.8192
Cp_1503 tree_1503 0 2.592e-15
Rtr_150_1504 tree_150 tree_1504 0.8192
Cp_1504 tree_1504 0 2.592e-15
Rtr_150_1505 tree_150 tree_1505 0.8192
Cp_1505 tree_1505 0 2.592e-15
Rtr_150_1506 tree_150 tree_1506 0.8192
Cp_1506 tree_1506 0 2.592e-15
Rtr_150_1507 tree_150 tree_1507 0.8192
Cp_1507 tree_1507 0 2.592e-15
Rtr_150_1508 tree_150 tree_1508 0.8192
Cp_1508 tree_1508 0 2.592e-15
Rtr_150_1509 tree_150 tree_1509 0.8192
Cp_1509 tree_1509 0 2.592e-15
Rtr_150_1510 tree_150 tree_1510 0.8192
Cp_1510 tree_1510 0 2.592e-15
Rtr_151_1511 tree_151 tree_1511 0.8192
Cp_1511 tree_1511 0 2.592e-15
Rtr_151_1512 tree_151 tree_1512 0.8192
Cp_1512 tree_1512 0 2.592e-15
Rtr_151_1513 tree_151 tree_1513 0.8192
Cp_1513 tree_1513 0 2.592e-15
Rtr_151_1514 tree_151 tree_1514 0.8192
Cp_1514 tree_1514 0 2.592e-15
Rtr_151_1515 tree_151 tree_1515 0.8192
Cp_1515 tree_1515 0 2.592e-15
Rtr_151_1516 tree_151 tree_1516 0.8192
Cp_1516 tree_1516 0 2.592e-15
Rtr_151_1517 tree_151 tree_1517 0.8192
Cp_1517 tree_1517 0 2.592e-15
Rtr_151_1518 tree_151 tree_1518 0.8192
Cp_1518 tree_1518 0 2.592e-15
Rtr_151_1519 tree_151 tree_1519 0.8192
Cp_1519 tree_1519 0 2.592e-15
Rtr_151_1520 tree_151 tree_1520 0.8192
Cp_1520 tree_1520 0 2.592e-15
Rtr_152_1521 tree_152 tree_1521 0.8192
Cp_1521 tree_1521 0 2.592e-15
Rtr_152_1522 tree_152 tree_1522 0.8192
Cp_1522 tree_1522 0 2.592e-15
Rtr_152_1523 tree_152 tree_1523 0.8192
Cp_1523 tree_1523 0 2.592e-15
Rtr_152_1524 tree_152 tree_1524 0.8192
Cp_1524 tree_1524 0 2.592e-15
Rtr_152_1525 tree_152 tree_1525 0.8192
Cp_1525 tree_1525 0 2.592e-15
Rtr_152_1526 tree_152 tree_1526 0.8192
Cp_1526 tree_1526 0 2.592e-15
Rtr_152_1527 tree_152 tree_1527 0.8192
Cp_1527 tree_1527 0 2.592e-15
Rtr_152_1528 tree_152 tree_1528 0.8192
Cp_1528 tree_1528 0 2.592e-15
Rtr_152_1529 tree_152 tree_1529 0.8192
Cp_1529 tree_1529 0 2.592e-15
Rtr_152_1530 tree_152 tree_1530 0.8192
Cp_1530 tree_1530 0 2.592e-15
Rtr_153_1531 tree_153 tree_1531 0.8192
Cp_1531 tree_1531 0 2.592e-15
Rtr_153_1532 tree_153 tree_1532 0.8192
Cp_1532 tree_1532 0 2.592e-15
Rtr_153_1533 tree_153 tree_1533 0.8192
Cp_1533 tree_1533 0 2.592e-15
Rtr_153_1534 tree_153 tree_1534 0.8192
Cp_1534 tree_1534 0 2.592e-15
Rtr_153_1535 tree_153 tree_1535 0.8192
Cp_1535 tree_1535 0 2.592e-15
Rtr_153_1536 tree_153 tree_1536 0.8192
Cp_1536 tree_1536 0 2.592e-15
Rtr_153_1537 tree_153 tree_1537 0.8192
Cp_1537 tree_1537 0 2.592e-15
Rtr_153_1538 tree_153 tree_1538 0.8192
Cp_1538 tree_1538 0 2.592e-15
Rtr_153_1539 tree_153 tree_1539 0.8192
Cp_1539 tree_1539 0 2.592e-15
Rtr_153_1540 tree_153 tree_1540 0.8192
Cp_1540 tree_1540 0 2.592e-15
Rtr_154_1541 tree_154 tree_1541 0.8192
Cp_1541 tree_1541 0 2.592e-15
Rtr_154_1542 tree_154 tree_1542 0.8192
Cp_1542 tree_1542 0 2.592e-15
Rtr_154_1543 tree_154 tree_1543 0.8192
Cp_1543 tree_1543 0 2.592e-15
Rtr_154_1544 tree_154 tree_1544 0.8192
Cp_1544 tree_1544 0 2.592e-15
Rtr_154_1545 tree_154 tree_1545 0.8192
Cp_1545 tree_1545 0 2.592e-15
Rtr_154_1546 tree_154 tree_1546 0.8192
Cp_1546 tree_1546 0 2.592e-15
Rtr_154_1547 tree_154 tree_1547 0.8192
Cp_1547 tree_1547 0 2.592e-15
Rtr_154_1548 tree_154 tree_1548 0.8192
Cp_1548 tree_1548 0 2.592e-15
Rtr_154_1549 tree_154 tree_1549 0.8192
Cp_1549 tree_1549 0 2.592e-15
Rtr_154_1550 tree_154 tree_1550 0.8192
Cp_1550 tree_1550 0 2.592e-15
Rtr_155_1551 tree_155 tree_1551 0.8192
Cp_1551 tree_1551 0 2.592e-15
Rtr_155_1552 tree_155 tree_1552 0.8192
Cp_1552 tree_1552 0 2.592e-15
Rtr_155_1553 tree_155 tree_1553 0.8192
Cp_1553 tree_1553 0 2.592e-15
Rtr_155_1554 tree_155 tree_1554 0.8192
Cp_1554 tree_1554 0 2.592e-15
Rtr_155_1555 tree_155 tree_1555 0.8192
Cp_1555 tree_1555 0 2.592e-15
Rtr_155_1556 tree_155 tree_1556 0.8192
Cp_1556 tree_1556 0 2.592e-15
Rtr_155_1557 tree_155 tree_1557 0.8192
Cp_1557 tree_1557 0 2.592e-15
Rtr_155_1558 tree_155 tree_1558 0.8192
Cp_1558 tree_1558 0 2.592e-15
Rtr_155_1559 tree_155 tree_1559 0.8192
Cp_1559 tree_1559 0 2.592e-15
Rtr_155_1560 tree_155 tree_1560 0.8192
Cp_1560 tree_1560 0 2.592e-15
Rtr_156_1561 tree_156 tree_1561 0.8192
Cp_1561 tree_1561 0 2.592e-15
Rtr_156_1562 tree_156 tree_1562 0.8192
Cp_1562 tree_1562 0 2.592e-15
Rtr_156_1563 tree_156 tree_1563 0.8192
Cp_1563 tree_1563 0 2.592e-15
Rtr_156_1564 tree_156 tree_1564 0.8192
Cp_1564 tree_1564 0 2.592e-15
Rtr_156_1565 tree_156 tree_1565 0.8192
Cp_1565 tree_1565 0 2.592e-15
Rtr_156_1566 tree_156 tree_1566 0.8192
Cp_1566 tree_1566 0 2.592e-15
Rtr_156_1567 tree_156 tree_1567 0.8192
Cp_1567 tree_1567 0 2.592e-15
Rtr_156_1568 tree_156 tree_1568 0.8192
Cp_1568 tree_1568 0 2.592e-15
Rtr_156_1569 tree_156 tree_1569 0.8192
Cp_1569 tree_1569 0 2.592e-15
Rtr_156_1570 tree_156 tree_1570 0.8192
Cp_1570 tree_1570 0 2.592e-15
Rtr_157_1571 tree_157 tree_1571 0.8192
Cp_1571 tree_1571 0 2.592e-15
Rtr_157_1572 tree_157 tree_1572 0.8192
Cp_1572 tree_1572 0 2.592e-15
Rtr_157_1573 tree_157 tree_1573 0.8192
Cp_1573 tree_1573 0 2.592e-15
Rtr_157_1574 tree_157 tree_1574 0.8192
Cp_1574 tree_1574 0 2.592e-15
Rtr_157_1575 tree_157 tree_1575 0.8192
Cp_1575 tree_1575 0 2.592e-15
Rtr_157_1576 tree_157 tree_1576 0.8192
Cp_1576 tree_1576 0 2.592e-15
Rtr_157_1577 tree_157 tree_1577 0.8192
Cp_1577 tree_1577 0 2.592e-15
Rtr_157_1578 tree_157 tree_1578 0.8192
Cp_1578 tree_1578 0 2.592e-15
Rtr_157_1579 tree_157 tree_1579 0.8192
Cp_1579 tree_1579 0 2.592e-15
Rtr_157_1580 tree_157 tree_1580 0.8192
Cp_1580 tree_1580 0 2.592e-15
Rtr_158_1581 tree_158 tree_1581 0.8192
Cp_1581 tree_1581 0 2.592e-15
Rtr_158_1582 tree_158 tree_1582 0.8192
Cp_1582 tree_1582 0 2.592e-15
Rtr_158_1583 tree_158 tree_1583 0.8192
Cp_1583 tree_1583 0 2.592e-15
Rtr_158_1584 tree_158 tree_1584 0.8192
Cp_1584 tree_1584 0 2.592e-15
Rtr_158_1585 tree_158 tree_1585 0.8192
Cp_1585 tree_1585 0 2.592e-15
Rtr_158_1586 tree_158 tree_1586 0.8192
Cp_1586 tree_1586 0 2.592e-15
Rtr_158_1587 tree_158 tree_1587 0.8192
Cp_1587 tree_1587 0 2.592e-15
Rtr_158_1588 tree_158 tree_1588 0.8192
Cp_1588 tree_1588 0 2.592e-15
Rtr_158_1589 tree_158 tree_1589 0.8192
Cp_1589 tree_1589 0 2.592e-15
Rtr_158_1590 tree_158 tree_1590 0.8192
Cp_1590 tree_1590 0 2.592e-15
Rtr_159_1591 tree_159 tree_1591 0.8192
Cp_1591 tree_1591 0 2.592e-15
Rtr_159_1592 tree_159 tree_1592 0.8192
Cp_1592 tree_1592 0 2.592e-15
Rtr_159_1593 tree_159 tree_1593 0.8192
Cp_1593 tree_1593 0 2.592e-15
Rtr_159_1594 tree_159 tree_1594 0.8192
Cp_1594 tree_1594 0 2.592e-15
Rtr_159_1595 tree_159 tree_1595 0.8192
Cp_1595 tree_1595 0 2.592e-15
Rtr_159_1596 tree_159 tree_1596 0.8192
Cp_1596 tree_1596 0 2.592e-15
Rtr_159_1597 tree_159 tree_1597 0.8192
Cp_1597 tree_1597 0 2.592e-15
Rtr_159_1598 tree_159 tree_1598 0.8192
Cp_1598 tree_1598 0 2.592e-15
Rtr_159_1599 tree_159 tree_1599 0.8192
Cp_1599 tree_1599 0 2.592e-15
Rtr_159_1600 tree_159 tree_1600 0.8192
Cp_1600 tree_1600 0 2.592e-15
Rtr_160_1601 tree_160 tree_1601 0.8192
Cp_1601 tree_1601 0 2.592e-15
Rtr_160_1602 tree_160 tree_1602 0.8192
Cp_1602 tree_1602 0 2.592e-15
Rtr_160_1603 tree_160 tree_1603 0.8192
Cp_1603 tree_1603 0 2.592e-15
Rtr_160_1604 tree_160 tree_1604 0.8192
Cp_1604 tree_1604 0 2.592e-15
Rtr_160_1605 tree_160 tree_1605 0.8192
Cp_1605 tree_1605 0 2.592e-15
Rtr_160_1606 tree_160 tree_1606 0.8192
Cp_1606 tree_1606 0 2.592e-15
Rtr_160_1607 tree_160 tree_1607 0.8192
Cp_1607 tree_1607 0 2.592e-15
Rtr_160_1608 tree_160 tree_1608 0.8192
Cp_1608 tree_1608 0 2.592e-15
Rtr_160_1609 tree_160 tree_1609 0.8192
Cp_1609 tree_1609 0 2.592e-15
Rtr_160_1610 tree_160 tree_1610 0.8192
Cp_1610 tree_1610 0 2.592e-15
Rtr_161_1611 tree_161 tree_1611 0.8192
Cp_1611 tree_1611 0 2.592e-15
Rtr_161_1612 tree_161 tree_1612 0.8192
Cp_1612 tree_1612 0 2.592e-15
Rtr_161_1613 tree_161 tree_1613 0.8192
Cp_1613 tree_1613 0 2.592e-15
Rtr_161_1614 tree_161 tree_1614 0.8192
Cp_1614 tree_1614 0 2.592e-15
Rtr_161_1615 tree_161 tree_1615 0.8192
Cp_1615 tree_1615 0 2.592e-15
Rtr_161_1616 tree_161 tree_1616 0.8192
Cp_1616 tree_1616 0 2.592e-15
Rtr_161_1617 tree_161 tree_1617 0.8192
Cp_1617 tree_1617 0 2.592e-15
Rtr_161_1618 tree_161 tree_1618 0.8192
Cp_1618 tree_1618 0 2.592e-15
Rtr_161_1619 tree_161 tree_1619 0.8192
Cp_1619 tree_1619 0 2.592e-15
Rtr_161_1620 tree_161 tree_1620 0.8192
Cp_1620 tree_1620 0 2.592e-15
Rtr_162_1621 tree_162 tree_1621 0.8192
Cp_1621 tree_1621 0 2.592e-15
Rtr_162_1622 tree_162 tree_1622 0.8192
Cp_1622 tree_1622 0 2.592e-15
Rtr_162_1623 tree_162 tree_1623 0.8192
Cp_1623 tree_1623 0 2.592e-15
Rtr_162_1624 tree_162 tree_1624 0.8192
Cp_1624 tree_1624 0 2.592e-15
Rtr_162_1625 tree_162 tree_1625 0.8192
Cp_1625 tree_1625 0 2.592e-15
Rtr_162_1626 tree_162 tree_1626 0.8192
Cp_1626 tree_1626 0 2.592e-15
Rtr_162_1627 tree_162 tree_1627 0.8192
Cp_1627 tree_1627 0 2.592e-15
Rtr_162_1628 tree_162 tree_1628 0.8192
Cp_1628 tree_1628 0 2.592e-15
Rtr_162_1629 tree_162 tree_1629 0.8192
Cp_1629 tree_1629 0 2.592e-15
Rtr_162_1630 tree_162 tree_1630 0.8192
Cp_1630 tree_1630 0 2.592e-15
Rtr_163_1631 tree_163 tree_1631 0.8192
Cp_1631 tree_1631 0 2.592e-15
Rtr_163_1632 tree_163 tree_1632 0.8192
Cp_1632 tree_1632 0 2.592e-15
Rtr_163_1633 tree_163 tree_1633 0.8192
Cp_1633 tree_1633 0 2.592e-15
Rtr_163_1634 tree_163 tree_1634 0.8192
Cp_1634 tree_1634 0 2.592e-15
Rtr_163_1635 tree_163 tree_1635 0.8192
Cp_1635 tree_1635 0 2.592e-15
Rtr_163_1636 tree_163 tree_1636 0.8192
Cp_1636 tree_1636 0 2.592e-15
Rtr_163_1637 tree_163 tree_1637 0.8192
Cp_1637 tree_1637 0 2.592e-15
Rtr_163_1638 tree_163 tree_1638 0.8192
Cp_1638 tree_1638 0 2.592e-15
Rtr_163_1639 tree_163 tree_1639 0.8192
Cp_1639 tree_1639 0 2.592e-15
Rtr_163_1640 tree_163 tree_1640 0.8192
Cp_1640 tree_1640 0 2.592e-15
Rtr_164_1641 tree_164 tree_1641 0.8192
Cp_1641 tree_1641 0 2.592e-15
Rtr_164_1642 tree_164 tree_1642 0.8192
Cp_1642 tree_1642 0 2.592e-15
Rtr_164_1643 tree_164 tree_1643 0.8192
Cp_1643 tree_1643 0 2.592e-15
Rtr_164_1644 tree_164 tree_1644 0.8192
Cp_1644 tree_1644 0 2.592e-15
Rtr_164_1645 tree_164 tree_1645 0.8192
Cp_1645 tree_1645 0 2.592e-15
Rtr_164_1646 tree_164 tree_1646 0.8192
Cp_1646 tree_1646 0 2.592e-15
Rtr_164_1647 tree_164 tree_1647 0.8192
Cp_1647 tree_1647 0 2.592e-15
Rtr_164_1648 tree_164 tree_1648 0.8192
Cp_1648 tree_1648 0 2.592e-15
Rtr_164_1649 tree_164 tree_1649 0.8192
Cp_1649 tree_1649 0 2.592e-15
Rtr_164_1650 tree_164 tree_1650 0.8192
Cp_1650 tree_1650 0 2.592e-15
Rtr_165_1651 tree_165 tree_1651 0.8192
Cp_1651 tree_1651 0 2.592e-15
Rtr_165_1652 tree_165 tree_1652 0.8192
Cp_1652 tree_1652 0 2.592e-15
Rtr_165_1653 tree_165 tree_1653 0.8192
Cp_1653 tree_1653 0 2.592e-15
Rtr_165_1654 tree_165 tree_1654 0.8192
Cp_1654 tree_1654 0 2.592e-15
Rtr_165_1655 tree_165 tree_1655 0.8192
Cp_1655 tree_1655 0 2.592e-15
Rtr_165_1656 tree_165 tree_1656 0.8192
Cp_1656 tree_1656 0 2.592e-15
Rtr_165_1657 tree_165 tree_1657 0.8192
Cp_1657 tree_1657 0 2.592e-15
Rtr_165_1658 tree_165 tree_1658 0.8192
Cp_1658 tree_1658 0 2.592e-15
Rtr_165_1659 tree_165 tree_1659 0.8192
Cp_1659 tree_1659 0 2.592e-15
Rtr_165_1660 tree_165 tree_1660 0.8192
Cp_1660 tree_1660 0 2.592e-15
Rtr_166_1661 tree_166 tree_1661 0.8192
Cp_1661 tree_1661 0 2.592e-15
Rtr_166_1662 tree_166 tree_1662 0.8192
Cp_1662 tree_1662 0 2.592e-15
Rtr_166_1663 tree_166 tree_1663 0.8192
Cp_1663 tree_1663 0 2.592e-15
Rtr_166_1664 tree_166 tree_1664 0.8192
Cp_1664 tree_1664 0 2.592e-15
Rtr_166_1665 tree_166 tree_1665 0.8192
Cp_1665 tree_1665 0 2.592e-15
Rtr_166_1666 tree_166 tree_1666 0.8192
Cp_1666 tree_1666 0 2.592e-15
Rtr_166_1667 tree_166 tree_1667 0.8192
Cp_1667 tree_1667 0 2.592e-15
Rtr_166_1668 tree_166 tree_1668 0.8192
Cp_1668 tree_1668 0 2.592e-15
Rtr_166_1669 tree_166 tree_1669 0.8192
Cp_1669 tree_1669 0 2.592e-15
Rtr_166_1670 tree_166 tree_1670 0.8192
Cp_1670 tree_1670 0 2.592e-15
Rtr_167_1671 tree_167 tree_1671 0.8192
Cp_1671 tree_1671 0 2.592e-15
Rtr_167_1672 tree_167 tree_1672 0.8192
Cp_1672 tree_1672 0 2.592e-15
Rtr_167_1673 tree_167 tree_1673 0.8192
Cp_1673 tree_1673 0 2.592e-15
Rtr_167_1674 tree_167 tree_1674 0.8192
Cp_1674 tree_1674 0 2.592e-15
Rtr_167_1675 tree_167 tree_1675 0.8192
Cp_1675 tree_1675 0 2.592e-15
Rtr_167_1676 tree_167 tree_1676 0.8192
Cp_1676 tree_1676 0 2.592e-15
Rtr_167_1677 tree_167 tree_1677 0.8192
Cp_1677 tree_1677 0 2.592e-15
Rtr_167_1678 tree_167 tree_1678 0.8192
Cp_1678 tree_1678 0 2.592e-15
Rtr_167_1679 tree_167 tree_1679 0.8192
Cp_1679 tree_1679 0 2.592e-15
Rtr_167_1680 tree_167 tree_1680 0.8192
Cp_1680 tree_1680 0 2.592e-15
Rtr_168_1681 tree_168 tree_1681 0.8192
Cp_1681 tree_1681 0 2.592e-15
Rtr_168_1682 tree_168 tree_1682 0.8192
Cp_1682 tree_1682 0 2.592e-15
Rtr_168_1683 tree_168 tree_1683 0.8192
Cp_1683 tree_1683 0 2.592e-15
Rtr_168_1684 tree_168 tree_1684 0.8192
Cp_1684 tree_1684 0 2.592e-15
Rtr_168_1685 tree_168 tree_1685 0.8192
Cp_1685 tree_1685 0 2.592e-15
Rtr_168_1686 tree_168 tree_1686 0.8192
Cp_1686 tree_1686 0 2.592e-15
Rtr_168_1687 tree_168 tree_1687 0.8192
Cp_1687 tree_1687 0 2.592e-15
Rtr_168_1688 tree_168 tree_1688 0.8192
Cp_1688 tree_1688 0 2.592e-15
Rtr_168_1689 tree_168 tree_1689 0.8192
Cp_1689 tree_1689 0 2.592e-15
Rtr_168_1690 tree_168 tree_1690 0.8192
Cp_1690 tree_1690 0 2.592e-15
Rtr_169_1691 tree_169 tree_1691 0.8192
Cp_1691 tree_1691 0 2.592e-15
Rtr_169_1692 tree_169 tree_1692 0.8192
Cp_1692 tree_1692 0 2.592e-15
Rtr_169_1693 tree_169 tree_1693 0.8192
Cp_1693 tree_1693 0 2.592e-15
Rtr_169_1694 tree_169 tree_1694 0.8192
Cp_1694 tree_1694 0 2.592e-15
Rtr_169_1695 tree_169 tree_1695 0.8192
Cp_1695 tree_1695 0 2.592e-15
Rtr_169_1696 tree_169 tree_1696 0.8192
Cp_1696 tree_1696 0 2.592e-15
Rtr_169_1697 tree_169 tree_1697 0.8192
Cp_1697 tree_1697 0 2.592e-15
Rtr_169_1698 tree_169 tree_1698 0.8192
Cp_1698 tree_1698 0 2.592e-15
Rtr_169_1699 tree_169 tree_1699 0.8192
Cp_1699 tree_1699 0 2.592e-15
Rtr_169_1700 tree_169 tree_1700 0.8192
Cp_1700 tree_1700 0 2.592e-15
Rtr_170_1701 tree_170 tree_1701 0.8192
Cp_1701 tree_1701 0 2.592e-15
Rtr_170_1702 tree_170 tree_1702 0.8192
Cp_1702 tree_1702 0 2.592e-15
Rtr_170_1703 tree_170 tree_1703 0.8192
Cp_1703 tree_1703 0 2.592e-15
Rtr_170_1704 tree_170 tree_1704 0.8192
Cp_1704 tree_1704 0 2.592e-15
Rtr_170_1705 tree_170 tree_1705 0.8192
Cp_1705 tree_1705 0 2.592e-15
Rtr_170_1706 tree_170 tree_1706 0.8192
Cp_1706 tree_1706 0 2.592e-15
Rtr_170_1707 tree_170 tree_1707 0.8192
Cp_1707 tree_1707 0 2.592e-15
Rtr_170_1708 tree_170 tree_1708 0.8192
Cp_1708 tree_1708 0 2.592e-15
Rtr_170_1709 tree_170 tree_1709 0.8192
Cp_1709 tree_1709 0 2.592e-15
Rtr_170_1710 tree_170 tree_1710 0.8192
Cp_1710 tree_1710 0 2.592e-15
Rtr_171_1711 tree_171 tree_1711 0.8192
Cp_1711 tree_1711 0 2.592e-15
Rtr_171_1712 tree_171 tree_1712 0.8192
Cp_1712 tree_1712 0 2.592e-15
Rtr_171_1713 tree_171 tree_1713 0.8192
Cp_1713 tree_1713 0 2.592e-15
Rtr_171_1714 tree_171 tree_1714 0.8192
Cp_1714 tree_1714 0 2.592e-15
Rtr_171_1715 tree_171 tree_1715 0.8192
Cp_1715 tree_1715 0 2.592e-15
Rtr_171_1716 tree_171 tree_1716 0.8192
Cp_1716 tree_1716 0 2.592e-15
Rtr_171_1717 tree_171 tree_1717 0.8192
Cp_1717 tree_1717 0 2.592e-15
Rtr_171_1718 tree_171 tree_1718 0.8192
Cp_1718 tree_1718 0 2.592e-15
Rtr_171_1719 tree_171 tree_1719 0.8192
Cp_1719 tree_1719 0 2.592e-15
Rtr_171_1720 tree_171 tree_1720 0.8192
Cp_1720 tree_1720 0 2.592e-15
Rtr_172_1721 tree_172 tree_1721 0.8192
Cp_1721 tree_1721 0 2.592e-15
Rtr_172_1722 tree_172 tree_1722 0.8192
Cp_1722 tree_1722 0 2.592e-15
Rtr_172_1723 tree_172 tree_1723 0.8192
Cp_1723 tree_1723 0 2.592e-15
Rtr_172_1724 tree_172 tree_1724 0.8192
Cp_1724 tree_1724 0 2.592e-15
Rtr_172_1725 tree_172 tree_1725 0.8192
Cp_1725 tree_1725 0 2.592e-15
Rtr_172_1726 tree_172 tree_1726 0.8192
Cp_1726 tree_1726 0 2.592e-15
Rtr_172_1727 tree_172 tree_1727 0.8192
Cp_1727 tree_1727 0 2.592e-15
Rtr_172_1728 tree_172 tree_1728 0.8192
Cp_1728 tree_1728 0 2.592e-15
Rtr_172_1729 tree_172 tree_1729 0.8192
Cp_1729 tree_1729 0 2.592e-15
Rtr_172_1730 tree_172 tree_1730 0.8192
Cp_1730 tree_1730 0 2.592e-15
Rtr_173_1731 tree_173 tree_1731 0.8192
Cp_1731 tree_1731 0 2.592e-15
Rtr_173_1732 tree_173 tree_1732 0.8192
Cp_1732 tree_1732 0 2.592e-15
Rtr_173_1733 tree_173 tree_1733 0.8192
Cp_1733 tree_1733 0 2.592e-15
Rtr_173_1734 tree_173 tree_1734 0.8192
Cp_1734 tree_1734 0 2.592e-15
Rtr_173_1735 tree_173 tree_1735 0.8192
Cp_1735 tree_1735 0 2.592e-15
Rtr_173_1736 tree_173 tree_1736 0.8192
Cp_1736 tree_1736 0 2.592e-15
Rtr_173_1737 tree_173 tree_1737 0.8192
Cp_1737 tree_1737 0 2.592e-15
Rtr_173_1738 tree_173 tree_1738 0.8192
Cp_1738 tree_1738 0 2.592e-15
Rtr_173_1739 tree_173 tree_1739 0.8192
Cp_1739 tree_1739 0 2.592e-15
Rtr_173_1740 tree_173 tree_1740 0.8192
Cp_1740 tree_1740 0 2.592e-15
Rtr_174_1741 tree_174 tree_1741 0.8192
Cp_1741 tree_1741 0 2.592e-15
Rtr_174_1742 tree_174 tree_1742 0.8192
Cp_1742 tree_1742 0 2.592e-15
Rtr_174_1743 tree_174 tree_1743 0.8192
Cp_1743 tree_1743 0 2.592e-15
Rtr_174_1744 tree_174 tree_1744 0.8192
Cp_1744 tree_1744 0 2.592e-15
Rtr_174_1745 tree_174 tree_1745 0.8192
Cp_1745 tree_1745 0 2.592e-15
Rtr_174_1746 tree_174 tree_1746 0.8192
Cp_1746 tree_1746 0 2.592e-15
Rtr_174_1747 tree_174 tree_1747 0.8192
Cp_1747 tree_1747 0 2.592e-15
Rtr_174_1748 tree_174 tree_1748 0.8192
Cp_1748 tree_1748 0 2.592e-15
Rtr_174_1749 tree_174 tree_1749 0.8192
Cp_1749 tree_1749 0 2.592e-15
Rtr_174_1750 tree_174 tree_1750 0.8192
Cp_1750 tree_1750 0 2.592e-15
Rtr_175_1751 tree_175 tree_1751 0.8192
Cp_1751 tree_1751 0 2.592e-15
Rtr_175_1752 tree_175 tree_1752 0.8192
Cp_1752 tree_1752 0 2.592e-15
Rtr_175_1753 tree_175 tree_1753 0.8192
Cp_1753 tree_1753 0 2.592e-15
Rtr_175_1754 tree_175 tree_1754 0.8192
Cp_1754 tree_1754 0 2.592e-15
Rtr_175_1755 tree_175 tree_1755 0.8192
Cp_1755 tree_1755 0 2.592e-15
Rtr_175_1756 tree_175 tree_1756 0.8192
Cp_1756 tree_1756 0 2.592e-15
Rtr_175_1757 tree_175 tree_1757 0.8192
Cp_1757 tree_1757 0 2.592e-15
Rtr_175_1758 tree_175 tree_1758 0.8192
Cp_1758 tree_1758 0 2.592e-15
Rtr_175_1759 tree_175 tree_1759 0.8192
Cp_1759 tree_1759 0 2.592e-15
Rtr_175_1760 tree_175 tree_1760 0.8192
Cp_1760 tree_1760 0 2.592e-15
Rtr_176_1761 tree_176 tree_1761 0.8192
Cp_1761 tree_1761 0 2.592e-15
Rtr_176_1762 tree_176 tree_1762 0.8192
Cp_1762 tree_1762 0 2.592e-15
Rtr_176_1763 tree_176 tree_1763 0.8192
Cp_1763 tree_1763 0 2.592e-15
Rtr_176_1764 tree_176 tree_1764 0.8192
Cp_1764 tree_1764 0 2.592e-15
Rtr_176_1765 tree_176 tree_1765 0.8192
Cp_1765 tree_1765 0 2.592e-15
Rtr_176_1766 tree_176 tree_1766 0.8192
Cp_1766 tree_1766 0 2.592e-15
Rtr_176_1767 tree_176 tree_1767 0.8192
Cp_1767 tree_1767 0 2.592e-15
Rtr_176_1768 tree_176 tree_1768 0.8192
Cp_1768 tree_1768 0 2.592e-15
Rtr_176_1769 tree_176 tree_1769 0.8192
Cp_1769 tree_1769 0 2.592e-15
Rtr_176_1770 tree_176 tree_1770 0.8192
Cp_1770 tree_1770 0 2.592e-15
Rtr_177_1771 tree_177 tree_1771 0.8192
Cp_1771 tree_1771 0 2.592e-15
Rtr_177_1772 tree_177 tree_1772 0.8192
Cp_1772 tree_1772 0 2.592e-15
Rtr_177_1773 tree_177 tree_1773 0.8192
Cp_1773 tree_1773 0 2.592e-15
Rtr_177_1774 tree_177 tree_1774 0.8192
Cp_1774 tree_1774 0 2.592e-15
Rtr_177_1775 tree_177 tree_1775 0.8192
Cp_1775 tree_1775 0 2.592e-15
Rtr_177_1776 tree_177 tree_1776 0.8192
Cp_1776 tree_1776 0 2.592e-15
Rtr_177_1777 tree_177 tree_1777 0.8192
Cp_1777 tree_1777 0 2.592e-15
Rtr_177_1778 tree_177 tree_1778 0.8192
Cp_1778 tree_1778 0 2.592e-15
Rtr_177_1779 tree_177 tree_1779 0.8192
Cp_1779 tree_1779 0 2.592e-15
Rtr_177_1780 tree_177 tree_1780 0.8192
Cp_1780 tree_1780 0 2.592e-15
Rtr_178_1781 tree_178 tree_1781 0.8192
Cp_1781 tree_1781 0 2.592e-15
Rtr_178_1782 tree_178 tree_1782 0.8192
Cp_1782 tree_1782 0 2.592e-15
Rtr_178_1783 tree_178 tree_1783 0.8192
Cp_1783 tree_1783 0 2.592e-15
Rtr_178_1784 tree_178 tree_1784 0.8192
Cp_1784 tree_1784 0 2.592e-15
Rtr_178_1785 tree_178 tree_1785 0.8192
Cp_1785 tree_1785 0 2.592e-15
Rtr_178_1786 tree_178 tree_1786 0.8192
Cp_1786 tree_1786 0 2.592e-15
Rtr_178_1787 tree_178 tree_1787 0.8192
Cp_1787 tree_1787 0 2.592e-15
Rtr_178_1788 tree_178 tree_1788 0.8192
Cp_1788 tree_1788 0 2.592e-15
Rtr_178_1789 tree_178 tree_1789 0.8192
Cp_1789 tree_1789 0 2.592e-15
Rtr_178_1790 tree_178 tree_1790 0.8192
Cp_1790 tree_1790 0 2.592e-15
Rtr_179_1791 tree_179 tree_1791 0.8192
Cp_1791 tree_1791 0 2.592e-15
Rtr_179_1792 tree_179 tree_1792 0.8192
Cp_1792 tree_1792 0 2.592e-15
Rtr_179_1793 tree_179 tree_1793 0.8192
Cp_1793 tree_1793 0 2.592e-15
Rtr_179_1794 tree_179 tree_1794 0.8192
Cp_1794 tree_1794 0 2.592e-15
Rtr_179_1795 tree_179 tree_1795 0.8192
Cp_1795 tree_1795 0 2.592e-15
Rtr_179_1796 tree_179 tree_1796 0.8192
Cp_1796 tree_1796 0 2.592e-15
Rtr_179_1797 tree_179 tree_1797 0.8192
Cp_1797 tree_1797 0 2.592e-15
Rtr_179_1798 tree_179 tree_1798 0.8192
Cp_1798 tree_1798 0 2.592e-15
Rtr_179_1799 tree_179 tree_1799 0.8192
Cp_1799 tree_1799 0 2.592e-15
Rtr_179_1800 tree_179 tree_1800 0.8192
Cp_1800 tree_1800 0 2.592e-15
Rtr_180_1801 tree_180 tree_1801 0.8192
Cp_1801 tree_1801 0 2.592e-15
Rtr_180_1802 tree_180 tree_1802 0.8192
Cp_1802 tree_1802 0 2.592e-15
Rtr_180_1803 tree_180 tree_1803 0.8192
Cp_1803 tree_1803 0 2.592e-15
Rtr_180_1804 tree_180 tree_1804 0.8192
Cp_1804 tree_1804 0 2.592e-15
Rtr_180_1805 tree_180 tree_1805 0.8192
Cp_1805 tree_1805 0 2.592e-15
Rtr_180_1806 tree_180 tree_1806 0.8192
Cp_1806 tree_1806 0 2.592e-15
Rtr_180_1807 tree_180 tree_1807 0.8192
Cp_1807 tree_1807 0 2.592e-15
Rtr_180_1808 tree_180 tree_1808 0.8192
Cp_1808 tree_1808 0 2.592e-15
Rtr_180_1809 tree_180 tree_1809 0.8192
Cp_1809 tree_1809 0 2.592e-15
Rtr_180_1810 tree_180 tree_1810 0.8192
Cp_1810 tree_1810 0 2.592e-15
Rtr_181_1811 tree_181 tree_1811 0.8192
Cp_1811 tree_1811 0 2.592e-15
Rtr_181_1812 tree_181 tree_1812 0.8192
Cp_1812 tree_1812 0 2.592e-15
Rtr_181_1813 tree_181 tree_1813 0.8192
Cp_1813 tree_1813 0 2.592e-15
Rtr_181_1814 tree_181 tree_1814 0.8192
Cp_1814 tree_1814 0 2.592e-15
Rtr_181_1815 tree_181 tree_1815 0.8192
Cp_1815 tree_1815 0 2.592e-15
Rtr_181_1816 tree_181 tree_1816 0.8192
Cp_1816 tree_1816 0 2.592e-15
Rtr_181_1817 tree_181 tree_1817 0.8192
Cp_1817 tree_1817 0 2.592e-15
Rtr_181_1818 tree_181 tree_1818 0.8192
Cp_1818 tree_1818 0 2.592e-15
Rtr_181_1819 tree_181 tree_1819 0.8192
Cp_1819 tree_1819 0 2.592e-15
Rtr_181_1820 tree_181 tree_1820 0.8192
Cp_1820 tree_1820 0 2.592e-15
Rtr_182_1821 tree_182 tree_1821 0.8192
Cp_1821 tree_1821 0 2.592e-15
Rtr_182_1822 tree_182 tree_1822 0.8192
Cp_1822 tree_1822 0 2.592e-15
Rtr_182_1823 tree_182 tree_1823 0.8192
Cp_1823 tree_1823 0 2.592e-15
Rtr_182_1824 tree_182 tree_1824 0.8192
Cp_1824 tree_1824 0 2.592e-15
Rtr_182_1825 tree_182 tree_1825 0.8192
Cp_1825 tree_1825 0 2.592e-15
Rtr_182_1826 tree_182 tree_1826 0.8192
Cp_1826 tree_1826 0 2.592e-15
Rtr_182_1827 tree_182 tree_1827 0.8192
Cp_1827 tree_1827 0 2.592e-15
Rtr_182_1828 tree_182 tree_1828 0.8192
Cp_1828 tree_1828 0 2.592e-15
Rtr_182_1829 tree_182 tree_1829 0.8192
Cp_1829 tree_1829 0 2.592e-15
Rtr_182_1830 tree_182 tree_1830 0.8192
Cp_1830 tree_1830 0 2.592e-15
Rtr_183_1831 tree_183 tree_1831 0.8192
Cp_1831 tree_1831 0 2.592e-15
Rtr_183_1832 tree_183 tree_1832 0.8192
Cp_1832 tree_1832 0 2.592e-15
Rtr_183_1833 tree_183 tree_1833 0.8192
Cp_1833 tree_1833 0 2.592e-15
Rtr_183_1834 tree_183 tree_1834 0.8192
Cp_1834 tree_1834 0 2.592e-15
Rtr_183_1835 tree_183 tree_1835 0.8192
Cp_1835 tree_1835 0 2.592e-15
Rtr_183_1836 tree_183 tree_1836 0.8192
Cp_1836 tree_1836 0 2.592e-15
Rtr_183_1837 tree_183 tree_1837 0.8192
Cp_1837 tree_1837 0 2.592e-15
Rtr_183_1838 tree_183 tree_1838 0.8192
Cp_1838 tree_1838 0 2.592e-15
Rtr_183_1839 tree_183 tree_1839 0.8192
Cp_1839 tree_1839 0 2.592e-15
Rtr_183_1840 tree_183 tree_1840 0.8192
Cp_1840 tree_1840 0 2.592e-15
Rtr_184_1841 tree_184 tree_1841 0.8192
Cp_1841 tree_1841 0 2.592e-15
Rtr_184_1842 tree_184 tree_1842 0.8192
Cp_1842 tree_1842 0 2.592e-15
Rtr_184_1843 tree_184 tree_1843 0.8192
Cp_1843 tree_1843 0 2.592e-15
Rtr_184_1844 tree_184 tree_1844 0.8192
Cp_1844 tree_1844 0 2.592e-15
Rtr_184_1845 tree_184 tree_1845 0.8192
Cp_1845 tree_1845 0 2.592e-15
Rtr_184_1846 tree_184 tree_1846 0.8192
Cp_1846 tree_1846 0 2.592e-15
Rtr_184_1847 tree_184 tree_1847 0.8192
Cp_1847 tree_1847 0 2.592e-15
Rtr_184_1848 tree_184 tree_1848 0.8192
Cp_1848 tree_1848 0 2.592e-15
Rtr_184_1849 tree_184 tree_1849 0.8192
Cp_1849 tree_1849 0 2.592e-15
Rtr_184_1850 tree_184 tree_1850 0.8192
Cp_1850 tree_1850 0 2.592e-15
Rtr_185_1851 tree_185 tree_1851 0.8192
Cp_1851 tree_1851 0 2.592e-15
Rtr_185_1852 tree_185 tree_1852 0.8192
Cp_1852 tree_1852 0 2.592e-15
Rtr_185_1853 tree_185 tree_1853 0.8192
Cp_1853 tree_1853 0 2.592e-15
Rtr_185_1854 tree_185 tree_1854 0.8192
Cp_1854 tree_1854 0 2.592e-15
Rtr_185_1855 tree_185 tree_1855 0.8192
Cp_1855 tree_1855 0 2.592e-15
Rtr_185_1856 tree_185 tree_1856 0.8192
Cp_1856 tree_1856 0 2.592e-15
Rtr_185_1857 tree_185 tree_1857 0.8192
Cp_1857 tree_1857 0 2.592e-15
Rtr_185_1858 tree_185 tree_1858 0.8192
Cp_1858 tree_1858 0 2.592e-15
Rtr_185_1859 tree_185 tree_1859 0.8192
Cp_1859 tree_1859 0 2.592e-15
Rtr_185_1860 tree_185 tree_1860 0.8192
Cp_1860 tree_1860 0 2.592e-15
Rtr_186_1861 tree_186 tree_1861 0.8192
Cp_1861 tree_1861 0 2.592e-15
Rtr_186_1862 tree_186 tree_1862 0.8192
Cp_1862 tree_1862 0 2.592e-15
Rtr_186_1863 tree_186 tree_1863 0.8192
Cp_1863 tree_1863 0 2.592e-15
Rtr_186_1864 tree_186 tree_1864 0.8192
Cp_1864 tree_1864 0 2.592e-15
Rtr_186_1865 tree_186 tree_1865 0.8192
Cp_1865 tree_1865 0 2.592e-15
Rtr_186_1866 tree_186 tree_1866 0.8192
Cp_1866 tree_1866 0 2.592e-15
Rtr_186_1867 tree_186 tree_1867 0.8192
Cp_1867 tree_1867 0 2.592e-15
Rtr_186_1868 tree_186 tree_1868 0.8192
Cp_1868 tree_1868 0 2.592e-15
Rtr_186_1869 tree_186 tree_1869 0.8192
Cp_1869 tree_1869 0 2.592e-15
Rtr_186_1870 tree_186 tree_1870 0.8192
Cp_1870 tree_1870 0 2.592e-15
Rtr_187_1871 tree_187 tree_1871 0.8192
Cp_1871 tree_1871 0 2.592e-15
Rtr_187_1872 tree_187 tree_1872 0.8192
Cp_1872 tree_1872 0 2.592e-15
Rtr_187_1873 tree_187 tree_1873 0.8192
Cp_1873 tree_1873 0 2.592e-15
Rtr_187_1874 tree_187 tree_1874 0.8192
Cp_1874 tree_1874 0 2.592e-15
Rtr_187_1875 tree_187 tree_1875 0.8192
Cp_1875 tree_1875 0 2.592e-15
Rtr_187_1876 tree_187 tree_1876 0.8192
Cp_1876 tree_1876 0 2.592e-15
Rtr_187_1877 tree_187 tree_1877 0.8192
Cp_1877 tree_1877 0 2.592e-15
Rtr_187_1878 tree_187 tree_1878 0.8192
Cp_1878 tree_1878 0 2.592e-15
Rtr_187_1879 tree_187 tree_1879 0.8192
Cp_1879 tree_1879 0 2.592e-15
Rtr_187_1880 tree_187 tree_1880 0.8192
Cp_1880 tree_1880 0 2.592e-15
Rtr_188_1881 tree_188 tree_1881 0.8192
Cp_1881 tree_1881 0 2.592e-15
Rtr_188_1882 tree_188 tree_1882 0.8192
Cp_1882 tree_1882 0 2.592e-15
Rtr_188_1883 tree_188 tree_1883 0.8192
Cp_1883 tree_1883 0 2.592e-15
Rtr_188_1884 tree_188 tree_1884 0.8192
Cp_1884 tree_1884 0 2.592e-15
Rtr_188_1885 tree_188 tree_1885 0.8192
Cp_1885 tree_1885 0 2.592e-15
Rtr_188_1886 tree_188 tree_1886 0.8192
Cp_1886 tree_1886 0 2.592e-15
Rtr_188_1887 tree_188 tree_1887 0.8192
Cp_1887 tree_1887 0 2.592e-15
Rtr_188_1888 tree_188 tree_1888 0.8192
Cp_1888 tree_1888 0 2.592e-15
Rtr_188_1889 tree_188 tree_1889 0.8192
Cp_1889 tree_1889 0 2.592e-15
Rtr_188_1890 tree_188 tree_1890 0.8192
Cp_1890 tree_1890 0 2.592e-15
Rtr_189_1891 tree_189 tree_1891 0.8192
Cp_1891 tree_1891 0 2.592e-15
Rtr_189_1892 tree_189 tree_1892 0.8192
Cp_1892 tree_1892 0 2.592e-15
Rtr_189_1893 tree_189 tree_1893 0.8192
Cp_1893 tree_1893 0 2.592e-15
Rtr_189_1894 tree_189 tree_1894 0.8192
Cp_1894 tree_1894 0 2.592e-15
Rtr_189_1895 tree_189 tree_1895 0.8192
Cp_1895 tree_1895 0 2.592e-15
Rtr_189_1896 tree_189 tree_1896 0.8192
Cp_1896 tree_1896 0 2.592e-15
Rtr_189_1897 tree_189 tree_1897 0.8192
Cp_1897 tree_1897 0 2.592e-15
Rtr_189_1898 tree_189 tree_1898 0.8192
Cp_1898 tree_1898 0 2.592e-15
Rtr_189_1899 tree_189 tree_1899 0.8192
Cp_1899 tree_1899 0 2.592e-15
Rtr_189_1900 tree_189 tree_1900 0.8192
Cp_1900 tree_1900 0 2.592e-15
Rtr_190_1901 tree_190 tree_1901 0.8192
Cp_1901 tree_1901 0 2.592e-15
Rtr_190_1902 tree_190 tree_1902 0.8192
Cp_1902 tree_1902 0 2.592e-15
Rtr_190_1903 tree_190 tree_1903 0.8192
Cp_1903 tree_1903 0 2.592e-15
Rtr_190_1904 tree_190 tree_1904 0.8192
Cp_1904 tree_1904 0 2.592e-15
Rtr_190_1905 tree_190 tree_1905 0.8192
Cp_1905 tree_1905 0 2.592e-15
Rtr_190_1906 tree_190 tree_1906 0.8192
Cp_1906 tree_1906 0 2.592e-15
Rtr_190_1907 tree_190 tree_1907 0.8192
Cp_1907 tree_1907 0 2.592e-15
Rtr_190_1908 tree_190 tree_1908 0.8192
Cp_1908 tree_1908 0 2.592e-15
Rtr_190_1909 tree_190 tree_1909 0.8192
Cp_1909 tree_1909 0 2.592e-15
Rtr_190_1910 tree_190 tree_1910 0.8192
Cp_1910 tree_1910 0 2.592e-15
Rtr_191_1911 tree_191 tree_1911 0.8192
Cp_1911 tree_1911 0 2.592e-15
Rtr_191_1912 tree_191 tree_1912 0.8192
Cp_1912 tree_1912 0 2.592e-15
Rtr_191_1913 tree_191 tree_1913 0.8192
Cp_1913 tree_1913 0 2.592e-15
Rtr_191_1914 tree_191 tree_1914 0.8192
Cp_1914 tree_1914 0 2.592e-15
Rtr_191_1915 tree_191 tree_1915 0.8192
Cp_1915 tree_1915 0 2.592e-15
Rtr_191_1916 tree_191 tree_1916 0.8192
Cp_1916 tree_1916 0 2.592e-15
Rtr_191_1917 tree_191 tree_1917 0.8192
Cp_1917 tree_1917 0 2.592e-15
Rtr_191_1918 tree_191 tree_1918 0.8192
Cp_1918 tree_1918 0 2.592e-15
Rtr_191_1919 tree_191 tree_1919 0.8192
Cp_1919 tree_1919 0 2.592e-15
Rtr_191_1920 tree_191 tree_1920 0.8192
Cp_1920 tree_1920 0 2.592e-15
Rtr_192_1921 tree_192 tree_1921 0.8192
Cp_1921 tree_1921 0 2.592e-15
Rtr_192_1922 tree_192 tree_1922 0.8192
Cp_1922 tree_1922 0 2.592e-15
Rtr_192_1923 tree_192 tree_1923 0.8192
Cp_1923 tree_1923 0 2.592e-15
Rtr_192_1924 tree_192 tree_1924 0.8192
Cp_1924 tree_1924 0 2.592e-15
Rtr_192_1925 tree_192 tree_1925 0.8192
Cp_1925 tree_1925 0 2.592e-15
Rtr_192_1926 tree_192 tree_1926 0.8192
Cp_1926 tree_1926 0 2.592e-15
Rtr_192_1927 tree_192 tree_1927 0.8192
Cp_1927 tree_1927 0 2.592e-15
Rtr_192_1928 tree_192 tree_1928 0.8192
Cp_1928 tree_1928 0 2.592e-15
Rtr_192_1929 tree_192 tree_1929 0.8192
Cp_1929 tree_1929 0 2.592e-15
Rtr_192_1930 tree_192 tree_1930 0.8192
Cp_1930 tree_1930 0 2.592e-15
Rtr_193_1931 tree_193 tree_1931 0.8192
Cp_1931 tree_1931 0 2.592e-15
Rtr_193_1932 tree_193 tree_1932 0.8192
Cp_1932 tree_1932 0 2.592e-15
Rtr_193_1933 tree_193 tree_1933 0.8192
Cp_1933 tree_1933 0 2.592e-15
Rtr_193_1934 tree_193 tree_1934 0.8192
Cp_1934 tree_1934 0 2.592e-15
Rtr_193_1935 tree_193 tree_1935 0.8192
Cp_1935 tree_1935 0 2.592e-15
Rtr_193_1936 tree_193 tree_1936 0.8192
Cp_1936 tree_1936 0 2.592e-15
Rtr_193_1937 tree_193 tree_1937 0.8192
Cp_1937 tree_1937 0 2.592e-15
Rtr_193_1938 tree_193 tree_1938 0.8192
Cp_1938 tree_1938 0 2.592e-15
Rtr_193_1939 tree_193 tree_1939 0.8192
Cp_1939 tree_1939 0 2.592e-15
Rtr_193_1940 tree_193 tree_1940 0.8192
Cp_1940 tree_1940 0 2.592e-15
Rtr_194_1941 tree_194 tree_1941 0.8192
Cp_1941 tree_1941 0 2.592e-15
Rtr_194_1942 tree_194 tree_1942 0.8192
Cp_1942 tree_1942 0 2.592e-15
Rtr_194_1943 tree_194 tree_1943 0.8192
Cp_1943 tree_1943 0 2.592e-15
Rtr_194_1944 tree_194 tree_1944 0.8192
Cp_1944 tree_1944 0 2.592e-15
Rtr_194_1945 tree_194 tree_1945 0.8192
Cp_1945 tree_1945 0 2.592e-15
Rtr_194_1946 tree_194 tree_1946 0.8192
Cp_1946 tree_1946 0 2.592e-15
Rtr_194_1947 tree_194 tree_1947 0.8192
Cp_1947 tree_1947 0 2.592e-15
Rtr_194_1948 tree_194 tree_1948 0.8192
Cp_1948 tree_1948 0 2.592e-15
Rtr_194_1949 tree_194 tree_1949 0.8192
Cp_1949 tree_1949 0 2.592e-15
Rtr_194_1950 tree_194 tree_1950 0.8192
Cp_1950 tree_1950 0 2.592e-15
Rtr_195_1951 tree_195 tree_1951 0.8192
Cp_1951 tree_1951 0 2.592e-15
Rtr_195_1952 tree_195 tree_1952 0.8192
Cp_1952 tree_1952 0 2.592e-15
Rtr_195_1953 tree_195 tree_1953 0.8192
Cp_1953 tree_1953 0 2.592e-15
Rtr_195_1954 tree_195 tree_1954 0.8192
Cp_1954 tree_1954 0 2.592e-15
Rtr_195_1955 tree_195 tree_1955 0.8192
Cp_1955 tree_1955 0 2.592e-15
Rtr_195_1956 tree_195 tree_1956 0.8192
Cp_1956 tree_1956 0 2.592e-15
Rtr_195_1957 tree_195 tree_1957 0.8192
Cp_1957 tree_1957 0 2.592e-15
Rtr_195_1958 tree_195 tree_1958 0.8192
Cp_1958 tree_1958 0 2.592e-15
Rtr_195_1959 tree_195 tree_1959 0.8192
Cp_1959 tree_1959 0 2.592e-15
Rtr_195_1960 tree_195 tree_1960 0.8192
Cp_1960 tree_1960 0 2.592e-15
Rtr_196_1961 tree_196 tree_1961 0.8192
Cp_1961 tree_1961 0 2.592e-15
Rtr_196_1962 tree_196 tree_1962 0.8192
Cp_1962 tree_1962 0 2.592e-15
Rtr_196_1963 tree_196 tree_1963 0.8192
Cp_1963 tree_1963 0 2.592e-15
Rtr_196_1964 tree_196 tree_1964 0.8192
Cp_1964 tree_1964 0 2.592e-15
Rtr_196_1965 tree_196 tree_1965 0.8192
Cp_1965 tree_1965 0 2.592e-15
Rtr_196_1966 tree_196 tree_1966 0.8192
Cp_1966 tree_1966 0 2.592e-15
Rtr_196_1967 tree_196 tree_1967 0.8192
Cp_1967 tree_1967 0 2.592e-15
Rtr_196_1968 tree_196 tree_1968 0.8192
Cp_1968 tree_1968 0 2.592e-15
Rtr_196_1969 tree_196 tree_1969 0.8192
Cp_1969 tree_1969 0 2.592e-15
Rtr_196_1970 tree_196 tree_1970 0.8192
Cp_1970 tree_1970 0 2.592e-15
Rtr_197_1971 tree_197 tree_1971 0.8192
Cp_1971 tree_1971 0 2.592e-15
Rtr_197_1972 tree_197 tree_1972 0.8192
Cp_1972 tree_1972 0 2.592e-15
Rtr_197_1973 tree_197 tree_1973 0.8192
Cp_1973 tree_1973 0 2.592e-15
Rtr_197_1974 tree_197 tree_1974 0.8192
Cp_1974 tree_1974 0 2.592e-15
Rtr_197_1975 tree_197 tree_1975 0.8192
Cp_1975 tree_1975 0 2.592e-15
Rtr_197_1976 tree_197 tree_1976 0.8192
Cp_1976 tree_1976 0 2.592e-15
Rtr_197_1977 tree_197 tree_1977 0.8192
Cp_1977 tree_1977 0 2.592e-15
Rtr_197_1978 tree_197 tree_1978 0.8192
Cp_1978 tree_1978 0 2.592e-15
Rtr_197_1979 tree_197 tree_1979 0.8192
Cp_1979 tree_1979 0 2.592e-15
Rtr_197_1980 tree_197 tree_1980 0.8192
Cp_1980 tree_1980 0 2.592e-15
Rtr_198_1981 tree_198 tree_1981 0.8192
Cp_1981 tree_1981 0 2.592e-15
Rtr_198_1982 tree_198 tree_1982 0.8192
Cp_1982 tree_1982 0 2.592e-15
Rtr_198_1983 tree_198 tree_1983 0.8192
Cp_1983 tree_1983 0 2.592e-15
Rtr_198_1984 tree_198 tree_1984 0.8192
Cp_1984 tree_1984 0 2.592e-15
Rtr_198_1985 tree_198 tree_1985 0.8192
Cp_1985 tree_1985 0 2.592e-15
Rtr_198_1986 tree_198 tree_1986 0.8192
Cp_1986 tree_1986 0 2.592e-15
Rtr_198_1987 tree_198 tree_1987 0.8192
Cp_1987 tree_1987 0 2.592e-15
Rtr_198_1988 tree_198 tree_1988 0.8192
Cp_1988 tree_1988 0 2.592e-15
Rtr_198_1989 tree_198 tree_1989 0.8192
Cp_1989 tree_1989 0 2.592e-15
Rtr_198_1990 tree_198 tree_1990 0.8192
Cp_1990 tree_1990 0 2.592e-15
Rtr_199_1991 tree_199 tree_1991 0.8192
Cp_1991 tree_1991 0 2.592e-15
Rtr_199_1992 tree_199 tree_1992 0.8192
Cp_1992 tree_1992 0 2.592e-15
Rtr_199_1993 tree_199 tree_1993 0.8192
Cp_1993 tree_1993 0 2.592e-15
Rtr_199_1994 tree_199 tree_1994 0.8192
Cp_1994 tree_1994 0 2.592e-15
Rtr_199_1995 tree_199 tree_1995 0.8192
Cp_1995 tree_1995 0 2.592e-15
Rtr_199_1996 tree_199 tree_1996 0.8192
Cp_1996 tree_1996 0 2.592e-15
Rtr_199_1997 tree_199 tree_1997 0.8192
Cp_1997 tree_1997 0 2.592e-15
Rtr_199_1998 tree_199 tree_1998 0.8192
Cp_1998 tree_1998 0 2.592e-15
Rtr_199_1999 tree_199 tree_1999 0.8192
Cp_1999 tree_1999 0 2.592e-15
Rtr_199_2000 tree_199 tree_2000 0.8192
Cp_2000 tree_2000 0 2.592e-15
Rtr_200_2001 tree_200 tree_2001 0.8192
Cp_2001 tree_2001 0 2.592e-15
Rtr_200_2002 tree_200 tree_2002 0.8192
Cp_2002 tree_2002 0 2.592e-15
Rtr_200_2003 tree_200 tree_2003 0.8192
Cp_2003 tree_2003 0 2.592e-15
Rtr_200_2004 tree_200 tree_2004 0.8192
Cp_2004 tree_2004 0 2.592e-15
Rtr_200_2005 tree_200 tree_2005 0.8192
Cp_2005 tree_2005 0 2.592e-15
Rtr_200_2006 tree_200 tree_2006 0.8192
Cp_2006 tree_2006 0 2.592e-15
Rtr_200_2007 tree_200 tree_2007 0.8192
Cp_2007 tree_2007 0 2.592e-15
Rtr_200_2008 tree_200 tree_2008 0.8192
Cp_2008 tree_2008 0 2.592e-15
Rtr_200_2009 tree_200 tree_2009 0.8192
Cp_2009 tree_2009 0 2.592e-15
Rtr_200_2010 tree_200 tree_2010 0.8192
Cp_2010 tree_2010 0 2.592e-15
Rtr_201_2011 tree_201 tree_2011 0.8192
Cp_2011 tree_2011 0 2.592e-15
Rtr_201_2012 tree_201 tree_2012 0.8192
Cp_2012 tree_2012 0 2.592e-15
Rtr_201_2013 tree_201 tree_2013 0.8192
Cp_2013 tree_2013 0 2.592e-15
Rtr_201_2014 tree_201 tree_2014 0.8192
Cp_2014 tree_2014 0 2.592e-15
Rtr_201_2015 tree_201 tree_2015 0.8192
Cp_2015 tree_2015 0 2.592e-15
Rtr_201_2016 tree_201 tree_2016 0.8192
Cp_2016 tree_2016 0 2.592e-15
Rtr_201_2017 tree_201 tree_2017 0.8192
Cp_2017 tree_2017 0 2.592e-15
Rtr_201_2018 tree_201 tree_2018 0.8192
Cp_2018 tree_2018 0 2.592e-15
Rtr_201_2019 tree_201 tree_2019 0.8192
Cp_2019 tree_2019 0 2.592e-15
Rtr_201_2020 tree_201 tree_2020 0.8192
Cp_2020 tree_2020 0 2.592e-15
Rtr_202_2021 tree_202 tree_2021 0.8192
Cp_2021 tree_2021 0 2.592e-15
Rtr_202_2022 tree_202 tree_2022 0.8192
Cp_2022 tree_2022 0 2.592e-15
Rtr_202_2023 tree_202 tree_2023 0.8192
Cp_2023 tree_2023 0 2.592e-15
Rtr_202_2024 tree_202 tree_2024 0.8192
Cp_2024 tree_2024 0 2.592e-15
Rtr_202_2025 tree_202 tree_2025 0.8192
Cp_2025 tree_2025 0 2.592e-15
Rtr_202_2026 tree_202 tree_2026 0.8192
Cp_2026 tree_2026 0 2.592e-15
Rtr_202_2027 tree_202 tree_2027 0.8192
Cp_2027 tree_2027 0 2.592e-15
Rtr_202_2028 tree_202 tree_2028 0.8192
Cp_2028 tree_2028 0 2.592e-15
Rtr_202_2029 tree_202 tree_2029 0.8192
Cp_2029 tree_2029 0 2.592e-15
Rtr_202_2030 tree_202 tree_2030 0.8192
Cp_2030 tree_2030 0 2.592e-15
Rtr_203_2031 tree_203 tree_2031 0.8192
Cp_2031 tree_2031 0 2.592e-15
Rtr_203_2032 tree_203 tree_2032 0.8192
Cp_2032 tree_2032 0 2.592e-15
Rtr_203_2033 tree_203 tree_2033 0.8192
Cp_2033 tree_2033 0 2.592e-15
Rtr_203_2034 tree_203 tree_2034 0.8192
Cp_2034 tree_2034 0 2.592e-15
Rtr_203_2035 tree_203 tree_2035 0.8192
Cp_2035 tree_2035 0 2.592e-15
Rtr_203_2036 tree_203 tree_2036 0.8192
Cp_2036 tree_2036 0 2.592e-15
Rtr_203_2037 tree_203 tree_2037 0.8192
Cp_2037 tree_2037 0 2.592e-15
Rtr_203_2038 tree_203 tree_2038 0.8192
Cp_2038 tree_2038 0 2.592e-15
Rtr_203_2039 tree_203 tree_2039 0.8192
Cp_2039 tree_2039 0 2.592e-15
Rtr_203_2040 tree_203 tree_2040 0.8192
Cp_2040 tree_2040 0 2.592e-15
Rtr_204_2041 tree_204 tree_2041 0.8192
Cp_2041 tree_2041 0 2.592e-15
Rtr_204_2042 tree_204 tree_2042 0.8192
Cp_2042 tree_2042 0 2.592e-15
Rtr_204_2043 tree_204 tree_2043 0.8192
Cp_2043 tree_2043 0 2.592e-15
Rtr_204_2044 tree_204 tree_2044 0.8192
Cp_2044 tree_2044 0 2.592e-15
Rtr_204_2045 tree_204 tree_2045 0.8192
Cp_2045 tree_2045 0 2.592e-15
Rtr_204_2046 tree_204 tree_2046 0.8192
Cp_2046 tree_2046 0 2.592e-15
Rtr_204_2047 tree_204 tree_2047 0.8192
Cp_2047 tree_2047 0 2.592e-15
Rtr_204_2048 tree_204 tree_2048 0.8192
Cp_2048 tree_2048 0 2.592e-15
Rtr_204_2049 tree_204 tree_2049 0.8192
Cp_2049 tree_2049 0 2.592e-15
Rtr_204_2050 tree_204 tree_2050 0.8192
Cp_2050 tree_2050 0 2.592e-15
Rtr_205_2051 tree_205 tree_2051 0.8192
Cp_2051 tree_2051 0 2.592e-15
Rtr_205_2052 tree_205 tree_2052 0.8192
Cp_2052 tree_2052 0 2.592e-15
Rtr_205_2053 tree_205 tree_2053 0.8192
Cp_2053 tree_2053 0 2.592e-15
Rtr_205_2054 tree_205 tree_2054 0.8192
Cp_2054 tree_2054 0 2.592e-15
Rtr_205_2055 tree_205 tree_2055 0.8192
Cp_2055 tree_2055 0 2.592e-15
Rtr_205_2056 tree_205 tree_2056 0.8192
Cp_2056 tree_2056 0 2.592e-15
Rtr_205_2057 tree_205 tree_2057 0.8192
Cp_2057 tree_2057 0 2.592e-15
Rtr_205_2058 tree_205 tree_2058 0.8192
Cp_2058 tree_2058 0 2.592e-15
Rtr_205_2059 tree_205 tree_2059 0.8192
Cp_2059 tree_2059 0 2.592e-15
Rtr_205_2060 tree_205 tree_2060 0.8192
Cp_2060 tree_2060 0 2.592e-15
Rtr_206_2061 tree_206 tree_2061 0.8192
Cp_2061 tree_2061 0 2.592e-15
Rtr_206_2062 tree_206 tree_2062 0.8192
Cp_2062 tree_2062 0 2.592e-15
Rtr_206_2063 tree_206 tree_2063 0.8192
Cp_2063 tree_2063 0 2.592e-15
Rtr_206_2064 tree_206 tree_2064 0.8192
Cp_2064 tree_2064 0 2.592e-15
Rtr_206_2065 tree_206 tree_2065 0.8192
Cp_2065 tree_2065 0 2.592e-15
Rtr_206_2066 tree_206 tree_2066 0.8192
Cp_2066 tree_2066 0 2.592e-15
Rtr_206_2067 tree_206 tree_2067 0.8192
Cp_2067 tree_2067 0 2.592e-15
Rtr_206_2068 tree_206 tree_2068 0.8192
Cp_2068 tree_2068 0 2.592e-15
Rtr_206_2069 tree_206 tree_2069 0.8192
Cp_2069 tree_2069 0 2.592e-15
Rtr_206_2070 tree_206 tree_2070 0.8192
Cp_2070 tree_2070 0 2.592e-15
Rtr_207_2071 tree_207 tree_2071 0.8192
Cp_2071 tree_2071 0 2.592e-15
Rtr_207_2072 tree_207 tree_2072 0.8192
Cp_2072 tree_2072 0 2.592e-15
Rtr_207_2073 tree_207 tree_2073 0.8192
Cp_2073 tree_2073 0 2.592e-15
Rtr_207_2074 tree_207 tree_2074 0.8192
Cp_2074 tree_2074 0 2.592e-15
Rtr_207_2075 tree_207 tree_2075 0.8192
Cp_2075 tree_2075 0 2.592e-15
Rtr_207_2076 tree_207 tree_2076 0.8192
Cp_2076 tree_2076 0 2.592e-15
Rtr_207_2077 tree_207 tree_2077 0.8192
Cp_2077 tree_2077 0 2.592e-15
Rtr_207_2078 tree_207 tree_2078 0.8192
Cp_2078 tree_2078 0 2.592e-15
Rtr_207_2079 tree_207 tree_2079 0.8192
Cp_2079 tree_2079 0 2.592e-15
Rtr_207_2080 tree_207 tree_2080 0.8192
Cp_2080 tree_2080 0 2.592e-15
Rtr_208_2081 tree_208 tree_2081 0.8192
Cp_2081 tree_2081 0 2.592e-15
Rtr_208_2082 tree_208 tree_2082 0.8192
Cp_2082 tree_2082 0 2.592e-15
Rtr_208_2083 tree_208 tree_2083 0.8192
Cp_2083 tree_2083 0 2.592e-15
Rtr_208_2084 tree_208 tree_2084 0.8192
Cp_2084 tree_2084 0 2.592e-15
Rtr_208_2085 tree_208 tree_2085 0.8192
Cp_2085 tree_2085 0 2.592e-15
Rtr_208_2086 tree_208 tree_2086 0.8192
Cp_2086 tree_2086 0 2.592e-15
Rtr_208_2087 tree_208 tree_2087 0.8192
Cp_2087 tree_2087 0 2.592e-15
Rtr_208_2088 tree_208 tree_2088 0.8192
Cp_2088 tree_2088 0 2.592e-15
Rtr_208_2089 tree_208 tree_2089 0.8192
Cp_2089 tree_2089 0 2.592e-15
Rtr_208_2090 tree_208 tree_2090 0.8192
Cp_2090 tree_2090 0 2.592e-15
Rtr_209_2091 tree_209 tree_2091 0.8192
Cp_2091 tree_2091 0 2.592e-15
Rtr_209_2092 tree_209 tree_2092 0.8192
Cp_2092 tree_2092 0 2.592e-15
Rtr_209_2093 tree_209 tree_2093 0.8192
Cp_2093 tree_2093 0 2.592e-15
Rtr_209_2094 tree_209 tree_2094 0.8192
Cp_2094 tree_2094 0 2.592e-15
Rtr_209_2095 tree_209 tree_2095 0.8192
Cp_2095 tree_2095 0 2.592e-15
Rtr_209_2096 tree_209 tree_2096 0.8192
Cp_2096 tree_2096 0 2.592e-15
Rtr_209_2097 tree_209 tree_2097 0.8192
Cp_2097 tree_2097 0 2.592e-15
Rtr_209_2098 tree_209 tree_2098 0.8192
Cp_2098 tree_2098 0 2.592e-15
Rtr_209_2099 tree_209 tree_2099 0.8192
Cp_2099 tree_2099 0 2.592e-15
Rtr_209_2100 tree_209 tree_2100 0.8192
Cp_2100 tree_2100 0 2.592e-15
Rtr_210_2101 tree_210 tree_2101 0.8192
Cp_2101 tree_2101 0 2.592e-15
Rtr_210_2102 tree_210 tree_2102 0.8192
Cp_2102 tree_2102 0 2.592e-15
Rtr_210_2103 tree_210 tree_2103 0.8192
Cp_2103 tree_2103 0 2.592e-15
Rtr_210_2104 tree_210 tree_2104 0.8192
Cp_2104 tree_2104 0 2.592e-15
Rtr_210_2105 tree_210 tree_2105 0.8192
Cp_2105 tree_2105 0 2.592e-15
Rtr_210_2106 tree_210 tree_2106 0.8192
Cp_2106 tree_2106 0 2.592e-15
Rtr_210_2107 tree_210 tree_2107 0.8192
Cp_2107 tree_2107 0 2.592e-15
Rtr_210_2108 tree_210 tree_2108 0.8192
Cp_2108 tree_2108 0 2.592e-15
Rtr_210_2109 tree_210 tree_2109 0.8192
Cp_2109 tree_2109 0 2.592e-15
Rtr_210_2110 tree_210 tree_2110 0.8192
Cp_2110 tree_2110 0 2.592e-15
Rtr_211_2111 tree_211 tree_2111 0.8192
Cp_2111 tree_2111 0 2.592e-15
Rtr_211_2112 tree_211 tree_2112 0.8192
Cp_2112 tree_2112 0 2.592e-15
Rtr_211_2113 tree_211 tree_2113 0.8192
Cp_2113 tree_2113 0 2.592e-15
Rtr_211_2114 tree_211 tree_2114 0.8192
Cp_2114 tree_2114 0 2.592e-15
Rtr_211_2115 tree_211 tree_2115 0.8192
Cp_2115 tree_2115 0 2.592e-15
Rtr_211_2116 tree_211 tree_2116 0.8192
Cp_2116 tree_2116 0 2.592e-15
Rtr_211_2117 tree_211 tree_2117 0.8192
Cp_2117 tree_2117 0 2.592e-15
Rtr_211_2118 tree_211 tree_2118 0.8192
Cp_2118 tree_2118 0 2.592e-15
Rtr_211_2119 tree_211 tree_2119 0.8192
Cp_2119 tree_2119 0 2.592e-15
Rtr_211_2120 tree_211 tree_2120 0.8192
Cp_2120 tree_2120 0 2.592e-15
Rtr_212_2121 tree_212 tree_2121 0.8192
Cp_2121 tree_2121 0 2.592e-15
Rtr_212_2122 tree_212 tree_2122 0.8192
Cp_2122 tree_2122 0 2.592e-15
Rtr_212_2123 tree_212 tree_2123 0.8192
Cp_2123 tree_2123 0 2.592e-15
Rtr_212_2124 tree_212 tree_2124 0.8192
Cp_2124 tree_2124 0 2.592e-15
Rtr_212_2125 tree_212 tree_2125 0.8192
Cp_2125 tree_2125 0 2.592e-15
Rtr_212_2126 tree_212 tree_2126 0.8192
Cp_2126 tree_2126 0 2.592e-15
Rtr_212_2127 tree_212 tree_2127 0.8192
Cp_2127 tree_2127 0 2.592e-15
Rtr_212_2128 tree_212 tree_2128 0.8192
Cp_2128 tree_2128 0 2.592e-15
Rtr_212_2129 tree_212 tree_2129 0.8192
Cp_2129 tree_2129 0 2.592e-15
Rtr_212_2130 tree_212 tree_2130 0.8192
Cp_2130 tree_2130 0 2.592e-15
Rtr_213_2131 tree_213 tree_2131 0.8192
Cp_2131 tree_2131 0 2.592e-15
Rtr_213_2132 tree_213 tree_2132 0.8192
Cp_2132 tree_2132 0 2.592e-15
Rtr_213_2133 tree_213 tree_2133 0.8192
Cp_2133 tree_2133 0 2.592e-15
Rtr_213_2134 tree_213 tree_2134 0.8192
Cp_2134 tree_2134 0 2.592e-15
Rtr_213_2135 tree_213 tree_2135 0.8192
Cp_2135 tree_2135 0 2.592e-15
Rtr_213_2136 tree_213 tree_2136 0.8192
Cp_2136 tree_2136 0 2.592e-15
Rtr_213_2137 tree_213 tree_2137 0.8192
Cp_2137 tree_2137 0 2.592e-15
Rtr_213_2138 tree_213 tree_2138 0.8192
Cp_2138 tree_2138 0 2.592e-15
Rtr_213_2139 tree_213 tree_2139 0.8192
Cp_2139 tree_2139 0 2.592e-15
Rtr_213_2140 tree_213 tree_2140 0.8192
Cp_2140 tree_2140 0 2.592e-15
Rtr_214_2141 tree_214 tree_2141 0.8192
Cp_2141 tree_2141 0 2.592e-15
Rtr_214_2142 tree_214 tree_2142 0.8192
Cp_2142 tree_2142 0 2.592e-15
Rtr_214_2143 tree_214 tree_2143 0.8192
Cp_2143 tree_2143 0 2.592e-15
Rtr_214_2144 tree_214 tree_2144 0.8192
Cp_2144 tree_2144 0 2.592e-15
Rtr_214_2145 tree_214 tree_2145 0.8192
Cp_2145 tree_2145 0 2.592e-15
Rtr_214_2146 tree_214 tree_2146 0.8192
Cp_2146 tree_2146 0 2.592e-15
Rtr_214_2147 tree_214 tree_2147 0.8192
Cp_2147 tree_2147 0 2.592e-15
Rtr_214_2148 tree_214 tree_2148 0.8192
Cp_2148 tree_2148 0 2.592e-15
Rtr_214_2149 tree_214 tree_2149 0.8192
Cp_2149 tree_2149 0 2.592e-15
Rtr_214_2150 tree_214 tree_2150 0.8192
Cp_2150 tree_2150 0 2.592e-15
Rtr_215_2151 tree_215 tree_2151 0.8192
Cp_2151 tree_2151 0 2.592e-15
Rtr_215_2152 tree_215 tree_2152 0.8192
Cp_2152 tree_2152 0 2.592e-15
Rtr_215_2153 tree_215 tree_2153 0.8192
Cp_2153 tree_2153 0 2.592e-15
Rtr_215_2154 tree_215 tree_2154 0.8192
Cp_2154 tree_2154 0 2.592e-15
Rtr_215_2155 tree_215 tree_2155 0.8192
Cp_2155 tree_2155 0 2.592e-15
Rtr_215_2156 tree_215 tree_2156 0.8192
Cp_2156 tree_2156 0 2.592e-15
Rtr_215_2157 tree_215 tree_2157 0.8192
Cp_2157 tree_2157 0 2.592e-15
Rtr_215_2158 tree_215 tree_2158 0.8192
Cp_2158 tree_2158 0 2.592e-15
Rtr_215_2159 tree_215 tree_2159 0.8192
Cp_2159 tree_2159 0 2.592e-15
Rtr_215_2160 tree_215 tree_2160 0.8192
Cp_2160 tree_2160 0 2.592e-15
Rtr_216_2161 tree_216 tree_2161 0.8192
Cp_2161 tree_2161 0 2.592e-15
Rtr_216_2162 tree_216 tree_2162 0.8192
Cp_2162 tree_2162 0 2.592e-15
Rtr_216_2163 tree_216 tree_2163 0.8192
Cp_2163 tree_2163 0 2.592e-15
Rtr_216_2164 tree_216 tree_2164 0.8192
Cp_2164 tree_2164 0 2.592e-15
Rtr_216_2165 tree_216 tree_2165 0.8192
Cp_2165 tree_2165 0 2.592e-15
Rtr_216_2166 tree_216 tree_2166 0.8192
Cp_2166 tree_2166 0 2.592e-15
Rtr_216_2167 tree_216 tree_2167 0.8192
Cp_2167 tree_2167 0 2.592e-15
Rtr_216_2168 tree_216 tree_2168 0.8192
Cp_2168 tree_2168 0 2.592e-15
Rtr_216_2169 tree_216 tree_2169 0.8192
Cp_2169 tree_2169 0 2.592e-15
Rtr_216_2170 tree_216 tree_2170 0.8192
Cp_2170 tree_2170 0 2.592e-15
Rtr_217_2171 tree_217 tree_2171 0.8192
Cp_2171 tree_2171 0 2.592e-15
Rtr_217_2172 tree_217 tree_2172 0.8192
Cp_2172 tree_2172 0 2.592e-15
Rtr_217_2173 tree_217 tree_2173 0.8192
Cp_2173 tree_2173 0 2.592e-15
Rtr_217_2174 tree_217 tree_2174 0.8192
Cp_2174 tree_2174 0 2.592e-15
Rtr_217_2175 tree_217 tree_2175 0.8192
Cp_2175 tree_2175 0 2.592e-15
Rtr_217_2176 tree_217 tree_2176 0.8192
Cp_2176 tree_2176 0 2.592e-15
Rtr_217_2177 tree_217 tree_2177 0.8192
Cp_2177 tree_2177 0 2.592e-15
Rtr_217_2178 tree_217 tree_2178 0.8192
Cp_2178 tree_2178 0 2.592e-15
Rtr_217_2179 tree_217 tree_2179 0.8192
Cp_2179 tree_2179 0 2.592e-15
Rtr_217_2180 tree_217 tree_2180 0.8192
Cp_2180 tree_2180 0 2.592e-15
Rtr_218_2181 tree_218 tree_2181 0.8192
Cp_2181 tree_2181 0 2.592e-15
Rtr_218_2182 tree_218 tree_2182 0.8192
Cp_2182 tree_2182 0 2.592e-15
Rtr_218_2183 tree_218 tree_2183 0.8192
Cp_2183 tree_2183 0 2.592e-15
Rtr_218_2184 tree_218 tree_2184 0.8192
Cp_2184 tree_2184 0 2.592e-15
Rtr_218_2185 tree_218 tree_2185 0.8192
Cp_2185 tree_2185 0 2.592e-15
Rtr_218_2186 tree_218 tree_2186 0.8192
Cp_2186 tree_2186 0 2.592e-15
Rtr_218_2187 tree_218 tree_2187 0.8192
Cp_2187 tree_2187 0 2.592e-15
Rtr_218_2188 tree_218 tree_2188 0.8192
Cp_2188 tree_2188 0 2.592e-15
Rtr_218_2189 tree_218 tree_2189 0.8192
Cp_2189 tree_2189 0 2.592e-15
Rtr_218_2190 tree_218 tree_2190 0.8192
Cp_2190 tree_2190 0 2.592e-15
Rtr_219_2191 tree_219 tree_2191 0.8192
Cp_2191 tree_2191 0 2.592e-15
Rtr_219_2192 tree_219 tree_2192 0.8192
Cp_2192 tree_2192 0 2.592e-15
Rtr_219_2193 tree_219 tree_2193 0.8192
Cp_2193 tree_2193 0 2.592e-15
Rtr_219_2194 tree_219 tree_2194 0.8192
Cp_2194 tree_2194 0 2.592e-15
Rtr_219_2195 tree_219 tree_2195 0.8192
Cp_2195 tree_2195 0 2.592e-15
Rtr_219_2196 tree_219 tree_2196 0.8192
Cp_2196 tree_2196 0 2.592e-15
Rtr_219_2197 tree_219 tree_2197 0.8192
Cp_2197 tree_2197 0 2.592e-15
Rtr_219_2198 tree_219 tree_2198 0.8192
Cp_2198 tree_2198 0 2.592e-15
Rtr_219_2199 tree_219 tree_2199 0.8192
Cp_2199 tree_2199 0 2.592e-15
Rtr_219_2200 tree_219 tree_2200 0.8192
Cp_2200 tree_2200 0 2.592e-15
Rtr_220_2201 tree_220 tree_2201 0.8192
Cp_2201 tree_2201 0 2.592e-15
Rtr_220_2202 tree_220 tree_2202 0.8192
Cp_2202 tree_2202 0 2.592e-15
Rtr_220_2203 tree_220 tree_2203 0.8192
Cp_2203 tree_2203 0 2.592e-15
Rtr_220_2204 tree_220 tree_2204 0.8192
Cp_2204 tree_2204 0 2.592e-15
Rtr_220_2205 tree_220 tree_2205 0.8192
Cp_2205 tree_2205 0 2.592e-15
Rtr_220_2206 tree_220 tree_2206 0.8192
Cp_2206 tree_2206 0 2.592e-15
Rtr_220_2207 tree_220 tree_2207 0.8192
Cp_2207 tree_2207 0 2.592e-15
Rtr_220_2208 tree_220 tree_2208 0.8192
Cp_2208 tree_2208 0 2.592e-15
Rtr_220_2209 tree_220 tree_2209 0.8192
Cp_2209 tree_2209 0 2.592e-15
Rtr_220_2210 tree_220 tree_2210 0.8192
Cp_2210 tree_2210 0 2.592e-15
Rtr_221_2211 tree_221 tree_2211 0.8192
Cp_2211 tree_2211 0 2.592e-15
Rtr_221_2212 tree_221 tree_2212 0.8192
Cp_2212 tree_2212 0 2.592e-15
Rtr_221_2213 tree_221 tree_2213 0.8192
Cp_2213 tree_2213 0 2.592e-15
Rtr_221_2214 tree_221 tree_2214 0.8192
Cp_2214 tree_2214 0 2.592e-15
Rtr_221_2215 tree_221 tree_2215 0.8192
Cp_2215 tree_2215 0 2.592e-15
Rtr_221_2216 tree_221 tree_2216 0.8192
Cp_2216 tree_2216 0 2.592e-15
Rtr_221_2217 tree_221 tree_2217 0.8192
Cp_2217 tree_2217 0 2.592e-15
Rtr_221_2218 tree_221 tree_2218 0.8192
Cp_2218 tree_2218 0 2.592e-15
Rtr_221_2219 tree_221 tree_2219 0.8192
Cp_2219 tree_2219 0 2.592e-15
Rtr_221_2220 tree_221 tree_2220 0.8192
Cp_2220 tree_2220 0 2.592e-15
Rtr_222_2221 tree_222 tree_2221 0.8192
Cp_2221 tree_2221 0 2.592e-15
Rtr_222_2222 tree_222 tree_2222 0.8192
Cp_2222 tree_2222 0 2.592e-15
Rtr_222_2223 tree_222 tree_2223 0.8192
Cp_2223 tree_2223 0 2.592e-15
Rtr_222_2224 tree_222 tree_2224 0.8192
Cp_2224 tree_2224 0 2.592e-15
Rtr_222_2225 tree_222 tree_2225 0.8192
Cp_2225 tree_2225 0 2.592e-15
Rtr_222_2226 tree_222 tree_2226 0.8192
Cp_2226 tree_2226 0 2.592e-15
Rtr_222_2227 tree_222 tree_2227 0.8192
Cp_2227 tree_2227 0 2.592e-15
Rtr_222_2228 tree_222 tree_2228 0.8192
Cp_2228 tree_2228 0 2.592e-15
Rtr_222_2229 tree_222 tree_2229 0.8192
Cp_2229 tree_2229 0 2.592e-15
Rtr_222_2230 tree_222 tree_2230 0.8192
Cp_2230 tree_2230 0 2.592e-15
Rtr_223_2231 tree_223 tree_2231 0.8192
Cp_2231 tree_2231 0 2.592e-15
Rtr_223_2232 tree_223 tree_2232 0.8192
Cp_2232 tree_2232 0 2.592e-15
Rtr_223_2233 tree_223 tree_2233 0.8192
Cp_2233 tree_2233 0 2.592e-15
Rtr_223_2234 tree_223 tree_2234 0.8192
Cp_2234 tree_2234 0 2.592e-15
Rtr_223_2235 tree_223 tree_2235 0.8192
Cp_2235 tree_2235 0 2.592e-15
Rtr_223_2236 tree_223 tree_2236 0.8192
Cp_2236 tree_2236 0 2.592e-15
Rtr_223_2237 tree_223 tree_2237 0.8192
Cp_2237 tree_2237 0 2.592e-15
Rtr_223_2238 tree_223 tree_2238 0.8192
Cp_2238 tree_2238 0 2.592e-15
Rtr_223_2239 tree_223 tree_2239 0.8192
Cp_2239 tree_2239 0 2.592e-15
Rtr_223_2240 tree_223 tree_2240 0.8192
Cp_2240 tree_2240 0 2.592e-15
Rtr_224_2241 tree_224 tree_2241 0.8192
Cp_2241 tree_2241 0 2.592e-15
Rtr_224_2242 tree_224 tree_2242 0.8192
Cp_2242 tree_2242 0 2.592e-15
Rtr_224_2243 tree_224 tree_2243 0.8192
Cp_2243 tree_2243 0 2.592e-15
Rtr_224_2244 tree_224 tree_2244 0.8192
Cp_2244 tree_2244 0 2.592e-15
Rtr_224_2245 tree_224 tree_2245 0.8192
Cp_2245 tree_2245 0 2.592e-15
Rtr_224_2246 tree_224 tree_2246 0.8192
Cp_2246 tree_2246 0 2.592e-15
Rtr_224_2247 tree_224 tree_2247 0.8192
Cp_2247 tree_2247 0 2.592e-15
Rtr_224_2248 tree_224 tree_2248 0.8192
Cp_2248 tree_2248 0 2.592e-15
Rtr_224_2249 tree_224 tree_2249 0.8192
Cp_2249 tree_2249 0 2.592e-15
Rtr_224_2250 tree_224 tree_2250 0.8192
Cp_2250 tree_2250 0 2.592e-15
Rtr_225_2251 tree_225 tree_2251 0.8192
Cp_2251 tree_2251 0 2.592e-15
Rtr_225_2252 tree_225 tree_2252 0.8192
Cp_2252 tree_2252 0 2.592e-15
Rtr_225_2253 tree_225 tree_2253 0.8192
Cp_2253 tree_2253 0 2.592e-15
Rtr_225_2254 tree_225 tree_2254 0.8192
Cp_2254 tree_2254 0 2.592e-15
Rtr_225_2255 tree_225 tree_2255 0.8192
Cp_2255 tree_2255 0 2.592e-15
Rtr_225_2256 tree_225 tree_2256 0.8192
Cp_2256 tree_2256 0 2.592e-15
Rtr_225_2257 tree_225 tree_2257 0.8192
Cp_2257 tree_2257 0 2.592e-15
Rtr_225_2258 tree_225 tree_2258 0.8192
Cp_2258 tree_2258 0 2.592e-15
Rtr_225_2259 tree_225 tree_2259 0.8192
Cp_2259 tree_2259 0 2.592e-15
Rtr_225_2260 tree_225 tree_2260 0.8192
Cp_2260 tree_2260 0 2.592e-15
Rtr_226_2261 tree_226 tree_2261 0.8192
Cp_2261 tree_2261 0 2.592e-15
Rtr_226_2262 tree_226 tree_2262 0.8192
Cp_2262 tree_2262 0 2.592e-15
Rtr_226_2263 tree_226 tree_2263 0.8192
Cp_2263 tree_2263 0 2.592e-15
Rtr_226_2264 tree_226 tree_2264 0.8192
Cp_2264 tree_2264 0 2.592e-15
Rtr_226_2265 tree_226 tree_2265 0.8192
Cp_2265 tree_2265 0 2.592e-15
Rtr_226_2266 tree_226 tree_2266 0.8192
Cp_2266 tree_2266 0 2.592e-15
Rtr_226_2267 tree_226 tree_2267 0.8192
Cp_2267 tree_2267 0 2.592e-15
Rtr_226_2268 tree_226 tree_2268 0.8192
Cp_2268 tree_2268 0 2.592e-15
Rtr_226_2269 tree_226 tree_2269 0.8192
Cp_2269 tree_2269 0 2.592e-15
Rtr_226_2270 tree_226 tree_2270 0.8192
Cp_2270 tree_2270 0 2.592e-15
Rtr_227_2271 tree_227 tree_2271 0.8192
Cp_2271 tree_2271 0 2.592e-15
Rtr_227_2272 tree_227 tree_2272 0.8192
Cp_2272 tree_2272 0 2.592e-15
Rtr_227_2273 tree_227 tree_2273 0.8192
Cp_2273 tree_2273 0 2.592e-15
Rtr_227_2274 tree_227 tree_2274 0.8192
Cp_2274 tree_2274 0 2.592e-15
Rtr_227_2275 tree_227 tree_2275 0.8192
Cp_2275 tree_2275 0 2.592e-15
Rtr_227_2276 tree_227 tree_2276 0.8192
Cp_2276 tree_2276 0 2.592e-15
Rtr_227_2277 tree_227 tree_2277 0.8192
Cp_2277 tree_2277 0 2.592e-15
Rtr_227_2278 tree_227 tree_2278 0.8192
Cp_2278 tree_2278 0 2.592e-15
Rtr_227_2279 tree_227 tree_2279 0.8192
Cp_2279 tree_2279 0 2.592e-15
Rtr_227_2280 tree_227 tree_2280 0.8192
Cp_2280 tree_2280 0 2.592e-15
Rtr_228_2281 tree_228 tree_2281 0.8192
Cp_2281 tree_2281 0 2.592e-15
Rtr_228_2282 tree_228 tree_2282 0.8192
Cp_2282 tree_2282 0 2.592e-15
Rtr_228_2283 tree_228 tree_2283 0.8192
Cp_2283 tree_2283 0 2.592e-15
Rtr_228_2284 tree_228 tree_2284 0.8192
Cp_2284 tree_2284 0 2.592e-15
Rtr_228_2285 tree_228 tree_2285 0.8192
Cp_2285 tree_2285 0 2.592e-15
Rtr_228_2286 tree_228 tree_2286 0.8192
Cp_2286 tree_2286 0 2.592e-15
Rtr_228_2287 tree_228 tree_2287 0.8192
Cp_2287 tree_2287 0 2.592e-15
Rtr_228_2288 tree_228 tree_2288 0.8192
Cp_2288 tree_2288 0 2.592e-15
Rtr_228_2289 tree_228 tree_2289 0.8192
Cp_2289 tree_2289 0 2.592e-15
Rtr_228_2290 tree_228 tree_2290 0.8192
Cp_2290 tree_2290 0 2.592e-15
Rtr_229_2291 tree_229 tree_2291 0.8192
Cp_2291 tree_2291 0 2.592e-15
Rtr_229_2292 tree_229 tree_2292 0.8192
Cp_2292 tree_2292 0 2.592e-15
Rtr_229_2293 tree_229 tree_2293 0.8192
Cp_2293 tree_2293 0 2.592e-15
Rtr_229_2294 tree_229 tree_2294 0.8192
Cp_2294 tree_2294 0 2.592e-15
Rtr_229_2295 tree_229 tree_2295 0.8192
Cp_2295 tree_2295 0 2.592e-15
Rtr_229_2296 tree_229 tree_2296 0.8192
Cp_2296 tree_2296 0 2.592e-15
Rtr_229_2297 tree_229 tree_2297 0.8192
Cp_2297 tree_2297 0 2.592e-15
Rtr_229_2298 tree_229 tree_2298 0.8192
Cp_2298 tree_2298 0 2.592e-15
Rtr_229_2299 tree_229 tree_2299 0.8192
Cp_2299 tree_2299 0 2.592e-15
Rtr_229_2300 tree_229 tree_2300 0.8192
Cp_2300 tree_2300 0 2.592e-15
Rtr_230_2301 tree_230 tree_2301 0.8192
Cp_2301 tree_2301 0 2.592e-15
Rtr_230_2302 tree_230 tree_2302 0.8192
Cp_2302 tree_2302 0 2.592e-15
Rtr_230_2303 tree_230 tree_2303 0.8192
Cp_2303 tree_2303 0 2.592e-15
Rtr_230_2304 tree_230 tree_2304 0.8192
Cp_2304 tree_2304 0 2.592e-15
Rtr_230_2305 tree_230 tree_2305 0.8192
Cp_2305 tree_2305 0 2.592e-15
Rtr_230_2306 tree_230 tree_2306 0.8192
Cp_2306 tree_2306 0 2.592e-15
Rtr_230_2307 tree_230 tree_2307 0.8192
Cp_2307 tree_2307 0 2.592e-15
Rtr_230_2308 tree_230 tree_2308 0.8192
Cp_2308 tree_2308 0 2.592e-15
Rtr_230_2309 tree_230 tree_2309 0.8192
Cp_2309 tree_2309 0 2.592e-15
Rtr_230_2310 tree_230 tree_2310 0.8192
Cp_2310 tree_2310 0 2.592e-15
Rtr_231_2311 tree_231 tree_2311 0.8192
Cp_2311 tree_2311 0 2.592e-15
Rtr_231_2312 tree_231 tree_2312 0.8192
Cp_2312 tree_2312 0 2.592e-15
Rtr_231_2313 tree_231 tree_2313 0.8192
Cp_2313 tree_2313 0 2.592e-15
Rtr_231_2314 tree_231 tree_2314 0.8192
Cp_2314 tree_2314 0 2.592e-15
Rtr_231_2315 tree_231 tree_2315 0.8192
Cp_2315 tree_2315 0 2.592e-15
Rtr_231_2316 tree_231 tree_2316 0.8192
Cp_2316 tree_2316 0 2.592e-15
Rtr_231_2317 tree_231 tree_2317 0.8192
Cp_2317 tree_2317 0 2.592e-15
Rtr_231_2318 tree_231 tree_2318 0.8192
Cp_2318 tree_2318 0 2.592e-15
Rtr_231_2319 tree_231 tree_2319 0.8192
Cp_2319 tree_2319 0 2.592e-15
Rtr_231_2320 tree_231 tree_2320 0.8192
Cp_2320 tree_2320 0 2.592e-15
Rtr_232_2321 tree_232 tree_2321 0.8192
Cp_2321 tree_2321 0 2.592e-15
Rtr_232_2322 tree_232 tree_2322 0.8192
Cp_2322 tree_2322 0 2.592e-15
Rtr_232_2323 tree_232 tree_2323 0.8192
Cp_2323 tree_2323 0 2.592e-15
Rtr_232_2324 tree_232 tree_2324 0.8192
Cp_2324 tree_2324 0 2.592e-15
Rtr_232_2325 tree_232 tree_2325 0.8192
Cp_2325 tree_2325 0 2.592e-15
Rtr_232_2326 tree_232 tree_2326 0.8192
Cp_2326 tree_2326 0 2.592e-15
Rtr_232_2327 tree_232 tree_2327 0.8192
Cp_2327 tree_2327 0 2.592e-15
Rtr_232_2328 tree_232 tree_2328 0.8192
Cp_2328 tree_2328 0 2.592e-15
Rtr_232_2329 tree_232 tree_2329 0.8192
Cp_2329 tree_2329 0 2.592e-15
Rtr_232_2330 tree_232 tree_2330 0.8192
Cp_2330 tree_2330 0 2.592e-15
Rtr_233_2331 tree_233 tree_2331 0.8192
Cp_2331 tree_2331 0 2.592e-15
Rtr_233_2332 tree_233 tree_2332 0.8192
Cp_2332 tree_2332 0 2.592e-15
Rtr_233_2333 tree_233 tree_2333 0.8192
Cp_2333 tree_2333 0 2.592e-15
Rtr_233_2334 tree_233 tree_2334 0.8192
Cp_2334 tree_2334 0 2.592e-15
Rtr_233_2335 tree_233 tree_2335 0.8192
Cp_2335 tree_2335 0 2.592e-15
Rtr_233_2336 tree_233 tree_2336 0.8192
Cp_2336 tree_2336 0 2.592e-15
Rtr_233_2337 tree_233 tree_2337 0.8192
Cp_2337 tree_2337 0 2.592e-15
Rtr_233_2338 tree_233 tree_2338 0.8192
Cp_2338 tree_2338 0 2.592e-15
Rtr_233_2339 tree_233 tree_2339 0.8192
Cp_2339 tree_2339 0 2.592e-15
Rtr_233_2340 tree_233 tree_2340 0.8192
Cp_2340 tree_2340 0 2.592e-15
Rtr_234_2341 tree_234 tree_2341 0.8192
Cp_2341 tree_2341 0 2.592e-15
Rtr_234_2342 tree_234 tree_2342 0.8192
Cp_2342 tree_2342 0 2.592e-15
Rtr_234_2343 tree_234 tree_2343 0.8192
Cp_2343 tree_2343 0 2.592e-15
Rtr_234_2344 tree_234 tree_2344 0.8192
Cp_2344 tree_2344 0 2.592e-15
Rtr_234_2345 tree_234 tree_2345 0.8192
Cp_2345 tree_2345 0 2.592e-15
Rtr_234_2346 tree_234 tree_2346 0.8192
Cp_2346 tree_2346 0 2.592e-15
Rtr_234_2347 tree_234 tree_2347 0.8192
Cp_2347 tree_2347 0 2.592e-15
Rtr_234_2348 tree_234 tree_2348 0.8192
Cp_2348 tree_2348 0 2.592e-15
Rtr_234_2349 tree_234 tree_2349 0.8192
Cp_2349 tree_2349 0 2.592e-15
Rtr_234_2350 tree_234 tree_2350 0.8192
Cp_2350 tree_2350 0 2.592e-15
Rtr_235_2351 tree_235 tree_2351 0.8192
Cp_2351 tree_2351 0 2.592e-15
Rtr_235_2352 tree_235 tree_2352 0.8192
Cp_2352 tree_2352 0 2.592e-15
Rtr_235_2353 tree_235 tree_2353 0.8192
Cp_2353 tree_2353 0 2.592e-15
Rtr_235_2354 tree_235 tree_2354 0.8192
Cp_2354 tree_2354 0 2.592e-15
Rtr_235_2355 tree_235 tree_2355 0.8192
Cp_2355 tree_2355 0 2.592e-15
Rtr_235_2356 tree_235 tree_2356 0.8192
Cp_2356 tree_2356 0 2.592e-15
Rtr_235_2357 tree_235 tree_2357 0.8192
Cp_2357 tree_2357 0 2.592e-15
Rtr_235_2358 tree_235 tree_2358 0.8192
Cp_2358 tree_2358 0 2.592e-15
Rtr_235_2359 tree_235 tree_2359 0.8192
Cp_2359 tree_2359 0 2.592e-15
Rtr_235_2360 tree_235 tree_2360 0.8192
Cp_2360 tree_2360 0 2.592e-15
Rtr_236_2361 tree_236 tree_2361 0.8192
Cp_2361 tree_2361 0 2.592e-15
Rtr_236_2362 tree_236 tree_2362 0.8192
Cp_2362 tree_2362 0 2.592e-15
Rtr_236_2363 tree_236 tree_2363 0.8192
Cp_2363 tree_2363 0 2.592e-15
Rtr_236_2364 tree_236 tree_2364 0.8192
Cp_2364 tree_2364 0 2.592e-15
Rtr_236_2365 tree_236 tree_2365 0.8192
Cp_2365 tree_2365 0 2.592e-15
Rtr_236_2366 tree_236 tree_2366 0.8192
Cp_2366 tree_2366 0 2.592e-15
Rtr_236_2367 tree_236 tree_2367 0.8192
Cp_2367 tree_2367 0 2.592e-15
Rtr_236_2368 tree_236 tree_2368 0.8192
Cp_2368 tree_2368 0 2.592e-15
Rtr_236_2369 tree_236 tree_2369 0.8192
Cp_2369 tree_2369 0 2.592e-15
Rtr_236_2370 tree_236 tree_2370 0.8192
Cp_2370 tree_2370 0 2.592e-15
Rtr_237_2371 tree_237 tree_2371 0.8192
Cp_2371 tree_2371 0 2.592e-15
Rtr_237_2372 tree_237 tree_2372 0.8192
Cp_2372 tree_2372 0 2.592e-15
Rtr_237_2373 tree_237 tree_2373 0.8192
Cp_2373 tree_2373 0 2.592e-15
Rtr_237_2374 tree_237 tree_2374 0.8192
Cp_2374 tree_2374 0 2.592e-15
Rtr_237_2375 tree_237 tree_2375 0.8192
Cp_2375 tree_2375 0 2.592e-15
Rtr_237_2376 tree_237 tree_2376 0.8192
Cp_2376 tree_2376 0 2.592e-15
Rtr_237_2377 tree_237 tree_2377 0.8192
Cp_2377 tree_2377 0 2.592e-15
Rtr_237_2378 tree_237 tree_2378 0.8192
Cp_2378 tree_2378 0 2.592e-15
Rtr_237_2379 tree_237 tree_2379 0.8192
Cp_2379 tree_2379 0 2.592e-15
Rtr_237_2380 tree_237 tree_2380 0.8192
Cp_2380 tree_2380 0 2.592e-15
Rtr_238_2381 tree_238 tree_2381 0.8192
Cp_2381 tree_2381 0 2.592e-15
Rtr_238_2382 tree_238 tree_2382 0.8192
Cp_2382 tree_2382 0 2.592e-15
Rtr_238_2383 tree_238 tree_2383 0.8192
Cp_2383 tree_2383 0 2.592e-15
Rtr_238_2384 tree_238 tree_2384 0.8192
Cp_2384 tree_2384 0 2.592e-15
Rtr_238_2385 tree_238 tree_2385 0.8192
Cp_2385 tree_2385 0 2.592e-15
Rtr_238_2386 tree_238 tree_2386 0.8192
Cp_2386 tree_2386 0 2.592e-15
Rtr_238_2387 tree_238 tree_2387 0.8192
Cp_2387 tree_2387 0 2.592e-15
Rtr_238_2388 tree_238 tree_2388 0.8192
Cp_2388 tree_2388 0 2.592e-15
Rtr_238_2389 tree_238 tree_2389 0.8192
Cp_2389 tree_2389 0 2.592e-15
Rtr_238_2390 tree_238 tree_2390 0.8192
Cp_2390 tree_2390 0 2.592e-15
Rtr_239_2391 tree_239 tree_2391 0.8192
Cp_2391 tree_2391 0 2.592e-15
Rtr_239_2392 tree_239 tree_2392 0.8192
Cp_2392 tree_2392 0 2.592e-15
Rtr_239_2393 tree_239 tree_2393 0.8192
Cp_2393 tree_2393 0 2.592e-15
Rtr_239_2394 tree_239 tree_2394 0.8192
Cp_2394 tree_2394 0 2.592e-15
Rtr_239_2395 tree_239 tree_2395 0.8192
Cp_2395 tree_2395 0 2.592e-15
Rtr_239_2396 tree_239 tree_2396 0.8192
Cp_2396 tree_2396 0 2.592e-15
Rtr_239_2397 tree_239 tree_2397 0.8192
Cp_2397 tree_2397 0 2.592e-15
Rtr_239_2398 tree_239 tree_2398 0.8192
Cp_2398 tree_2398 0 2.592e-15
Rtr_239_2399 tree_239 tree_2399 0.8192
Cp_2399 tree_2399 0 2.592e-15
Rtr_239_2400 tree_239 tree_2400 0.8192
Cp_2400 tree_2400 0 2.592e-15
Rtr_240_2401 tree_240 tree_2401 0.8192
Cp_2401 tree_2401 0 2.592e-15
Rtr_240_2402 tree_240 tree_2402 0.8192
Cp_2402 tree_2402 0 2.592e-15
Rtr_240_2403 tree_240 tree_2403 0.8192
Cp_2403 tree_2403 0 2.592e-15
Rtr_240_2404 tree_240 tree_2404 0.8192
Cp_2404 tree_2404 0 2.592e-15
Rtr_240_2405 tree_240 tree_2405 0.8192
Cp_2405 tree_2405 0 2.592e-15
Rtr_240_2406 tree_240 tree_2406 0.8192
Cp_2406 tree_2406 0 2.592e-15
Rtr_240_2407 tree_240 tree_2407 0.8192
Cp_2407 tree_2407 0 2.592e-15
Rtr_240_2408 tree_240 tree_2408 0.8192
Cp_2408 tree_2408 0 2.592e-15
Rtr_240_2409 tree_240 tree_2409 0.8192
Cp_2409 tree_2409 0 2.592e-15
Rtr_240_2410 tree_240 tree_2410 0.8192
Cp_2410 tree_2410 0 2.592e-15
Rtr_241_2411 tree_241 tree_2411 0.8192
Cp_2411 tree_2411 0 2.592e-15
Rtr_241_2412 tree_241 tree_2412 0.8192
Cp_2412 tree_2412 0 2.592e-15
Rtr_241_2413 tree_241 tree_2413 0.8192
Cp_2413 tree_2413 0 2.592e-15
Rtr_241_2414 tree_241 tree_2414 0.8192
Cp_2414 tree_2414 0 2.592e-15
Rtr_241_2415 tree_241 tree_2415 0.8192
Cp_2415 tree_2415 0 2.592e-15
Rtr_241_2416 tree_241 tree_2416 0.8192
Cp_2416 tree_2416 0 2.592e-15
Rtr_241_2417 tree_241 tree_2417 0.8192
Cp_2417 tree_2417 0 2.592e-15
Rtr_241_2418 tree_241 tree_2418 0.8192
Cp_2418 tree_2418 0 2.592e-15
Rtr_241_2419 tree_241 tree_2419 0.8192
Cp_2419 tree_2419 0 2.592e-15
Rtr_241_2420 tree_241 tree_2420 0.8192
Cp_2420 tree_2420 0 2.592e-15
Rtr_242_2421 tree_242 tree_2421 0.8192
Cp_2421 tree_2421 0 2.592e-15
Rtr_242_2422 tree_242 tree_2422 0.8192
Cp_2422 tree_2422 0 2.592e-15
Rtr_242_2423 tree_242 tree_2423 0.8192
Cp_2423 tree_2423 0 2.592e-15
Rtr_242_2424 tree_242 tree_2424 0.8192
Cp_2424 tree_2424 0 2.592e-15
Rtr_242_2425 tree_242 tree_2425 0.8192
Cp_2425 tree_2425 0 2.592e-15
Rtr_242_2426 tree_242 tree_2426 0.8192
Cp_2426 tree_2426 0 2.592e-15
Rtr_242_2427 tree_242 tree_2427 0.8192
Cp_2427 tree_2427 0 2.592e-15
Rtr_242_2428 tree_242 tree_2428 0.8192
Cp_2428 tree_2428 0 2.592e-15
Rtr_242_2429 tree_242 tree_2429 0.8192
Cp_2429 tree_2429 0 2.592e-15
Rtr_242_2430 tree_242 tree_2430 0.8192
Cp_2430 tree_2430 0 2.592e-15
Rtr_243_2431 tree_243 tree_2431 0.8192
Cp_2431 tree_2431 0 2.592e-15
Rtr_243_2432 tree_243 tree_2432 0.8192
Cp_2432 tree_2432 0 2.592e-15
Rtr_243_2433 tree_243 tree_2433 0.8192
Cp_2433 tree_2433 0 2.592e-15
Rtr_243_2434 tree_243 tree_2434 0.8192
Cp_2434 tree_2434 0 2.592e-15
Rtr_243_2435 tree_243 tree_2435 0.8192
Cp_2435 tree_2435 0 2.592e-15
Rtr_243_2436 tree_243 tree_2436 0.8192
Cp_2436 tree_2436 0 2.592e-15
Rtr_243_2437 tree_243 tree_2437 0.8192
Cp_2437 tree_2437 0 2.592e-15
Rtr_243_2438 tree_243 tree_2438 0.8192
Cp_2438 tree_2438 0 2.592e-15
Rtr_243_2439 tree_243 tree_2439 0.8192
Cp_2439 tree_2439 0 2.592e-15
Rtr_243_2440 tree_243 tree_2440 0.8192
Cp_2440 tree_2440 0 2.592e-15
Rtr_244_2441 tree_244 tree_2441 0.8192
Cp_2441 tree_2441 0 2.592e-15
Rtr_244_2442 tree_244 tree_2442 0.8192
Cp_2442 tree_2442 0 2.592e-15
Rtr_244_2443 tree_244 tree_2443 0.8192
Cp_2443 tree_2443 0 2.592e-15
Rtr_244_2444 tree_244 tree_2444 0.8192
Cp_2444 tree_2444 0 2.592e-15
Rtr_244_2445 tree_244 tree_2445 0.8192
Cp_2445 tree_2445 0 2.592e-15
Rtr_244_2446 tree_244 tree_2446 0.8192
Cp_2446 tree_2446 0 2.592e-15
Rtr_244_2447 tree_244 tree_2447 0.8192
Cp_2447 tree_2447 0 2.592e-15
Rtr_244_2448 tree_244 tree_2448 0.8192
Cp_2448 tree_2448 0 2.592e-15
Rtr_244_2449 tree_244 tree_2449 0.8192
Cp_2449 tree_2449 0 2.592e-15
Rtr_244_2450 tree_244 tree_2450 0.8192
Cp_2450 tree_2450 0 2.592e-15
Rtr_245_2451 tree_245 tree_2451 0.8192
Cp_2451 tree_2451 0 2.592e-15
Rtr_245_2452 tree_245 tree_2452 0.8192
Cp_2452 tree_2452 0 2.592e-15
Rtr_245_2453 tree_245 tree_2453 0.8192
Cp_2453 tree_2453 0 2.592e-15
Rtr_245_2454 tree_245 tree_2454 0.8192
Cp_2454 tree_2454 0 2.592e-15
Rtr_245_2455 tree_245 tree_2455 0.8192
Cp_2455 tree_2455 0 2.592e-15
Rtr_245_2456 tree_245 tree_2456 0.8192
Cp_2456 tree_2456 0 2.592e-15
Rtr_245_2457 tree_245 tree_2457 0.8192
Cp_2457 tree_2457 0 2.592e-15
Rtr_245_2458 tree_245 tree_2458 0.8192
Cp_2458 tree_2458 0 2.592e-15
Rtr_245_2459 tree_245 tree_2459 0.8192
Cp_2459 tree_2459 0 2.592e-15
Rtr_245_2460 tree_245 tree_2460 0.8192
Cp_2460 tree_2460 0 2.592e-15
Rtr_246_2461 tree_246 tree_2461 0.8192
Cp_2461 tree_2461 0 2.592e-15
Rtr_246_2462 tree_246 tree_2462 0.8192
Cp_2462 tree_2462 0 2.592e-15
Rtr_246_2463 tree_246 tree_2463 0.8192
Cp_2463 tree_2463 0 2.592e-15
Rtr_246_2464 tree_246 tree_2464 0.8192
Cp_2464 tree_2464 0 2.592e-15
Rtr_246_2465 tree_246 tree_2465 0.8192
Cp_2465 tree_2465 0 2.592e-15
Rtr_246_2466 tree_246 tree_2466 0.8192
Cp_2466 tree_2466 0 2.592e-15
Rtr_246_2467 tree_246 tree_2467 0.8192
Cp_2467 tree_2467 0 2.592e-15
Rtr_246_2468 tree_246 tree_2468 0.8192
Cp_2468 tree_2468 0 2.592e-15
Rtr_246_2469 tree_246 tree_2469 0.8192
Cp_2469 tree_2469 0 2.592e-15
Rtr_246_2470 tree_246 tree_2470 0.8192
Cp_2470 tree_2470 0 2.592e-15
Rtr_247_2471 tree_247 tree_2471 0.8192
Cp_2471 tree_2471 0 2.592e-15
Rtr_247_2472 tree_247 tree_2472 0.8192
Cp_2472 tree_2472 0 2.592e-15
Rtr_247_2473 tree_247 tree_2473 0.8192
Cp_2473 tree_2473 0 2.592e-15
Rtr_247_2474 tree_247 tree_2474 0.8192
Cp_2474 tree_2474 0 2.592e-15
Rtr_247_2475 tree_247 tree_2475 0.8192
Cp_2475 tree_2475 0 2.592e-15
Rtr_247_2476 tree_247 tree_2476 0.8192
Cp_2476 tree_2476 0 2.592e-15
Rtr_247_2477 tree_247 tree_2477 0.8192
Cp_2477 tree_2477 0 2.592e-15
Rtr_247_2478 tree_247 tree_2478 0.8192
Cp_2478 tree_2478 0 2.592e-15
Rtr_247_2479 tree_247 tree_2479 0.8192
Cp_2479 tree_2479 0 2.592e-15
Rtr_247_2480 tree_247 tree_2480 0.8192
Cp_2480 tree_2480 0 2.592e-15
Rtr_248_2481 tree_248 tree_2481 0.8192
Cp_2481 tree_2481 0 2.592e-15
Rtr_248_2482 tree_248 tree_2482 0.8192
Cp_2482 tree_2482 0 2.592e-15
Rtr_248_2483 tree_248 tree_2483 0.8192
Cp_2483 tree_2483 0 2.592e-15
Rtr_248_2484 tree_248 tree_2484 0.8192
Cp_2484 tree_2484 0 2.592e-15
Rtr_248_2485 tree_248 tree_2485 0.8192
Cp_2485 tree_2485 0 2.592e-15
Rtr_248_2486 tree_248 tree_2486 0.8192
Cp_2486 tree_2486 0 2.592e-15
Rtr_248_2487 tree_248 tree_2487 0.8192
Cp_2487 tree_2487 0 2.592e-15
Rtr_248_2488 tree_248 tree_2488 0.8192
Cp_2488 tree_2488 0 2.592e-15
Rtr_248_2489 tree_248 tree_2489 0.8192
Cp_2489 tree_2489 0 2.592e-15
Rtr_248_2490 tree_248 tree_2490 0.8192
Cp_2490 tree_2490 0 2.592e-15
Rtr_249_2491 tree_249 tree_2491 0.8192
Cp_2491 tree_2491 0 2.592e-15
Rtr_249_2492 tree_249 tree_2492 0.8192
Cp_2492 tree_2492 0 2.592e-15
Rtr_249_2493 tree_249 tree_2493 0.8192
Cp_2493 tree_2493 0 2.592e-15
Rtr_249_2494 tree_249 tree_2494 0.8192
Cp_2494 tree_2494 0 2.592e-15
Rtr_249_2495 tree_249 tree_2495 0.8192
Cp_2495 tree_2495 0 2.592e-15
Rtr_249_2496 tree_249 tree_2496 0.8192
Cp_2496 tree_2496 0 2.592e-15
Rtr_249_2497 tree_249 tree_2497 0.8192
Cp_2497 tree_2497 0 2.592e-15
Rtr_249_2498 tree_249 tree_2498 0.8192
Cp_2498 tree_2498 0 2.592e-15
Rtr_249_2499 tree_249 tree_2499 0.8192
Cp_2499 tree_2499 0 2.592e-15
Rtr_249_2500 tree_249 tree_2500 0.8192
Cp_2500 tree_2500 0 2.592e-15
Rtr_250_2501 tree_250 tree_2501 0.8192
Cp_2501 tree_2501 0 2.592e-15
Rtr_250_2502 tree_250 tree_2502 0.8192
Cp_2502 tree_2502 0 2.592e-15
Rtr_250_2503 tree_250 tree_2503 0.8192
Cp_2503 tree_2503 0 2.592e-15
Rtr_250_2504 tree_250 tree_2504 0.8192
Cp_2504 tree_2504 0 2.592e-15
Rtr_250_2505 tree_250 tree_2505 0.8192
Cp_2505 tree_2505 0 2.592e-15
Rtr_250_2506 tree_250 tree_2506 0.8192
Cp_2506 tree_2506 0 2.592e-15
Rtr_250_2507 tree_250 tree_2507 0.8192
Cp_2507 tree_2507 0 2.592e-15
Rtr_250_2508 tree_250 tree_2508 0.8192
Cp_2508 tree_2508 0 2.592e-15
Rtr_250_2509 tree_250 tree_2509 0.8192
Cp_2509 tree_2509 0 2.592e-15
Rtr_250_2510 tree_250 tree_2510 0.8192
Cp_2510 tree_2510 0 2.592e-15
Rtr_251_2511 tree_251 tree_2511 0.8192
Cp_2511 tree_2511 0 2.592e-15
Rtr_251_2512 tree_251 tree_2512 0.8192
Cp_2512 tree_2512 0 2.592e-15
Rtr_251_2513 tree_251 tree_2513 0.8192
Cp_2513 tree_2513 0 2.592e-15
Rtr_251_2514 tree_251 tree_2514 0.8192
Cp_2514 tree_2514 0 2.592e-15
Rtr_251_2515 tree_251 tree_2515 0.8192
Cp_2515 tree_2515 0 2.592e-15
Rtr_251_2516 tree_251 tree_2516 0.8192
Cp_2516 tree_2516 0 2.592e-15
Rtr_251_2517 tree_251 tree_2517 0.8192
Cp_2517 tree_2517 0 2.592e-15
Rtr_251_2518 tree_251 tree_2518 0.8192
Cp_2518 tree_2518 0 2.592e-15
Rtr_251_2519 tree_251 tree_2519 0.8192
Cp_2519 tree_2519 0 2.592e-15
Rtr_251_2520 tree_251 tree_2520 0.8192
Cp_2520 tree_2520 0 2.592e-15
Rtr_252_2521 tree_252 tree_2521 0.8192
Cp_2521 tree_2521 0 2.592e-15
Rtr_252_2522 tree_252 tree_2522 0.8192
Cp_2522 tree_2522 0 2.592e-15
Rtr_252_2523 tree_252 tree_2523 0.8192
Cp_2523 tree_2523 0 2.592e-15
Rtr_252_2524 tree_252 tree_2524 0.8192
Cp_2524 tree_2524 0 2.592e-15
Rtr_252_2525 tree_252 tree_2525 0.8192
Cp_2525 tree_2525 0 2.592e-15
Rtr_252_2526 tree_252 tree_2526 0.8192
Cp_2526 tree_2526 0 2.592e-15
Rtr_252_2527 tree_252 tree_2527 0.8192
Cp_2527 tree_2527 0 2.592e-15
Rtr_252_2528 tree_252 tree_2528 0.8192
Cp_2528 tree_2528 0 2.592e-15
Rtr_252_2529 tree_252 tree_2529 0.8192
Cp_2529 tree_2529 0 2.592e-15
Rtr_252_2530 tree_252 tree_2530 0.8192
Cp_2530 tree_2530 0 2.592e-15
Rtr_253_2531 tree_253 tree_2531 0.8192
Cp_2531 tree_2531 0 2.592e-15
Rtr_253_2532 tree_253 tree_2532 0.8192
Cp_2532 tree_2532 0 2.592e-15
Rtr_253_2533 tree_253 tree_2533 0.8192
Cp_2533 tree_2533 0 2.592e-15
Rtr_253_2534 tree_253 tree_2534 0.8192
Cp_2534 tree_2534 0 2.592e-15
Rtr_253_2535 tree_253 tree_2535 0.8192
Cp_2535 tree_2535 0 2.592e-15
Rtr_253_2536 tree_253 tree_2536 0.8192
Cp_2536 tree_2536 0 2.592e-15
Rtr_253_2537 tree_253 tree_2537 0.8192
Cp_2537 tree_2537 0 2.592e-15
Rtr_253_2538 tree_253 tree_2538 0.8192
Cp_2538 tree_2538 0 2.592e-15
Rtr_253_2539 tree_253 tree_2539 0.8192
Cp_2539 tree_2539 0 2.592e-15
Rtr_253_2540 tree_253 tree_2540 0.8192
Cp_2540 tree_2540 0 2.592e-15
Rtr_254_2541 tree_254 tree_2541 0.8192
Cp_2541 tree_2541 0 2.592e-15
Rtr_254_2542 tree_254 tree_2542 0.8192
Cp_2542 tree_2542 0 2.592e-15
Rtr_254_2543 tree_254 tree_2543 0.8192
Cp_2543 tree_2543 0 2.592e-15
Rtr_254_2544 tree_254 tree_2544 0.8192
Cp_2544 tree_2544 0 2.592e-15
Rtr_254_2545 tree_254 tree_2545 0.8192
Cp_2545 tree_2545 0 2.592e-15
Rtr_254_2546 tree_254 tree_2546 0.8192
Cp_2546 tree_2546 0 2.592e-15
Rtr_254_2547 tree_254 tree_2547 0.8192
Cp_2547 tree_2547 0 2.592e-15
Rtr_254_2548 tree_254 tree_2548 0.8192
Cp_2548 tree_2548 0 2.592e-15
Rtr_254_2549 tree_254 tree_2549 0.8192
Cp_2549 tree_2549 0 2.592e-15
Rtr_254_2550 tree_254 tree_2550 0.8192
Cp_2550 tree_2550 0 2.592e-15
Rtr_255_2551 tree_255 tree_2551 0.8192
Cp_2551 tree_2551 0 2.592e-15
Rtr_255_2552 tree_255 tree_2552 0.8192
Cp_2552 tree_2552 0 2.592e-15
Rtr_255_2553 tree_255 tree_2553 0.8192
Cp_2553 tree_2553 0 2.592e-15
Rtr_255_2554 tree_255 tree_2554 0.8192
Cp_2554 tree_2554 0 2.592e-15
Rtr_255_2555 tree_255 tree_2555 0.8192
Cp_2555 tree_2555 0 2.592e-15
Rtr_255_2556 tree_255 tree_2556 0.8192
Cp_2556 tree_2556 0 2.592e-15
Rtr_255_2557 tree_255 tree_2557 0.8192
Cp_2557 tree_2557 0 2.592e-15
Rtr_255_2558 tree_255 tree_2558 0.8192
Cp_2558 tree_2558 0 2.592e-15
Rtr_255_2559 tree_255 tree_2559 0.8192
Cp_2559 tree_2559 0 2.592e-15
Rtr_255_2560 tree_255 tree_2560 0.8192
Cp_2560 tree_2560 0 2.592e-15
Rtr_256_2561 tree_256 tree_2561 0.8192
Cp_2561 tree_2561 0 2.592e-15
Rtr_256_2562 tree_256 tree_2562 0.8192
Cp_2562 tree_2562 0 2.592e-15
Rtr_256_2563 tree_256 tree_2563 0.8192
Cp_2563 tree_2563 0 2.592e-15
Rtr_256_2564 tree_256 tree_2564 0.8192
Cp_2564 tree_2564 0 2.592e-15
Rtr_256_2565 tree_256 tree_2565 0.8192
Cp_2565 tree_2565 0 2.592e-15
Rtr_256_2566 tree_256 tree_2566 0.8192
Cp_2566 tree_2566 0 2.592e-15
Rtr_256_2567 tree_256 tree_2567 0.8192
Cp_2567 tree_2567 0 2.592e-15
Rtr_256_2568 tree_256 tree_2568 0.8192
Cp_2568 tree_2568 0 2.592e-15
Rtr_256_2569 tree_256 tree_2569 0.8192
Cp_2569 tree_2569 0 2.592e-15
Rtr_256_2570 tree_256 tree_2570 0.8192
Cp_2570 tree_2570 0 2.592e-15
Rtr_257_2571 tree_257 tree_2571 0.8192
Cp_2571 tree_2571 0 2.592e-15
Rtr_257_2572 tree_257 tree_2572 0.8192
Cp_2572 tree_2572 0 2.592e-15
Rtr_257_2573 tree_257 tree_2573 0.8192
Cp_2573 tree_2573 0 2.592e-15
Rtr_257_2574 tree_257 tree_2574 0.8192
Cp_2574 tree_2574 0 2.592e-15
Rtr_257_2575 tree_257 tree_2575 0.8192
Cp_2575 tree_2575 0 2.592e-15
Rtr_257_2576 tree_257 tree_2576 0.8192
Cp_2576 tree_2576 0 2.592e-15
Rtr_257_2577 tree_257 tree_2577 0.8192
Cp_2577 tree_2577 0 2.592e-15
Rtr_257_2578 tree_257 tree_2578 0.8192
Cp_2578 tree_2578 0 2.592e-15
Rtr_257_2579 tree_257 tree_2579 0.8192
Cp_2579 tree_2579 0 2.592e-15
Rtr_257_2580 tree_257 tree_2580 0.8192
Cp_2580 tree_2580 0 2.592e-15
Rtr_258_2581 tree_258 tree_2581 0.8192
Cp_2581 tree_2581 0 2.592e-15
Rtr_258_2582 tree_258 tree_2582 0.8192
Cp_2582 tree_2582 0 2.592e-15
Rtr_258_2583 tree_258 tree_2583 0.8192
Cp_2583 tree_2583 0 2.592e-15
Rtr_258_2584 tree_258 tree_2584 0.8192
Cp_2584 tree_2584 0 2.592e-15
Rtr_258_2585 tree_258 tree_2585 0.8192
Cp_2585 tree_2585 0 2.592e-15
Rtr_258_2586 tree_258 tree_2586 0.8192
Cp_2586 tree_2586 0 2.592e-15
Rtr_258_2587 tree_258 tree_2587 0.8192
Cp_2587 tree_2587 0 2.592e-15
Rtr_258_2588 tree_258 tree_2588 0.8192
Cp_2588 tree_2588 0 2.592e-15
Rtr_258_2589 tree_258 tree_2589 0.8192
Cp_2589 tree_2589 0 2.592e-15
Rtr_258_2590 tree_258 tree_2590 0.8192
Cp_2590 tree_2590 0 2.592e-15
Rtr_259_2591 tree_259 tree_2591 0.8192
Cp_2591 tree_2591 0 2.592e-15
Rtr_259_2592 tree_259 tree_2592 0.8192
Cp_2592 tree_2592 0 2.592e-15
Rtr_259_2593 tree_259 tree_2593 0.8192
Cp_2593 tree_2593 0 2.592e-15
Rtr_259_2594 tree_259 tree_2594 0.8192
Cp_2594 tree_2594 0 2.592e-15
Rtr_259_2595 tree_259 tree_2595 0.8192
Cp_2595 tree_2595 0 2.592e-15
Rtr_259_2596 tree_259 tree_2596 0.8192
Cp_2596 tree_2596 0 2.592e-15
Rtr_259_2597 tree_259 tree_2597 0.8192
Cp_2597 tree_2597 0 2.592e-15
Rtr_259_2598 tree_259 tree_2598 0.8192
Cp_2598 tree_2598 0 2.592e-15
Rtr_259_2599 tree_259 tree_2599 0.8192
Cp_2599 tree_2599 0 2.592e-15
Rtr_259_2600 tree_259 tree_2600 0.8192
Cp_2600 tree_2600 0 2.592e-15
Rtr_260_2601 tree_260 tree_2601 0.8192
Cp_2601 tree_2601 0 2.592e-15
Rtr_260_2602 tree_260 tree_2602 0.8192
Cp_2602 tree_2602 0 2.592e-15
Rtr_260_2603 tree_260 tree_2603 0.8192
Cp_2603 tree_2603 0 2.592e-15
Rtr_260_2604 tree_260 tree_2604 0.8192
Cp_2604 tree_2604 0 2.592e-15
Rtr_260_2605 tree_260 tree_2605 0.8192
Cp_2605 tree_2605 0 2.592e-15
Rtr_260_2606 tree_260 tree_2606 0.8192
Cp_2606 tree_2606 0 2.592e-15
Rtr_260_2607 tree_260 tree_2607 0.8192
Cp_2607 tree_2607 0 2.592e-15
Rtr_260_2608 tree_260 tree_2608 0.8192
Cp_2608 tree_2608 0 2.592e-15
Rtr_260_2609 tree_260 tree_2609 0.8192
Cp_2609 tree_2609 0 2.592e-15
Rtr_260_2610 tree_260 tree_2610 0.8192
Cp_2610 tree_2610 0 2.592e-15
Rtr_261_2611 tree_261 tree_2611 0.8192
Cp_2611 tree_2611 0 2.592e-15
Rtr_261_2612 tree_261 tree_2612 0.8192
Cp_2612 tree_2612 0 2.592e-15
Rtr_261_2613 tree_261 tree_2613 0.8192
Cp_2613 tree_2613 0 2.592e-15
Rtr_261_2614 tree_261 tree_2614 0.8192
Cp_2614 tree_2614 0 2.592e-15
Rtr_261_2615 tree_261 tree_2615 0.8192
Cp_2615 tree_2615 0 2.592e-15
Rtr_261_2616 tree_261 tree_2616 0.8192
Cp_2616 tree_2616 0 2.592e-15
Rtr_261_2617 tree_261 tree_2617 0.8192
Cp_2617 tree_2617 0 2.592e-15
Rtr_261_2618 tree_261 tree_2618 0.8192
Cp_2618 tree_2618 0 2.592e-15
Rtr_261_2619 tree_261 tree_2619 0.8192
Cp_2619 tree_2619 0 2.592e-15
Rtr_261_2620 tree_261 tree_2620 0.8192
Cp_2620 tree_2620 0 2.592e-15
Rtr_262_2621 tree_262 tree_2621 0.8192
Cp_2621 tree_2621 0 2.592e-15
Rtr_262_2622 tree_262 tree_2622 0.8192
Cp_2622 tree_2622 0 2.592e-15
Rtr_262_2623 tree_262 tree_2623 0.8192
Cp_2623 tree_2623 0 2.592e-15
Rtr_262_2624 tree_262 tree_2624 0.8192
Cp_2624 tree_2624 0 2.592e-15
Rtr_262_2625 tree_262 tree_2625 0.8192
Cp_2625 tree_2625 0 2.592e-15
Rtr_262_2626 tree_262 tree_2626 0.8192
Cp_2626 tree_2626 0 2.592e-15
Rtr_262_2627 tree_262 tree_2627 0.8192
Cp_2627 tree_2627 0 2.592e-15
Rtr_262_2628 tree_262 tree_2628 0.8192
Cp_2628 tree_2628 0 2.592e-15
Rtr_262_2629 tree_262 tree_2629 0.8192
Cp_2629 tree_2629 0 2.592e-15
Rtr_262_2630 tree_262 tree_2630 0.8192
Cp_2630 tree_2630 0 2.592e-15
Rtr_263_2631 tree_263 tree_2631 0.8192
Cp_2631 tree_2631 0 2.592e-15
Rtr_263_2632 tree_263 tree_2632 0.8192
Cp_2632 tree_2632 0 2.592e-15
Rtr_263_2633 tree_263 tree_2633 0.8192
Cp_2633 tree_2633 0 2.592e-15
Rtr_263_2634 tree_263 tree_2634 0.8192
Cp_2634 tree_2634 0 2.592e-15
Rtr_263_2635 tree_263 tree_2635 0.8192
Cp_2635 tree_2635 0 2.592e-15
Rtr_263_2636 tree_263 tree_2636 0.8192
Cp_2636 tree_2636 0 2.592e-15
Rtr_263_2637 tree_263 tree_2637 0.8192
Cp_2637 tree_2637 0 2.592e-15
Rtr_263_2638 tree_263 tree_2638 0.8192
Cp_2638 tree_2638 0 2.592e-15
Rtr_263_2639 tree_263 tree_2639 0.8192
Cp_2639 tree_2639 0 2.592e-15
Rtr_263_2640 tree_263 tree_2640 0.8192
Cp_2640 tree_2640 0 2.592e-15
Rtr_264_2641 tree_264 tree_2641 0.8192
Cp_2641 tree_2641 0 2.592e-15
Rtr_264_2642 tree_264 tree_2642 0.8192
Cp_2642 tree_2642 0 2.592e-15
Rtr_264_2643 tree_264 tree_2643 0.8192
Cp_2643 tree_2643 0 2.592e-15
Rtr_264_2644 tree_264 tree_2644 0.8192
Cp_2644 tree_2644 0 2.592e-15
Rtr_264_2645 tree_264 tree_2645 0.8192
Cp_2645 tree_2645 0 2.592e-15
Rtr_264_2646 tree_264 tree_2646 0.8192
Cp_2646 tree_2646 0 2.592e-15
Rtr_264_2647 tree_264 tree_2647 0.8192
Cp_2647 tree_2647 0 2.592e-15
Rtr_264_2648 tree_264 tree_2648 0.8192
Cp_2648 tree_2648 0 2.592e-15
Rtr_264_2649 tree_264 tree_2649 0.8192
Cp_2649 tree_2649 0 2.592e-15
Rtr_264_2650 tree_264 tree_2650 0.8192
Cp_2650 tree_2650 0 2.592e-15
Rtr_265_2651 tree_265 tree_2651 0.8192
Cp_2651 tree_2651 0 2.592e-15
Rtr_265_2652 tree_265 tree_2652 0.8192
Cp_2652 tree_2652 0 2.592e-15
Rtr_265_2653 tree_265 tree_2653 0.8192
Cp_2653 tree_2653 0 2.592e-15
Rtr_265_2654 tree_265 tree_2654 0.8192
Cp_2654 tree_2654 0 2.592e-15
Rtr_265_2655 tree_265 tree_2655 0.8192
Cp_2655 tree_2655 0 2.592e-15
Rtr_265_2656 tree_265 tree_2656 0.8192
Cp_2656 tree_2656 0 2.592e-15
Rtr_265_2657 tree_265 tree_2657 0.8192
Cp_2657 tree_2657 0 2.592e-15
Rtr_265_2658 tree_265 tree_2658 0.8192
Cp_2658 tree_2658 0 2.592e-15
Rtr_265_2659 tree_265 tree_2659 0.8192
Cp_2659 tree_2659 0 2.592e-15
Rtr_265_2660 tree_265 tree_2660 0.8192
Cp_2660 tree_2660 0 2.592e-15
Rtr_266_2661 tree_266 tree_2661 0.8192
Cp_2661 tree_2661 0 2.592e-15
Rtr_266_2662 tree_266 tree_2662 0.8192
Cp_2662 tree_2662 0 2.592e-15
Rtr_266_2663 tree_266 tree_2663 0.8192
Cp_2663 tree_2663 0 2.592e-15
Rtr_266_2664 tree_266 tree_2664 0.8192
Cp_2664 tree_2664 0 2.592e-15
Rtr_266_2665 tree_266 tree_2665 0.8192
Cp_2665 tree_2665 0 2.592e-15
Rtr_266_2666 tree_266 tree_2666 0.8192
Cp_2666 tree_2666 0 2.592e-15
Rtr_266_2667 tree_266 tree_2667 0.8192
Cp_2667 tree_2667 0 2.592e-15
Rtr_266_2668 tree_266 tree_2668 0.8192
Cp_2668 tree_2668 0 2.592e-15
Rtr_266_2669 tree_266 tree_2669 0.8192
Cp_2669 tree_2669 0 2.592e-15
Rtr_266_2670 tree_266 tree_2670 0.8192
Cp_2670 tree_2670 0 2.592e-15
Rtr_267_2671 tree_267 tree_2671 0.8192
Cp_2671 tree_2671 0 2.592e-15
Rtr_267_2672 tree_267 tree_2672 0.8192
Cp_2672 tree_2672 0 2.592e-15
Rtr_267_2673 tree_267 tree_2673 0.8192
Cp_2673 tree_2673 0 2.592e-15
Rtr_267_2674 tree_267 tree_2674 0.8192
Cp_2674 tree_2674 0 2.592e-15
Rtr_267_2675 tree_267 tree_2675 0.8192
Cp_2675 tree_2675 0 2.592e-15
Rtr_267_2676 tree_267 tree_2676 0.8192
Cp_2676 tree_2676 0 2.592e-15
Rtr_267_2677 tree_267 tree_2677 0.8192
Cp_2677 tree_2677 0 2.592e-15
Rtr_267_2678 tree_267 tree_2678 0.8192
Cp_2678 tree_2678 0 2.592e-15
Rtr_267_2679 tree_267 tree_2679 0.8192
Cp_2679 tree_2679 0 2.592e-15
Rtr_267_2680 tree_267 tree_2680 0.8192
Cp_2680 tree_2680 0 2.592e-15
Rtr_268_2681 tree_268 tree_2681 0.8192
Cp_2681 tree_2681 0 2.592e-15
Rtr_268_2682 tree_268 tree_2682 0.8192
Cp_2682 tree_2682 0 2.592e-15
Rtr_268_2683 tree_268 tree_2683 0.8192
Cp_2683 tree_2683 0 2.592e-15
Rtr_268_2684 tree_268 tree_2684 0.8192
Cp_2684 tree_2684 0 2.592e-15
Rtr_268_2685 tree_268 tree_2685 0.8192
Cp_2685 tree_2685 0 2.592e-15
Rtr_268_2686 tree_268 tree_2686 0.8192
Cp_2686 tree_2686 0 2.592e-15
Rtr_268_2687 tree_268 tree_2687 0.8192
Cp_2687 tree_2687 0 2.592e-15
Rtr_268_2688 tree_268 tree_2688 0.8192
Cp_2688 tree_2688 0 2.592e-15
Rtr_268_2689 tree_268 tree_2689 0.8192
Cp_2689 tree_2689 0 2.592e-15
Rtr_268_2690 tree_268 tree_2690 0.8192
Cp_2690 tree_2690 0 2.592e-15
Rtr_269_2691 tree_269 tree_2691 0.8192
Cp_2691 tree_2691 0 2.592e-15
Rtr_269_2692 tree_269 tree_2692 0.8192
Cp_2692 tree_2692 0 2.592e-15
Rtr_269_2693 tree_269 tree_2693 0.8192
Cp_2693 tree_2693 0 2.592e-15
Rtr_269_2694 tree_269 tree_2694 0.8192
Cp_2694 tree_2694 0 2.592e-15
Rtr_269_2695 tree_269 tree_2695 0.8192
Cp_2695 tree_2695 0 2.592e-15
Rtr_269_2696 tree_269 tree_2696 0.8192
Cp_2696 tree_2696 0 2.592e-15
Rtr_269_2697 tree_269 tree_2697 0.8192
Cp_2697 tree_2697 0 2.592e-15
Rtr_269_2698 tree_269 tree_2698 0.8192
Cp_2698 tree_2698 0 2.592e-15
Rtr_269_2699 tree_269 tree_2699 0.8192
Cp_2699 tree_2699 0 2.592e-15
Rtr_269_2700 tree_269 tree_2700 0.8192
Cp_2700 tree_2700 0 2.592e-15
Rtr_270_2701 tree_270 tree_2701 0.8192
Cp_2701 tree_2701 0 2.592e-15
Rtr_270_2702 tree_270 tree_2702 0.8192
Cp_2702 tree_2702 0 2.592e-15
Rtr_270_2703 tree_270 tree_2703 0.8192
Cp_2703 tree_2703 0 2.592e-15
Rtr_270_2704 tree_270 tree_2704 0.8192
Cp_2704 tree_2704 0 2.592e-15
Rtr_270_2705 tree_270 tree_2705 0.8192
Cp_2705 tree_2705 0 2.592e-15
Rtr_270_2706 tree_270 tree_2706 0.8192
Cp_2706 tree_2706 0 2.592e-15
Rtr_270_2707 tree_270 tree_2707 0.8192
Cp_2707 tree_2707 0 2.592e-15
Rtr_270_2708 tree_270 tree_2708 0.8192
Cp_2708 tree_2708 0 2.592e-15
Rtr_270_2709 tree_270 tree_2709 0.8192
Cp_2709 tree_2709 0 2.592e-15
Rtr_270_2710 tree_270 tree_2710 0.8192
Cp_2710 tree_2710 0 2.592e-15
Rtr_271_2711 tree_271 tree_2711 0.8192
Cp_2711 tree_2711 0 2.592e-15
Rtr_271_2712 tree_271 tree_2712 0.8192
Cp_2712 tree_2712 0 2.592e-15
Rtr_271_2713 tree_271 tree_2713 0.8192
Cp_2713 tree_2713 0 2.592e-15
Rtr_271_2714 tree_271 tree_2714 0.8192
Cp_2714 tree_2714 0 2.592e-15
Rtr_271_2715 tree_271 tree_2715 0.8192
Cp_2715 tree_2715 0 2.592e-15
Rtr_271_2716 tree_271 tree_2716 0.8192
Cp_2716 tree_2716 0 2.592e-15
Rtr_271_2717 tree_271 tree_2717 0.8192
Cp_2717 tree_2717 0 2.592e-15
Rtr_271_2718 tree_271 tree_2718 0.8192
Cp_2718 tree_2718 0 2.592e-15
Rtr_271_2719 tree_271 tree_2719 0.8192
Cp_2719 tree_2719 0 2.592e-15
Rtr_271_2720 tree_271 tree_2720 0.8192
Cp_2720 tree_2720 0 2.592e-15
Rtr_272_2721 tree_272 tree_2721 0.8192
Cp_2721 tree_2721 0 2.592e-15
Rtr_272_2722 tree_272 tree_2722 0.8192
Cp_2722 tree_2722 0 2.592e-15
Rtr_272_2723 tree_272 tree_2723 0.8192
Cp_2723 tree_2723 0 2.592e-15
Rtr_272_2724 tree_272 tree_2724 0.8192
Cp_2724 tree_2724 0 2.592e-15
Rtr_272_2725 tree_272 tree_2725 0.8192
Cp_2725 tree_2725 0 2.592e-15
Rtr_272_2726 tree_272 tree_2726 0.8192
Cp_2726 tree_2726 0 2.592e-15
Rtr_272_2727 tree_272 tree_2727 0.8192
Cp_2727 tree_2727 0 2.592e-15
Rtr_272_2728 tree_272 tree_2728 0.8192
Cp_2728 tree_2728 0 2.592e-15
Rtr_272_2729 tree_272 tree_2729 0.8192
Cp_2729 tree_2729 0 2.592e-15
Rtr_272_2730 tree_272 tree_2730 0.8192
Cp_2730 tree_2730 0 2.592e-15
Rtr_273_2731 tree_273 tree_2731 0.8192
Cp_2731 tree_2731 0 2.592e-15
Rtr_273_2732 tree_273 tree_2732 0.8192
Cp_2732 tree_2732 0 2.592e-15
Rtr_273_2733 tree_273 tree_2733 0.8192
Cp_2733 tree_2733 0 2.592e-15
Rtr_273_2734 tree_273 tree_2734 0.8192
Cp_2734 tree_2734 0 2.592e-15
Rtr_273_2735 tree_273 tree_2735 0.8192
Cp_2735 tree_2735 0 2.592e-15
Rtr_273_2736 tree_273 tree_2736 0.8192
Cp_2736 tree_2736 0 2.592e-15
Rtr_273_2737 tree_273 tree_2737 0.8192
Cp_2737 tree_2737 0 2.592e-15
Rtr_273_2738 tree_273 tree_2738 0.8192
Cp_2738 tree_2738 0 2.592e-15
Rtr_273_2739 tree_273 tree_2739 0.8192
Cp_2739 tree_2739 0 2.592e-15
Rtr_273_2740 tree_273 tree_2740 0.8192
Cp_2740 tree_2740 0 2.592e-15
Rtr_274_2741 tree_274 tree_2741 0.8192
Cp_2741 tree_2741 0 2.592e-15
Rtr_274_2742 tree_274 tree_2742 0.8192
Cp_2742 tree_2742 0 2.592e-15
Rtr_274_2743 tree_274 tree_2743 0.8192
Cp_2743 tree_2743 0 2.592e-15
Rtr_274_2744 tree_274 tree_2744 0.8192
Cp_2744 tree_2744 0 2.592e-15
Rtr_274_2745 tree_274 tree_2745 0.8192
Cp_2745 tree_2745 0 2.592e-15
Rtr_274_2746 tree_274 tree_2746 0.8192
Cp_2746 tree_2746 0 2.592e-15
Rtr_274_2747 tree_274 tree_2747 0.8192
Cp_2747 tree_2747 0 2.592e-15
Rtr_274_2748 tree_274 tree_2748 0.8192
Cp_2748 tree_2748 0 2.592e-15
Rtr_274_2749 tree_274 tree_2749 0.8192
Cp_2749 tree_2749 0 2.592e-15
Rtr_274_2750 tree_274 tree_2750 0.8192
Cp_2750 tree_2750 0 2.592e-15
Rtr_275_2751 tree_275 tree_2751 0.8192
Cp_2751 tree_2751 0 2.592e-15
Rtr_275_2752 tree_275 tree_2752 0.8192
Cp_2752 tree_2752 0 2.592e-15
Rtr_275_2753 tree_275 tree_2753 0.8192
Cp_2753 tree_2753 0 2.592e-15
Rtr_275_2754 tree_275 tree_2754 0.8192
Cp_2754 tree_2754 0 2.592e-15
Rtr_275_2755 tree_275 tree_2755 0.8192
Cp_2755 tree_2755 0 2.592e-15
Rtr_275_2756 tree_275 tree_2756 0.8192
Cp_2756 tree_2756 0 2.592e-15
Rtr_275_2757 tree_275 tree_2757 0.8192
Cp_2757 tree_2757 0 2.592e-15
Rtr_275_2758 tree_275 tree_2758 0.8192
Cp_2758 tree_2758 0 2.592e-15
Rtr_275_2759 tree_275 tree_2759 0.8192
Cp_2759 tree_2759 0 2.592e-15
Rtr_275_2760 tree_275 tree_2760 0.8192
Cp_2760 tree_2760 0 2.592e-15
Rtr_276_2761 tree_276 tree_2761 0.8192
Cp_2761 tree_2761 0 2.592e-15
Rtr_276_2762 tree_276 tree_2762 0.8192
Cp_2762 tree_2762 0 2.592e-15
Rtr_276_2763 tree_276 tree_2763 0.8192
Cp_2763 tree_2763 0 2.592e-15
Rtr_276_2764 tree_276 tree_2764 0.8192
Cp_2764 tree_2764 0 2.592e-15
Rtr_276_2765 tree_276 tree_2765 0.8192
Cp_2765 tree_2765 0 2.592e-15
Rtr_276_2766 tree_276 tree_2766 0.8192
Cp_2766 tree_2766 0 2.592e-15
Rtr_276_2767 tree_276 tree_2767 0.8192
Cp_2767 tree_2767 0 2.592e-15
Rtr_276_2768 tree_276 tree_2768 0.8192
Cp_2768 tree_2768 0 2.592e-15
Rtr_276_2769 tree_276 tree_2769 0.8192
Cp_2769 tree_2769 0 2.592e-15
Rtr_276_2770 tree_276 tree_2770 0.8192
Cp_2770 tree_2770 0 2.592e-15
Rtr_277_2771 tree_277 tree_2771 0.8192
Cp_2771 tree_2771 0 2.592e-15
Rtr_277_2772 tree_277 tree_2772 0.8192
Cp_2772 tree_2772 0 2.592e-15
Rtr_277_2773 tree_277 tree_2773 0.8192
Cp_2773 tree_2773 0 2.592e-15
Rtr_277_2774 tree_277 tree_2774 0.8192
Cp_2774 tree_2774 0 2.592e-15
Rtr_277_2775 tree_277 tree_2775 0.8192
Cp_2775 tree_2775 0 2.592e-15
Rtr_277_2776 tree_277 tree_2776 0.8192
Cp_2776 tree_2776 0 2.592e-15
Rtr_277_2777 tree_277 tree_2777 0.8192
Cp_2777 tree_2777 0 2.592e-15
Rtr_277_2778 tree_277 tree_2778 0.8192
Cp_2778 tree_2778 0 2.592e-15
Rtr_277_2779 tree_277 tree_2779 0.8192
Cp_2779 tree_2779 0 2.592e-15
Rtr_277_2780 tree_277 tree_2780 0.8192
Cp_2780 tree_2780 0 2.592e-15
Rtr_278_2781 tree_278 tree_2781 0.8192
Cp_2781 tree_2781 0 2.592e-15
Rtr_278_2782 tree_278 tree_2782 0.8192
Cp_2782 tree_2782 0 2.592e-15
Rtr_278_2783 tree_278 tree_2783 0.8192
Cp_2783 tree_2783 0 2.592e-15
Rtr_278_2784 tree_278 tree_2784 0.8192
Cp_2784 tree_2784 0 2.592e-15
Rtr_278_2785 tree_278 tree_2785 0.8192
Cp_2785 tree_2785 0 2.592e-15
Rtr_278_2786 tree_278 tree_2786 0.8192
Cp_2786 tree_2786 0 2.592e-15
Rtr_278_2787 tree_278 tree_2787 0.8192
Cp_2787 tree_2787 0 2.592e-15
Rtr_278_2788 tree_278 tree_2788 0.8192
Cp_2788 tree_2788 0 2.592e-15
Rtr_278_2789 tree_278 tree_2789 0.8192
Cp_2789 tree_2789 0 2.592e-15
Rtr_278_2790 tree_278 tree_2790 0.8192
Cp_2790 tree_2790 0 2.592e-15
Rtr_279_2791 tree_279 tree_2791 0.8192
Cp_2791 tree_2791 0 2.592e-15
Rtr_279_2792 tree_279 tree_2792 0.8192
Cp_2792 tree_2792 0 2.592e-15
Rtr_279_2793 tree_279 tree_2793 0.8192
Cp_2793 tree_2793 0 2.592e-15
Rtr_279_2794 tree_279 tree_2794 0.8192
Cp_2794 tree_2794 0 2.592e-15
Rtr_279_2795 tree_279 tree_2795 0.8192
Cp_2795 tree_2795 0 2.592e-15
Rtr_279_2796 tree_279 tree_2796 0.8192
Cp_2796 tree_2796 0 2.592e-15
Rtr_279_2797 tree_279 tree_2797 0.8192
Cp_2797 tree_2797 0 2.592e-15
Rtr_279_2798 tree_279 tree_2798 0.8192
Cp_2798 tree_2798 0 2.592e-15
Rtr_279_2799 tree_279 tree_2799 0.8192
Cp_2799 tree_2799 0 2.592e-15
Rtr_279_2800 tree_279 tree_2800 0.8192
Cp_2800 tree_2800 0 2.592e-15
Rtr_280_2801 tree_280 tree_2801 0.8192
Cp_2801 tree_2801 0 2.592e-15
Rtr_280_2802 tree_280 tree_2802 0.8192
Cp_2802 tree_2802 0 2.592e-15
Rtr_280_2803 tree_280 tree_2803 0.8192
Cp_2803 tree_2803 0 2.592e-15
Rtr_280_2804 tree_280 tree_2804 0.8192
Cp_2804 tree_2804 0 2.592e-15
Rtr_280_2805 tree_280 tree_2805 0.8192
Cp_2805 tree_2805 0 2.592e-15
Rtr_280_2806 tree_280 tree_2806 0.8192
Cp_2806 tree_2806 0 2.592e-15
Rtr_280_2807 tree_280 tree_2807 0.8192
Cp_2807 tree_2807 0 2.592e-15
Rtr_280_2808 tree_280 tree_2808 0.8192
Cp_2808 tree_2808 0 2.592e-15
Rtr_280_2809 tree_280 tree_2809 0.8192
Cp_2809 tree_2809 0 2.592e-15
Rtr_280_2810 tree_280 tree_2810 0.8192
Cp_2810 tree_2810 0 2.592e-15
Rtr_281_2811 tree_281 tree_2811 0.8192
Cp_2811 tree_2811 0 2.592e-15
Rtr_281_2812 tree_281 tree_2812 0.8192
Cp_2812 tree_2812 0 2.592e-15
Rtr_281_2813 tree_281 tree_2813 0.8192
Cp_2813 tree_2813 0 2.592e-15
Rtr_281_2814 tree_281 tree_2814 0.8192
Cp_2814 tree_2814 0 2.592e-15
Rtr_281_2815 tree_281 tree_2815 0.8192
Cp_2815 tree_2815 0 2.592e-15
Rtr_281_2816 tree_281 tree_2816 0.8192
Cp_2816 tree_2816 0 2.592e-15
Rtr_281_2817 tree_281 tree_2817 0.8192
Cp_2817 tree_2817 0 2.592e-15
Rtr_281_2818 tree_281 tree_2818 0.8192
Cp_2818 tree_2818 0 2.592e-15
Rtr_281_2819 tree_281 tree_2819 0.8192
Cp_2819 tree_2819 0 2.592e-15
Rtr_281_2820 tree_281 tree_2820 0.8192
Cp_2820 tree_2820 0 2.592e-15
Rtr_282_2821 tree_282 tree_2821 0.8192
Cp_2821 tree_2821 0 2.592e-15
Rtr_282_2822 tree_282 tree_2822 0.8192
Cp_2822 tree_2822 0 2.592e-15
Rtr_282_2823 tree_282 tree_2823 0.8192
Cp_2823 tree_2823 0 2.592e-15
Rtr_282_2824 tree_282 tree_2824 0.8192
Cp_2824 tree_2824 0 2.592e-15
Rtr_282_2825 tree_282 tree_2825 0.8192
Cp_2825 tree_2825 0 2.592e-15
Rtr_282_2826 tree_282 tree_2826 0.8192
Cp_2826 tree_2826 0 2.592e-15
Rtr_282_2827 tree_282 tree_2827 0.8192
Cp_2827 tree_2827 0 2.592e-15
Rtr_282_2828 tree_282 tree_2828 0.8192
Cp_2828 tree_2828 0 2.592e-15
Rtr_282_2829 tree_282 tree_2829 0.8192
Cp_2829 tree_2829 0 2.592e-15
Rtr_282_2830 tree_282 tree_2830 0.8192
Cp_2830 tree_2830 0 2.592e-15
Rtr_283_2831 tree_283 tree_2831 0.8192
Cp_2831 tree_2831 0 2.592e-15
Rtr_283_2832 tree_283 tree_2832 0.8192
Cp_2832 tree_2832 0 2.592e-15
Rtr_283_2833 tree_283 tree_2833 0.8192
Cp_2833 tree_2833 0 2.592e-15
Rtr_283_2834 tree_283 tree_2834 0.8192
Cp_2834 tree_2834 0 2.592e-15
Rtr_283_2835 tree_283 tree_2835 0.8192
Cp_2835 tree_2835 0 2.592e-15
Rtr_283_2836 tree_283 tree_2836 0.8192
Cp_2836 tree_2836 0 2.592e-15
Rtr_283_2837 tree_283 tree_2837 0.8192
Cp_2837 tree_2837 0 2.592e-15
Rtr_283_2838 tree_283 tree_2838 0.8192
Cp_2838 tree_2838 0 2.592e-15
Rtr_283_2839 tree_283 tree_2839 0.8192
Cp_2839 tree_2839 0 2.592e-15
Rtr_283_2840 tree_283 tree_2840 0.8192
Cp_2840 tree_2840 0 2.592e-15
Rtr_284_2841 tree_284 tree_2841 0.8192
Cp_2841 tree_2841 0 2.592e-15
Rtr_284_2842 tree_284 tree_2842 0.8192
Cp_2842 tree_2842 0 2.592e-15
Rtr_284_2843 tree_284 tree_2843 0.8192
Cp_2843 tree_2843 0 2.592e-15
Rtr_284_2844 tree_284 tree_2844 0.8192
Cp_2844 tree_2844 0 2.592e-15
Rtr_284_2845 tree_284 tree_2845 0.8192
Cp_2845 tree_2845 0 2.592e-15
Rtr_284_2846 tree_284 tree_2846 0.8192
Cp_2846 tree_2846 0 2.592e-15
Rtr_284_2847 tree_284 tree_2847 0.8192
Cp_2847 tree_2847 0 2.592e-15
Rtr_284_2848 tree_284 tree_2848 0.8192
Cp_2848 tree_2848 0 2.592e-15
Rtr_284_2849 tree_284 tree_2849 0.8192
Cp_2849 tree_2849 0 2.592e-15
Rtr_284_2850 tree_284 tree_2850 0.8192
Cp_2850 tree_2850 0 2.592e-15
Rtr_285_2851 tree_285 tree_2851 0.8192
Cp_2851 tree_2851 0 2.592e-15
Rtr_285_2852 tree_285 tree_2852 0.8192
Cp_2852 tree_2852 0 2.592e-15
Rtr_285_2853 tree_285 tree_2853 0.8192
Cp_2853 tree_2853 0 2.592e-15
Rtr_285_2854 tree_285 tree_2854 0.8192
Cp_2854 tree_2854 0 2.592e-15
Rtr_285_2855 tree_285 tree_2855 0.8192
Cp_2855 tree_2855 0 2.592e-15
Rtr_285_2856 tree_285 tree_2856 0.8192
Cp_2856 tree_2856 0 2.592e-15
Rtr_285_2857 tree_285 tree_2857 0.8192
Cp_2857 tree_2857 0 2.592e-15
Rtr_285_2858 tree_285 tree_2858 0.8192
Cp_2858 tree_2858 0 2.592e-15
Rtr_285_2859 tree_285 tree_2859 0.8192
Cp_2859 tree_2859 0 2.592e-15
Rtr_285_2860 tree_285 tree_2860 0.8192
Cp_2860 tree_2860 0 2.592e-15
Rtr_286_2861 tree_286 tree_2861 0.8192
Cp_2861 tree_2861 0 2.592e-15
Rtr_286_2862 tree_286 tree_2862 0.8192
Cp_2862 tree_2862 0 2.592e-15
Rtr_286_2863 tree_286 tree_2863 0.8192
Cp_2863 tree_2863 0 2.592e-15
Rtr_286_2864 tree_286 tree_2864 0.8192
Cp_2864 tree_2864 0 2.592e-15
Rtr_286_2865 tree_286 tree_2865 0.8192
Cp_2865 tree_2865 0 2.592e-15
Rtr_286_2866 tree_286 tree_2866 0.8192
Cp_2866 tree_2866 0 2.592e-15
Rtr_286_2867 tree_286 tree_2867 0.8192
Cp_2867 tree_2867 0 2.592e-15
Rtr_286_2868 tree_286 tree_2868 0.8192
Cp_2868 tree_2868 0 2.592e-15
Rtr_286_2869 tree_286 tree_2869 0.8192
Cp_2869 tree_2869 0 2.592e-15
Rtr_286_2870 tree_286 tree_2870 0.8192
Cp_2870 tree_2870 0 2.592e-15
Rtr_287_2871 tree_287 tree_2871 0.8192
Cp_2871 tree_2871 0 2.592e-15
Rtr_287_2872 tree_287 tree_2872 0.8192
Cp_2872 tree_2872 0 2.592e-15
Rtr_287_2873 tree_287 tree_2873 0.8192
Cp_2873 tree_2873 0 2.592e-15
Rtr_287_2874 tree_287 tree_2874 0.8192
Cp_2874 tree_2874 0 2.592e-15
Rtr_287_2875 tree_287 tree_2875 0.8192
Cp_2875 tree_2875 0 2.592e-15
Rtr_287_2876 tree_287 tree_2876 0.8192
Cp_2876 tree_2876 0 2.592e-15
Rtr_287_2877 tree_287 tree_2877 0.8192
Cp_2877 tree_2877 0 2.592e-15
Rtr_287_2878 tree_287 tree_2878 0.8192
Cp_2878 tree_2878 0 2.592e-15
Rtr_287_2879 tree_287 tree_2879 0.8192
Cp_2879 tree_2879 0 2.592e-15
Rtr_287_2880 tree_287 tree_2880 0.8192
Cp_2880 tree_2880 0 2.592e-15
Rtr_288_2881 tree_288 tree_2881 0.8192
Cp_2881 tree_2881 0 2.592e-15
Rtr_288_2882 tree_288 tree_2882 0.8192
Cp_2882 tree_2882 0 2.592e-15
Rtr_288_2883 tree_288 tree_2883 0.8192
Cp_2883 tree_2883 0 2.592e-15
Rtr_288_2884 tree_288 tree_2884 0.8192
Cp_2884 tree_2884 0 2.592e-15
Rtr_288_2885 tree_288 tree_2885 0.8192
Cp_2885 tree_2885 0 2.592e-15
Rtr_288_2886 tree_288 tree_2886 0.8192
Cp_2886 tree_2886 0 2.592e-15
Rtr_288_2887 tree_288 tree_2887 0.8192
Cp_2887 tree_2887 0 2.592e-15
Rtr_288_2888 tree_288 tree_2888 0.8192
Cp_2888 tree_2888 0 2.592e-15
Rtr_288_2889 tree_288 tree_2889 0.8192
Cp_2889 tree_2889 0 2.592e-15
Rtr_288_2890 tree_288 tree_2890 0.8192
Cp_2890 tree_2890 0 2.592e-15
Rtr_289_2891 tree_289 tree_2891 0.8192
Cp_2891 tree_2891 0 2.592e-15
Rtr_289_2892 tree_289 tree_2892 0.8192
Cp_2892 tree_2892 0 2.592e-15
Rtr_289_2893 tree_289 tree_2893 0.8192
Cp_2893 tree_2893 0 2.592e-15
Rtr_289_2894 tree_289 tree_2894 0.8192
Cp_2894 tree_2894 0 2.592e-15
Rtr_289_2895 tree_289 tree_2895 0.8192
Cp_2895 tree_2895 0 2.592e-15
Rtr_289_2896 tree_289 tree_2896 0.8192
Cp_2896 tree_2896 0 2.592e-15
Rtr_289_2897 tree_289 tree_2897 0.8192
Cp_2897 tree_2897 0 2.592e-15
Rtr_289_2898 tree_289 tree_2898 0.8192
Cp_2898 tree_2898 0 2.592e-15
Rtr_289_2899 tree_289 tree_2899 0.8192
Cp_2899 tree_2899 0 2.592e-15
Rtr_289_2900 tree_289 tree_2900 0.8192
Cp_2900 tree_2900 0 2.592e-15
Rtr_290_2901 tree_290 tree_2901 0.8192
Cp_2901 tree_2901 0 2.592e-15
Rtr_290_2902 tree_290 tree_2902 0.8192
Cp_2902 tree_2902 0 2.592e-15
Rtr_290_2903 tree_290 tree_2903 0.8192
Cp_2903 tree_2903 0 2.592e-15
Rtr_290_2904 tree_290 tree_2904 0.8192
Cp_2904 tree_2904 0 2.592e-15
Rtr_290_2905 tree_290 tree_2905 0.8192
Cp_2905 tree_2905 0 2.592e-15
Rtr_290_2906 tree_290 tree_2906 0.8192
Cp_2906 tree_2906 0 2.592e-15
Rtr_290_2907 tree_290 tree_2907 0.8192
Cp_2907 tree_2907 0 2.592e-15
Rtr_290_2908 tree_290 tree_2908 0.8192
Cp_2908 tree_2908 0 2.592e-15
Rtr_290_2909 tree_290 tree_2909 0.8192
Cp_2909 tree_2909 0 2.592e-15
Rtr_290_2910 tree_290 tree_2910 0.8192
Cp_2910 tree_2910 0 2.592e-15
Rtr_291_2911 tree_291 tree_2911 0.8192
Cp_2911 tree_2911 0 2.592e-15
Rtr_291_2912 tree_291 tree_2912 0.8192
Cp_2912 tree_2912 0 2.592e-15
Rtr_291_2913 tree_291 tree_2913 0.8192
Cp_2913 tree_2913 0 2.592e-15
Rtr_291_2914 tree_291 tree_2914 0.8192
Cp_2914 tree_2914 0 2.592e-15
Rtr_291_2915 tree_291 tree_2915 0.8192
Cp_2915 tree_2915 0 2.592e-15
Rtr_291_2916 tree_291 tree_2916 0.8192
Cp_2916 tree_2916 0 2.592e-15
Rtr_291_2917 tree_291 tree_2917 0.8192
Cp_2917 tree_2917 0 2.592e-15
Rtr_291_2918 tree_291 tree_2918 0.8192
Cp_2918 tree_2918 0 2.592e-15
Rtr_291_2919 tree_291 tree_2919 0.8192
Cp_2919 tree_2919 0 2.592e-15
Rtr_291_2920 tree_291 tree_2920 0.8192
Cp_2920 tree_2920 0 2.592e-15
Rtr_292_2921 tree_292 tree_2921 0.8192
Cp_2921 tree_2921 0 2.592e-15
Rtr_292_2922 tree_292 tree_2922 0.8192
Cp_2922 tree_2922 0 2.592e-15
Rtr_292_2923 tree_292 tree_2923 0.8192
Cp_2923 tree_2923 0 2.592e-15
Rtr_292_2924 tree_292 tree_2924 0.8192
Cp_2924 tree_2924 0 2.592e-15
Rtr_292_2925 tree_292 tree_2925 0.8192
Cp_2925 tree_2925 0 2.592e-15
Rtr_292_2926 tree_292 tree_2926 0.8192
Cp_2926 tree_2926 0 2.592e-15
Rtr_292_2927 tree_292 tree_2927 0.8192
Cp_2927 tree_2927 0 2.592e-15
Rtr_292_2928 tree_292 tree_2928 0.8192
Cp_2928 tree_2928 0 2.592e-15
Rtr_292_2929 tree_292 tree_2929 0.8192
Cp_2929 tree_2929 0 2.592e-15
Rtr_292_2930 tree_292 tree_2930 0.8192
Cp_2930 tree_2930 0 2.592e-15
Rtr_293_2931 tree_293 tree_2931 0.8192
Cp_2931 tree_2931 0 2.592e-15
Rtr_293_2932 tree_293 tree_2932 0.8192
Cp_2932 tree_2932 0 2.592e-15
Rtr_293_2933 tree_293 tree_2933 0.8192
Cp_2933 tree_2933 0 2.592e-15
Rtr_293_2934 tree_293 tree_2934 0.8192
Cp_2934 tree_2934 0 2.592e-15
Rtr_293_2935 tree_293 tree_2935 0.8192
Cp_2935 tree_2935 0 2.592e-15
Rtr_293_2936 tree_293 tree_2936 0.8192
Cp_2936 tree_2936 0 2.592e-15
Rtr_293_2937 tree_293 tree_2937 0.8192
Cp_2937 tree_2937 0 2.592e-15
Rtr_293_2938 tree_293 tree_2938 0.8192
Cp_2938 tree_2938 0 2.592e-15
Rtr_293_2939 tree_293 tree_2939 0.8192
Cp_2939 tree_2939 0 2.592e-15
Rtr_293_2940 tree_293 tree_2940 0.8192
Cp_2940 tree_2940 0 2.592e-15
Rtr_294_2941 tree_294 tree_2941 0.8192
Cp_2941 tree_2941 0 2.592e-15
Rtr_294_2942 tree_294 tree_2942 0.8192
Cp_2942 tree_2942 0 2.592e-15
Rtr_294_2943 tree_294 tree_2943 0.8192
Cp_2943 tree_2943 0 2.592e-15
Rtr_294_2944 tree_294 tree_2944 0.8192
Cp_2944 tree_2944 0 2.592e-15
Rtr_294_2945 tree_294 tree_2945 0.8192
Cp_2945 tree_2945 0 2.592e-15
Rtr_294_2946 tree_294 tree_2946 0.8192
Cp_2946 tree_2946 0 2.592e-15
Rtr_294_2947 tree_294 tree_2947 0.8192
Cp_2947 tree_2947 0 2.592e-15
Rtr_294_2948 tree_294 tree_2948 0.8192
Cp_2948 tree_2948 0 2.592e-15
Rtr_294_2949 tree_294 tree_2949 0.8192
Cp_2949 tree_2949 0 2.592e-15
Rtr_294_2950 tree_294 tree_2950 0.8192
Cp_2950 tree_2950 0 2.592e-15
Rtr_295_2951 tree_295 tree_2951 0.8192
Cp_2951 tree_2951 0 2.592e-15
Rtr_295_2952 tree_295 tree_2952 0.8192
Cp_2952 tree_2952 0 2.592e-15
Rtr_295_2953 tree_295 tree_2953 0.8192
Cp_2953 tree_2953 0 2.592e-15
Rtr_295_2954 tree_295 tree_2954 0.8192
Cp_2954 tree_2954 0 2.592e-15
Rtr_295_2955 tree_295 tree_2955 0.8192
Cp_2955 tree_2955 0 2.592e-15
Rtr_295_2956 tree_295 tree_2956 0.8192
Cp_2956 tree_2956 0 2.592e-15
Rtr_295_2957 tree_295 tree_2957 0.8192
Cp_2957 tree_2957 0 2.592e-15
Rtr_295_2958 tree_295 tree_2958 0.8192
Cp_2958 tree_2958 0 2.592e-15
Rtr_295_2959 tree_295 tree_2959 0.8192
Cp_2959 tree_2959 0 2.592e-15
Rtr_295_2960 tree_295 tree_2960 0.8192
Cp_2960 tree_2960 0 2.592e-15
Rtr_296_2961 tree_296 tree_2961 0.8192
Cp_2961 tree_2961 0 2.592e-15
Rtr_296_2962 tree_296 tree_2962 0.8192
Cp_2962 tree_2962 0 2.592e-15
Rtr_296_2963 tree_296 tree_2963 0.8192
Cp_2963 tree_2963 0 2.592e-15
Rtr_296_2964 tree_296 tree_2964 0.8192
Cp_2964 tree_2964 0 2.592e-15
Rtr_296_2965 tree_296 tree_2965 0.8192
Cp_2965 tree_2965 0 2.592e-15
Rtr_296_2966 tree_296 tree_2966 0.8192
Cp_2966 tree_2966 0 2.592e-15
Rtr_296_2967 tree_296 tree_2967 0.8192
Cp_2967 tree_2967 0 2.592e-15
Rtr_296_2968 tree_296 tree_2968 0.8192
Cp_2968 tree_2968 0 2.592e-15
Rtr_296_2969 tree_296 tree_2969 0.8192
Cp_2969 tree_2969 0 2.592e-15
Rtr_296_2970 tree_296 tree_2970 0.8192
Cp_2970 tree_2970 0 2.592e-15
Rtr_297_2971 tree_297 tree_2971 0.8192
Cp_2971 tree_2971 0 2.592e-15
Rtr_297_2972 tree_297 tree_2972 0.8192
Cp_2972 tree_2972 0 2.592e-15
Rtr_297_2973 tree_297 tree_2973 0.8192
Cp_2973 tree_2973 0 2.592e-15
Rtr_297_2974 tree_297 tree_2974 0.8192
Cp_2974 tree_2974 0 2.592e-15
Rtr_297_2975 tree_297 tree_2975 0.8192
Cp_2975 tree_2975 0 2.592e-15
Rtr_297_2976 tree_297 tree_2976 0.8192
Cp_2976 tree_2976 0 2.592e-15
Rtr_297_2977 tree_297 tree_2977 0.8192
Cp_2977 tree_2977 0 2.592e-15
Rtr_297_2978 tree_297 tree_2978 0.8192
Cp_2978 tree_2978 0 2.592e-15
Rtr_297_2979 tree_297 tree_2979 0.8192
Cp_2979 tree_2979 0 2.592e-15
Rtr_297_2980 tree_297 tree_2980 0.8192
Cp_2980 tree_2980 0 2.592e-15
Rtr_298_2981 tree_298 tree_2981 0.8192
Cp_2981 tree_2981 0 2.592e-15
Rtr_298_2982 tree_298 tree_2982 0.8192
Cp_2982 tree_2982 0 2.592e-15
Rtr_298_2983 tree_298 tree_2983 0.8192
Cp_2983 tree_2983 0 2.592e-15
Rtr_298_2984 tree_298 tree_2984 0.8192
Cp_2984 tree_2984 0 2.592e-15
Rtr_298_2985 tree_298 tree_2985 0.8192
Cp_2985 tree_2985 0 2.592e-15
Rtr_298_2986 tree_298 tree_2986 0.8192
Cp_2986 tree_2986 0 2.592e-15
Rtr_298_2987 tree_298 tree_2987 0.8192
Cp_2987 tree_2987 0 2.592e-15
Rtr_298_2988 tree_298 tree_2988 0.8192
Cp_2988 tree_2988 0 2.592e-15
Rtr_298_2989 tree_298 tree_2989 0.8192
Cp_2989 tree_2989 0 2.592e-15
Rtr_298_2990 tree_298 tree_2990 0.8192
Cp_2990 tree_2990 0 2.592e-15
Rtr_299_2991 tree_299 tree_2991 0.8192
Cp_2991 tree_2991 0 2.592e-15
Rtr_299_2992 tree_299 tree_2992 0.8192
Cp_2992 tree_2992 0 2.592e-15
Rtr_299_2993 tree_299 tree_2993 0.8192
Cp_2993 tree_2993 0 2.592e-15
Rtr_299_2994 tree_299 tree_2994 0.8192
Cp_2994 tree_2994 0 2.592e-15
Rtr_299_2995 tree_299 tree_2995 0.8192
Cp_2995 tree_2995 0 2.592e-15
Rtr_299_2996 tree_299 tree_2996 0.8192
Cp_2996 tree_2996 0 2.592e-15
Rtr_299_2997 tree_299 tree_2997 0.8192
Cp_2997 tree_2997 0 2.592e-15
Rtr_299_2998 tree_299 tree_2998 0.8192
Cp_2998 tree_2998 0 2.592e-15
Rtr_299_2999 tree_299 tree_2999 0.8192
Cp_2999 tree_2999 0 2.592e-15
Rtr_299_3000 tree_299 tree_3000 0.8192
Cp_3000 tree_3000 0 2.592e-15
Rtr_300_3001 tree_300 tree_3001 0.8192
Cp_3001 tree_3001 0 2.592e-15
Rtr_300_3002 tree_300 tree_3002 0.8192
Cp_3002 tree_3002 0 2.592e-15
Rtr_300_3003 tree_300 tree_3003 0.8192
Cp_3003 tree_3003 0 2.592e-15
Rtr_300_3004 tree_300 tree_3004 0.8192
Cp_3004 tree_3004 0 2.592e-15
Rtr_300_3005 tree_300 tree_3005 0.8192
Cp_3005 tree_3005 0 2.592e-15
Rtr_300_3006 tree_300 tree_3006 0.8192
Cp_3006 tree_3006 0 2.592e-15
Rtr_300_3007 tree_300 tree_3007 0.8192
Cp_3007 tree_3007 0 2.592e-15
Rtr_300_3008 tree_300 tree_3008 0.8192
Cp_3008 tree_3008 0 2.592e-15
Rtr_300_3009 tree_300 tree_3009 0.8192
Cp_3009 tree_3009 0 2.592e-15
Rtr_300_3010 tree_300 tree_3010 0.8192
Cp_3010 tree_3010 0 2.592e-15
Rtr_301_3011 tree_301 tree_3011 0.8192
Cp_3011 tree_3011 0 2.592e-15
Rtr_301_3012 tree_301 tree_3012 0.8192
Cp_3012 tree_3012 0 2.592e-15
Rtr_301_3013 tree_301 tree_3013 0.8192
Cp_3013 tree_3013 0 2.592e-15
Rtr_301_3014 tree_301 tree_3014 0.8192
Cp_3014 tree_3014 0 2.592e-15
Rtr_301_3015 tree_301 tree_3015 0.8192
Cp_3015 tree_3015 0 2.592e-15
Rtr_301_3016 tree_301 tree_3016 0.8192
Cp_3016 tree_3016 0 2.592e-15
Rtr_301_3017 tree_301 tree_3017 0.8192
Cp_3017 tree_3017 0 2.592e-15
Rtr_301_3018 tree_301 tree_3018 0.8192
Cp_3018 tree_3018 0 2.592e-15
Rtr_301_3019 tree_301 tree_3019 0.8192
Cp_3019 tree_3019 0 2.592e-15
Rtr_301_3020 tree_301 tree_3020 0.8192
Cp_3020 tree_3020 0 2.592e-15
Rtr_302_3021 tree_302 tree_3021 0.8192
Cp_3021 tree_3021 0 2.592e-15
Rtr_302_3022 tree_302 tree_3022 0.8192
Cp_3022 tree_3022 0 2.592e-15
Rtr_302_3023 tree_302 tree_3023 0.8192
Cp_3023 tree_3023 0 2.592e-15
Rtr_302_3024 tree_302 tree_3024 0.8192
Cp_3024 tree_3024 0 2.592e-15
Rtr_302_3025 tree_302 tree_3025 0.8192
Cp_3025 tree_3025 0 2.592e-15
Rtr_302_3026 tree_302 tree_3026 0.8192
Cp_3026 tree_3026 0 2.592e-15
Rtr_302_3027 tree_302 tree_3027 0.8192
Cp_3027 tree_3027 0 2.592e-15
Rtr_302_3028 tree_302 tree_3028 0.8192
Cp_3028 tree_3028 0 2.592e-15
Rtr_302_3029 tree_302 tree_3029 0.8192
Cp_3029 tree_3029 0 2.592e-15
Rtr_302_3030 tree_302 tree_3030 0.8192
Cp_3030 tree_3030 0 2.592e-15
Rtr_303_3031 tree_303 tree_3031 0.8192
Cp_3031 tree_3031 0 2.592e-15
Rtr_303_3032 tree_303 tree_3032 0.8192
Cp_3032 tree_3032 0 2.592e-15
Rtr_303_3033 tree_303 tree_3033 0.8192
Cp_3033 tree_3033 0 2.592e-15
Rtr_303_3034 tree_303 tree_3034 0.8192
Cp_3034 tree_3034 0 2.592e-15
Rtr_303_3035 tree_303 tree_3035 0.8192
Cp_3035 tree_3035 0 2.592e-15
Rtr_303_3036 tree_303 tree_3036 0.8192
Cp_3036 tree_3036 0 2.592e-15
Rtr_303_3037 tree_303 tree_3037 0.8192
Cp_3037 tree_3037 0 2.592e-15
Rtr_303_3038 tree_303 tree_3038 0.8192
Cp_3038 tree_3038 0 2.592e-15
Rtr_303_3039 tree_303 tree_3039 0.8192
Cp_3039 tree_3039 0 2.592e-15
Rtr_303_3040 tree_303 tree_3040 0.8192
Cp_3040 tree_3040 0 2.592e-15
Rtr_304_3041 tree_304 tree_3041 0.8192
Cp_3041 tree_3041 0 2.592e-15
Rtr_304_3042 tree_304 tree_3042 0.8192
Cp_3042 tree_3042 0 2.592e-15
Rtr_304_3043 tree_304 tree_3043 0.8192
Cp_3043 tree_3043 0 2.592e-15
Rtr_304_3044 tree_304 tree_3044 0.8192
Cp_3044 tree_3044 0 2.592e-15
Rtr_304_3045 tree_304 tree_3045 0.8192
Cp_3045 tree_3045 0 2.592e-15
Rtr_304_3046 tree_304 tree_3046 0.8192
Cp_3046 tree_3046 0 2.592e-15
Rtr_304_3047 tree_304 tree_3047 0.8192
Cp_3047 tree_3047 0 2.592e-15
Rtr_304_3048 tree_304 tree_3048 0.8192
Cp_3048 tree_3048 0 2.592e-15
Rtr_304_3049 tree_304 tree_3049 0.8192
Cp_3049 tree_3049 0 2.592e-15
Rtr_304_3050 tree_304 tree_3050 0.8192
Cp_3050 tree_3050 0 2.592e-15
Rtr_305_3051 tree_305 tree_3051 0.8192
Cp_3051 tree_3051 0 2.592e-15
Rtr_305_3052 tree_305 tree_3052 0.8192
Cp_3052 tree_3052 0 2.592e-15
Rtr_305_3053 tree_305 tree_3053 0.8192
Cp_3053 tree_3053 0 2.592e-15
Rtr_305_3054 tree_305 tree_3054 0.8192
Cp_3054 tree_3054 0 2.592e-15
Rtr_305_3055 tree_305 tree_3055 0.8192
Cp_3055 tree_3055 0 2.592e-15
Rtr_305_3056 tree_305 tree_3056 0.8192
Cp_3056 tree_3056 0 2.592e-15
Rtr_305_3057 tree_305 tree_3057 0.8192
Cp_3057 tree_3057 0 2.592e-15
Rtr_305_3058 tree_305 tree_3058 0.8192
Cp_3058 tree_3058 0 2.592e-15
Rtr_305_3059 tree_305 tree_3059 0.8192
Cp_3059 tree_3059 0 2.592e-15
Rtr_305_3060 tree_305 tree_3060 0.8192
Cp_3060 tree_3060 0 2.592e-15
Rtr_306_3061 tree_306 tree_3061 0.8192
Cp_3061 tree_3061 0 2.592e-15
Rtr_306_3062 tree_306 tree_3062 0.8192
Cp_3062 tree_3062 0 2.592e-15
Rtr_306_3063 tree_306 tree_3063 0.8192
Cp_3063 tree_3063 0 2.592e-15
Rtr_306_3064 tree_306 tree_3064 0.8192
Cp_3064 tree_3064 0 2.592e-15
Rtr_306_3065 tree_306 tree_3065 0.8192
Cp_3065 tree_3065 0 2.592e-15
Rtr_306_3066 tree_306 tree_3066 0.8192
Cp_3066 tree_3066 0 2.592e-15
Rtr_306_3067 tree_306 tree_3067 0.8192
Cp_3067 tree_3067 0 2.592e-15
Rtr_306_3068 tree_306 tree_3068 0.8192
Cp_3068 tree_3068 0 2.592e-15
Rtr_306_3069 tree_306 tree_3069 0.8192
Cp_3069 tree_3069 0 2.592e-15
Rtr_306_3070 tree_306 tree_3070 0.8192
Cp_3070 tree_3070 0 2.592e-15
Rtr_307_3071 tree_307 tree_3071 0.8192
Cp_3071 tree_3071 0 2.592e-15
Rtr_307_3072 tree_307 tree_3072 0.8192
Cp_3072 tree_3072 0 2.592e-15
Rtr_307_3073 tree_307 tree_3073 0.8192
Cp_3073 tree_3073 0 2.592e-15
Rtr_307_3074 tree_307 tree_3074 0.8192
Cp_3074 tree_3074 0 2.592e-15
Rtr_307_3075 tree_307 tree_3075 0.8192
Cp_3075 tree_3075 0 2.592e-15
Rtr_307_3076 tree_307 tree_3076 0.8192
Cp_3076 tree_3076 0 2.592e-15
Rtr_307_3077 tree_307 tree_3077 0.8192
Cp_3077 tree_3077 0 2.592e-15
Rtr_307_3078 tree_307 tree_3078 0.8192
Cp_3078 tree_3078 0 2.592e-15
Rtr_307_3079 tree_307 tree_3079 0.8192
Cp_3079 tree_3079 0 2.592e-15
Rtr_307_3080 tree_307 tree_3080 0.8192
Cp_3080 tree_3080 0 2.592e-15
Rtr_308_3081 tree_308 tree_3081 0.8192
Cp_3081 tree_3081 0 2.592e-15
Rtr_308_3082 tree_308 tree_3082 0.8192
Cp_3082 tree_3082 0 2.592e-15
Rtr_308_3083 tree_308 tree_3083 0.8192
Cp_3083 tree_3083 0 2.592e-15
Rtr_308_3084 tree_308 tree_3084 0.8192
Cp_3084 tree_3084 0 2.592e-15
Rtr_308_3085 tree_308 tree_3085 0.8192
Cp_3085 tree_3085 0 2.592e-15
Rtr_308_3086 tree_308 tree_3086 0.8192
Cp_3086 tree_3086 0 2.592e-15
Rtr_308_3087 tree_308 tree_3087 0.8192
Cp_3087 tree_3087 0 2.592e-15
Rtr_308_3088 tree_308 tree_3088 0.8192
Cp_3088 tree_3088 0 2.592e-15
Rtr_308_3089 tree_308 tree_3089 0.8192
Cp_3089 tree_3089 0 2.592e-15
Rtr_308_3090 tree_308 tree_3090 0.8192
Cp_3090 tree_3090 0 2.592e-15
Rtr_309_3091 tree_309 tree_3091 0.8192
Cp_3091 tree_3091 0 2.592e-15
Rtr_309_3092 tree_309 tree_3092 0.8192
Cp_3092 tree_3092 0 2.592e-15
Rtr_309_3093 tree_309 tree_3093 0.8192
Cp_3093 tree_3093 0 2.592e-15
Rtr_309_3094 tree_309 tree_3094 0.8192
Cp_3094 tree_3094 0 2.592e-15
Rtr_309_3095 tree_309 tree_3095 0.8192
Cp_3095 tree_3095 0 2.592e-15
Rtr_309_3096 tree_309 tree_3096 0.8192
Cp_3096 tree_3096 0 2.592e-15
Rtr_309_3097 tree_309 tree_3097 0.8192
Cp_3097 tree_3097 0 2.592e-15
Rtr_309_3098 tree_309 tree_3098 0.8192
Cp_3098 tree_3098 0 2.592e-15
Rtr_309_3099 tree_309 tree_3099 0.8192
Cp_3099 tree_3099 0 2.592e-15
Rtr_309_3100 tree_309 tree_3100 0.8192
Cp_3100 tree_3100 0 2.592e-15
Rtr_310_3101 tree_310 tree_3101 0.8192
Cp_3101 tree_3101 0 2.592e-15
Rtr_310_3102 tree_310 tree_3102 0.8192
Cp_3102 tree_3102 0 2.592e-15
Rtr_310_3103 tree_310 tree_3103 0.8192
Cp_3103 tree_3103 0 2.592e-15
Rtr_310_3104 tree_310 tree_3104 0.8192
Cp_3104 tree_3104 0 2.592e-15
Rtr_310_3105 tree_310 tree_3105 0.8192
Cp_3105 tree_3105 0 2.592e-15
Rtr_310_3106 tree_310 tree_3106 0.8192
Cp_3106 tree_3106 0 2.592e-15
Rtr_310_3107 tree_310 tree_3107 0.8192
Cp_3107 tree_3107 0 2.592e-15
Rtr_310_3108 tree_310 tree_3108 0.8192
Cp_3108 tree_3108 0 2.592e-15
Rtr_310_3109 tree_310 tree_3109 0.8192
Cp_3109 tree_3109 0 2.592e-15
Rtr_310_3110 tree_310 tree_3110 0.8192
Cp_3110 tree_3110 0 2.592e-15
Rtr_311_3111 tree_311 tree_3111 0.8192
Cp_3111 tree_3111 0 2.592e-15
Rtr_311_3112 tree_311 tree_3112 0.8192
Cp_3112 tree_3112 0 2.592e-15
Rtr_311_3113 tree_311 tree_3113 0.8192
Cp_3113 tree_3113 0 2.592e-15
Rtr_311_3114 tree_311 tree_3114 0.8192
Cp_3114 tree_3114 0 2.592e-15
Rtr_311_3115 tree_311 tree_3115 0.8192
Cp_3115 tree_3115 0 2.592e-15
Rtr_311_3116 tree_311 tree_3116 0.8192
Cp_3116 tree_3116 0 2.592e-15
Rtr_311_3117 tree_311 tree_3117 0.8192
Cp_3117 tree_3117 0 2.592e-15
Rtr_311_3118 tree_311 tree_3118 0.8192
Cp_3118 tree_3118 0 2.592e-15
Rtr_311_3119 tree_311 tree_3119 0.8192
Cp_3119 tree_3119 0 2.592e-15
Rtr_311_3120 tree_311 tree_3120 0.8192
Cp_3120 tree_3120 0 2.592e-15
Rtr_312_3121 tree_312 tree_3121 0.8192
Cp_3121 tree_3121 0 2.592e-15
Rtr_312_3122 tree_312 tree_3122 0.8192
Cp_3122 tree_3122 0 2.592e-15
Rtr_312_3123 tree_312 tree_3123 0.8192
Cp_3123 tree_3123 0 2.592e-15
Rtr_312_3124 tree_312 tree_3124 0.8192
Cp_3124 tree_3124 0 2.592e-15
Rtr_312_3125 tree_312 tree_3125 0.8192
Cp_3125 tree_3125 0 2.592e-15
Rtr_312_3126 tree_312 tree_3126 0.8192
Cp_3126 tree_3126 0 2.592e-15
Rtr_312_3127 tree_312 tree_3127 0.8192
Cp_3127 tree_3127 0 2.592e-15
Rtr_312_3128 tree_312 tree_3128 0.8192
Cp_3128 tree_3128 0 2.592e-15
Rtr_312_3129 tree_312 tree_3129 0.8192
Cp_3129 tree_3129 0 2.592e-15
Rtr_312_3130 tree_312 tree_3130 0.8192
Cp_3130 tree_3130 0 2.592e-15
Rtr_313_3131 tree_313 tree_3131 0.8192
Cp_3131 tree_3131 0 2.592e-15
Rtr_313_3132 tree_313 tree_3132 0.8192
Cp_3132 tree_3132 0 2.592e-15
Rtr_313_3133 tree_313 tree_3133 0.8192
Cp_3133 tree_3133 0 2.592e-15
Rtr_313_3134 tree_313 tree_3134 0.8192
Cp_3134 tree_3134 0 2.592e-15
Rtr_313_3135 tree_313 tree_3135 0.8192
Cp_3135 tree_3135 0 2.592e-15
Rtr_313_3136 tree_313 tree_3136 0.8192
Cp_3136 tree_3136 0 2.592e-15
Rtr_313_3137 tree_313 tree_3137 0.8192
Cp_3137 tree_3137 0 2.592e-15
Rtr_313_3138 tree_313 tree_3138 0.8192
Cp_3138 tree_3138 0 2.592e-15
Rtr_313_3139 tree_313 tree_3139 0.8192
Cp_3139 tree_3139 0 2.592e-15
Rtr_313_3140 tree_313 tree_3140 0.8192
Cp_3140 tree_3140 0 2.592e-15
Rtr_314_3141 tree_314 tree_3141 0.8192
Cp_3141 tree_3141 0 2.592e-15
Rtr_314_3142 tree_314 tree_3142 0.8192
Cp_3142 tree_3142 0 2.592e-15
Rtr_314_3143 tree_314 tree_3143 0.8192
Cp_3143 tree_3143 0 2.592e-15
Rtr_314_3144 tree_314 tree_3144 0.8192
Cp_3144 tree_3144 0 2.592e-15
Rtr_314_3145 tree_314 tree_3145 0.8192
Cp_3145 tree_3145 0 2.592e-15
Rtr_314_3146 tree_314 tree_3146 0.8192
Cp_3146 tree_3146 0 2.592e-15
Rtr_314_3147 tree_314 tree_3147 0.8192
Cp_3147 tree_3147 0 2.592e-15
Rtr_314_3148 tree_314 tree_3148 0.8192
Cp_3148 tree_3148 0 2.592e-15
Rtr_314_3149 tree_314 tree_3149 0.8192
Cp_3149 tree_3149 0 2.592e-15
Rtr_314_3150 tree_314 tree_3150 0.8192
Cp_3150 tree_3150 0 2.592e-15
Rtr_315_3151 tree_315 tree_3151 0.8192
Cp_3151 tree_3151 0 2.592e-15
Rtr_315_3152 tree_315 tree_3152 0.8192
Cp_3152 tree_3152 0 2.592e-15
Rtr_315_3153 tree_315 tree_3153 0.8192
Cp_3153 tree_3153 0 2.592e-15
Rtr_315_3154 tree_315 tree_3154 0.8192
Cp_3154 tree_3154 0 2.592e-15
Rtr_315_3155 tree_315 tree_3155 0.8192
Cp_3155 tree_3155 0 2.592e-15
Rtr_315_3156 tree_315 tree_3156 0.8192
Cp_3156 tree_3156 0 2.592e-15
Rtr_315_3157 tree_315 tree_3157 0.8192
Cp_3157 tree_3157 0 2.592e-15
Rtr_315_3158 tree_315 tree_3158 0.8192
Cp_3158 tree_3158 0 2.592e-15
Rtr_315_3159 tree_315 tree_3159 0.8192
Cp_3159 tree_3159 0 2.592e-15
Rtr_315_3160 tree_315 tree_3160 0.8192
Cp_3160 tree_3160 0 2.592e-15
Rtr_316_3161 tree_316 tree_3161 0.8192
Cp_3161 tree_3161 0 2.592e-15
Rtr_316_3162 tree_316 tree_3162 0.8192
Cp_3162 tree_3162 0 2.592e-15
Rtr_316_3163 tree_316 tree_3163 0.8192
Cp_3163 tree_3163 0 2.592e-15
Rtr_316_3164 tree_316 tree_3164 0.8192
Cp_3164 tree_3164 0 2.592e-15
Rtr_316_3165 tree_316 tree_3165 0.8192
Cp_3165 tree_3165 0 2.592e-15
Rtr_316_3166 tree_316 tree_3166 0.8192
Cp_3166 tree_3166 0 2.592e-15
Rtr_316_3167 tree_316 tree_3167 0.8192
Cp_3167 tree_3167 0 2.592e-15
Rtr_316_3168 tree_316 tree_3168 0.8192
Cp_3168 tree_3168 0 2.592e-15
Rtr_316_3169 tree_316 tree_3169 0.8192
Cp_3169 tree_3169 0 2.592e-15
Rtr_316_3170 tree_316 tree_3170 0.8192
Cp_3170 tree_3170 0 2.592e-15
Rtr_317_3171 tree_317 tree_3171 0.8192
Cp_3171 tree_3171 0 2.592e-15
Rtr_317_3172 tree_317 tree_3172 0.8192
Cp_3172 tree_3172 0 2.592e-15
Rtr_317_3173 tree_317 tree_3173 0.8192
Cp_3173 tree_3173 0 2.592e-15
Rtr_317_3174 tree_317 tree_3174 0.8192
Cp_3174 tree_3174 0 2.592e-15
Rtr_317_3175 tree_317 tree_3175 0.8192
Cp_3175 tree_3175 0 2.592e-15
Rtr_317_3176 tree_317 tree_3176 0.8192
Cp_3176 tree_3176 0 2.592e-15
Rtr_317_3177 tree_317 tree_3177 0.8192
Cp_3177 tree_3177 0 2.592e-15
Rtr_317_3178 tree_317 tree_3178 0.8192
Cp_3178 tree_3178 0 2.592e-15
Rtr_317_3179 tree_317 tree_3179 0.8192
Cp_3179 tree_3179 0 2.592e-15
Rtr_317_3180 tree_317 tree_3180 0.8192
Cp_3180 tree_3180 0 2.592e-15
Rtr_318_3181 tree_318 tree_3181 0.8192
Cp_3181 tree_3181 0 2.592e-15
Rtr_318_3182 tree_318 tree_3182 0.8192
Cp_3182 tree_3182 0 2.592e-15
Rtr_318_3183 tree_318 tree_3183 0.8192
Cp_3183 tree_3183 0 2.592e-15
Rtr_318_3184 tree_318 tree_3184 0.8192
Cp_3184 tree_3184 0 2.592e-15
Rtr_318_3185 tree_318 tree_3185 0.8192
Cp_3185 tree_3185 0 2.592e-15
Rtr_318_3186 tree_318 tree_3186 0.8192
Cp_3186 tree_3186 0 2.592e-15
Rtr_318_3187 tree_318 tree_3187 0.8192
Cp_3187 tree_3187 0 2.592e-15
Rtr_318_3188 tree_318 tree_3188 0.8192
Cp_3188 tree_3188 0 2.592e-15
Rtr_318_3189 tree_318 tree_3189 0.8192
Cp_3189 tree_3189 0 2.592e-15
Rtr_318_3190 tree_318 tree_3190 0.8192
Cp_3190 tree_3190 0 2.592e-15
Rtr_319_3191 tree_319 tree_3191 0.8192
Cp_3191 tree_3191 0 2.592e-15
Rtr_319_3192 tree_319 tree_3192 0.8192
Cp_3192 tree_3192 0 2.592e-15
Rtr_319_3193 tree_319 tree_3193 0.8192
Cp_3193 tree_3193 0 2.592e-15
Rtr_319_3194 tree_319 tree_3194 0.8192
Cp_3194 tree_3194 0 2.592e-15
Rtr_319_3195 tree_319 tree_3195 0.8192
Cp_3195 tree_3195 0 2.592e-15
Rtr_319_3196 tree_319 tree_3196 0.8192
Cp_3196 tree_3196 0 2.592e-15
Rtr_319_3197 tree_319 tree_3197 0.8192
Cp_3197 tree_3197 0 2.592e-15
Rtr_319_3198 tree_319 tree_3198 0.8192
Cp_3198 tree_3198 0 2.592e-15
Rtr_319_3199 tree_319 tree_3199 0.8192
Cp_3199 tree_3199 0 2.592e-15
Rtr_319_3200 tree_319 tree_3200 0.8192
Cp_3200 tree_3200 0 2.592e-15
Rtr_320_3201 tree_320 tree_3201 0.8192
Cp_3201 tree_3201 0 2.592e-15
Rtr_320_3202 tree_320 tree_3202 0.8192
Cp_3202 tree_3202 0 2.592e-15
Rtr_320_3203 tree_320 tree_3203 0.8192
Cp_3203 tree_3203 0 2.592e-15
Rtr_320_3204 tree_320 tree_3204 0.8192
Cp_3204 tree_3204 0 2.592e-15
Rtr_320_3205 tree_320 tree_3205 0.8192
Cp_3205 tree_3205 0 2.592e-15
Rtr_320_3206 tree_320 tree_3206 0.8192
Cp_3206 tree_3206 0 2.592e-15
Rtr_320_3207 tree_320 tree_3207 0.8192
Cp_3207 tree_3207 0 2.592e-15
Rtr_320_3208 tree_320 tree_3208 0.8192
Cp_3208 tree_3208 0 2.592e-15
Rtr_320_3209 tree_320 tree_3209 0.8192
Cp_3209 tree_3209 0 2.592e-15
Rtr_320_3210 tree_320 tree_3210 0.8192
Cp_3210 tree_3210 0 2.592e-15
Rtr_321_3211 tree_321 tree_3211 0.8192
Cp_3211 tree_3211 0 2.592e-15
Rtr_321_3212 tree_321 tree_3212 0.8192
Cp_3212 tree_3212 0 2.592e-15
Rtr_321_3213 tree_321 tree_3213 0.8192
Cp_3213 tree_3213 0 2.592e-15
Rtr_321_3214 tree_321 tree_3214 0.8192
Cp_3214 tree_3214 0 2.592e-15
Rtr_321_3215 tree_321 tree_3215 0.8192
Cp_3215 tree_3215 0 2.592e-15
Rtr_321_3216 tree_321 tree_3216 0.8192
Cp_3216 tree_3216 0 2.592e-15
Rtr_321_3217 tree_321 tree_3217 0.8192
Cp_3217 tree_3217 0 2.592e-15
Rtr_321_3218 tree_321 tree_3218 0.8192
Cp_3218 tree_3218 0 2.592e-15
Rtr_321_3219 tree_321 tree_3219 0.8192
Cp_3219 tree_3219 0 2.592e-15
Rtr_321_3220 tree_321 tree_3220 0.8192
Cp_3220 tree_3220 0 2.592e-15
Rtr_322_3221 tree_322 tree_3221 0.8192
Cp_3221 tree_3221 0 2.592e-15
Rtr_322_3222 tree_322 tree_3222 0.8192
Cp_3222 tree_3222 0 2.592e-15
Rtr_322_3223 tree_322 tree_3223 0.8192
Cp_3223 tree_3223 0 2.592e-15
Rtr_322_3224 tree_322 tree_3224 0.8192
Cp_3224 tree_3224 0 2.592e-15
Rtr_322_3225 tree_322 tree_3225 0.8192
Cp_3225 tree_3225 0 2.592e-15
Rtr_322_3226 tree_322 tree_3226 0.8192
Cp_3226 tree_3226 0 2.592e-15
Rtr_322_3227 tree_322 tree_3227 0.8192
Cp_3227 tree_3227 0 2.592e-15
Rtr_322_3228 tree_322 tree_3228 0.8192
Cp_3228 tree_3228 0 2.592e-15
Rtr_322_3229 tree_322 tree_3229 0.8192
Cp_3229 tree_3229 0 2.592e-15
Rtr_322_3230 tree_322 tree_3230 0.8192
Cp_3230 tree_3230 0 2.592e-15
Rtr_323_3231 tree_323 tree_3231 0.8192
Cp_3231 tree_3231 0 2.592e-15
Rtr_323_3232 tree_323 tree_3232 0.8192
Cp_3232 tree_3232 0 2.592e-15
Rtr_323_3233 tree_323 tree_3233 0.8192
Cp_3233 tree_3233 0 2.592e-15
Rtr_323_3234 tree_323 tree_3234 0.8192
Cp_3234 tree_3234 0 2.592e-15
Rtr_323_3235 tree_323 tree_3235 0.8192
Cp_3235 tree_3235 0 2.592e-15
Rtr_323_3236 tree_323 tree_3236 0.8192
Cp_3236 tree_3236 0 2.592e-15
Rtr_323_3237 tree_323 tree_3237 0.8192
Cp_3237 tree_3237 0 2.592e-15
Rtr_323_3238 tree_323 tree_3238 0.8192
Cp_3238 tree_3238 0 2.592e-15
Rtr_323_3239 tree_323 tree_3239 0.8192
Cp_3239 tree_3239 0 2.592e-15
Rtr_323_3240 tree_323 tree_3240 0.8192
Cp_3240 tree_3240 0 2.592e-15
Rtr_324_3241 tree_324 tree_3241 0.8192
Cp_3241 tree_3241 0 2.592e-15
Rtr_324_3242 tree_324 tree_3242 0.8192
Cp_3242 tree_3242 0 2.592e-15
Rtr_324_3243 tree_324 tree_3243 0.8192
Cp_3243 tree_3243 0 2.592e-15
Rtr_324_3244 tree_324 tree_3244 0.8192
Cp_3244 tree_3244 0 2.592e-15
Rtr_324_3245 tree_324 tree_3245 0.8192
Cp_3245 tree_3245 0 2.592e-15
Rtr_324_3246 tree_324 tree_3246 0.8192
Cp_3246 tree_3246 0 2.592e-15
Rtr_324_3247 tree_324 tree_3247 0.8192
Cp_3247 tree_3247 0 2.592e-15
Rtr_324_3248 tree_324 tree_3248 0.8192
Cp_3248 tree_3248 0 2.592e-15
Rtr_324_3249 tree_324 tree_3249 0.8192
Cp_3249 tree_3249 0 2.592e-15
Rtr_324_3250 tree_324 tree_3250 0.8192
Cp_3250 tree_3250 0 2.592e-15
Rtr_325_3251 tree_325 tree_3251 0.8192
Cp_3251 tree_3251 0 2.592e-15
Rtr_325_3252 tree_325 tree_3252 0.8192
Cp_3252 tree_3252 0 2.592e-15
Rtr_325_3253 tree_325 tree_3253 0.8192
Cp_3253 tree_3253 0 2.592e-15
Rtr_325_3254 tree_325 tree_3254 0.8192
Cp_3254 tree_3254 0 2.592e-15
Rtr_325_3255 tree_325 tree_3255 0.8192
Cp_3255 tree_3255 0 2.592e-15
Rtr_325_3256 tree_325 tree_3256 0.8192
Cp_3256 tree_3256 0 2.592e-15
Rtr_325_3257 tree_325 tree_3257 0.8192
Cp_3257 tree_3257 0 2.592e-15
Rtr_325_3258 tree_325 tree_3258 0.8192
Cp_3258 tree_3258 0 2.592e-15
Rtr_325_3259 tree_325 tree_3259 0.8192
Cp_3259 tree_3259 0 2.592e-15
Rtr_325_3260 tree_325 tree_3260 0.8192
Cp_3260 tree_3260 0 2.592e-15
Rtr_326_3261 tree_326 tree_3261 0.8192
Cp_3261 tree_3261 0 2.592e-15
Rtr_326_3262 tree_326 tree_3262 0.8192
Cp_3262 tree_3262 0 2.592e-15
Rtr_326_3263 tree_326 tree_3263 0.8192
Cp_3263 tree_3263 0 2.592e-15
Rtr_326_3264 tree_326 tree_3264 0.8192
Cp_3264 tree_3264 0 2.592e-15
Rtr_326_3265 tree_326 tree_3265 0.8192
Cp_3265 tree_3265 0 2.592e-15
Rtr_326_3266 tree_326 tree_3266 0.8192
Cp_3266 tree_3266 0 2.592e-15
Rtr_326_3267 tree_326 tree_3267 0.8192
Cp_3267 tree_3267 0 2.592e-15
Rtr_326_3268 tree_326 tree_3268 0.8192
Cp_3268 tree_3268 0 2.592e-15
Rtr_326_3269 tree_326 tree_3269 0.8192
Cp_3269 tree_3269 0 2.592e-15
Rtr_326_3270 tree_326 tree_3270 0.8192
Cp_3270 tree_3270 0 2.592e-15
Rtr_327_3271 tree_327 tree_3271 0.8192
Cp_3271 tree_3271 0 2.592e-15
Rtr_327_3272 tree_327 tree_3272 0.8192
Cp_3272 tree_3272 0 2.592e-15
Rtr_327_3273 tree_327 tree_3273 0.8192
Cp_3273 tree_3273 0 2.592e-15
Rtr_327_3274 tree_327 tree_3274 0.8192
Cp_3274 tree_3274 0 2.592e-15
Rtr_327_3275 tree_327 tree_3275 0.8192
Cp_3275 tree_3275 0 2.592e-15
Rtr_327_3276 tree_327 tree_3276 0.8192
Cp_3276 tree_3276 0 2.592e-15
Rtr_327_3277 tree_327 tree_3277 0.8192
Cp_3277 tree_3277 0 2.592e-15
Rtr_327_3278 tree_327 tree_3278 0.8192
Cp_3278 tree_3278 0 2.592e-15
Rtr_327_3279 tree_327 tree_3279 0.8192
Cp_3279 tree_3279 0 2.592e-15
Rtr_327_3280 tree_327 tree_3280 0.8192
Cp_3280 tree_3280 0 2.592e-15
Rtr_328_3281 tree_328 tree_3281 0.8192
Cp_3281 tree_3281 0 2.592e-15
Rtr_328_3282 tree_328 tree_3282 0.8192
Cp_3282 tree_3282 0 2.592e-15
Rtr_328_3283 tree_328 tree_3283 0.8192
Cp_3283 tree_3283 0 2.592e-15
Rtr_328_3284 tree_328 tree_3284 0.8192
Cp_3284 tree_3284 0 2.592e-15
Rtr_328_3285 tree_328 tree_3285 0.8192
Cp_3285 tree_3285 0 2.592e-15
Rtr_328_3286 tree_328 tree_3286 0.8192
Cp_3286 tree_3286 0 2.592e-15
Rtr_328_3287 tree_328 tree_3287 0.8192
Cp_3287 tree_3287 0 2.592e-15
Rtr_328_3288 tree_328 tree_3288 0.8192
Cp_3288 tree_3288 0 2.592e-15
Rtr_328_3289 tree_328 tree_3289 0.8192
Cp_3289 tree_3289 0 2.592e-15
Rtr_328_3290 tree_328 tree_3290 0.8192
Cp_3290 tree_3290 0 2.592e-15
Rtr_329_3291 tree_329 tree_3291 0.8192
Cp_3291 tree_3291 0 2.592e-15
Rtr_329_3292 tree_329 tree_3292 0.8192
Cp_3292 tree_3292 0 2.592e-15
Rtr_329_3293 tree_329 tree_3293 0.8192
Cp_3293 tree_3293 0 2.592e-15
Rtr_329_3294 tree_329 tree_3294 0.8192
Cp_3294 tree_3294 0 2.592e-15
Rtr_329_3295 tree_329 tree_3295 0.8192
Cp_3295 tree_3295 0 2.592e-15
Rtr_329_3296 tree_329 tree_3296 0.8192
Cp_3296 tree_3296 0 2.592e-15
Rtr_329_3297 tree_329 tree_3297 0.8192
Cp_3297 tree_3297 0 2.592e-15
Rtr_329_3298 tree_329 tree_3298 0.8192
Cp_3298 tree_3298 0 2.592e-15
Rtr_329_3299 tree_329 tree_3299 0.8192
Cp_3299 tree_3299 0 2.592e-15
Rtr_329_3300 tree_329 tree_3300 0.8192
Cp_3300 tree_3300 0 2.592e-15
Rtr_330_3301 tree_330 tree_3301 0.8192
Cp_3301 tree_3301 0 2.592e-15
Rtr_330_3302 tree_330 tree_3302 0.8192
Cp_3302 tree_3302 0 2.592e-15
Rtr_330_3303 tree_330 tree_3303 0.8192
Cp_3303 tree_3303 0 2.592e-15
Rtr_330_3304 tree_330 tree_3304 0.8192
Cp_3304 tree_3304 0 2.592e-15
Rtr_330_3305 tree_330 tree_3305 0.8192
Cp_3305 tree_3305 0 2.592e-15
Rtr_330_3306 tree_330 tree_3306 0.8192
Cp_3306 tree_3306 0 2.592e-15
Rtr_330_3307 tree_330 tree_3307 0.8192
Cp_3307 tree_3307 0 2.592e-15
Rtr_330_3308 tree_330 tree_3308 0.8192
Cp_3308 tree_3308 0 2.592e-15
Rtr_330_3309 tree_330 tree_3309 0.8192
Cp_3309 tree_3309 0 2.592e-15
Rtr_330_3310 tree_330 tree_3310 0.8192
Cp_3310 tree_3310 0 2.592e-15
Rtr_331_3311 tree_331 tree_3311 0.8192
Cp_3311 tree_3311 0 2.592e-15
Rtr_331_3312 tree_331 tree_3312 0.8192
Cp_3312 tree_3312 0 2.592e-15
Rtr_331_3313 tree_331 tree_3313 0.8192
Cp_3313 tree_3313 0 2.592e-15
Rtr_331_3314 tree_331 tree_3314 0.8192
Cp_3314 tree_3314 0 2.592e-15
Rtr_331_3315 tree_331 tree_3315 0.8192
Cp_3315 tree_3315 0 2.592e-15
Rtr_331_3316 tree_331 tree_3316 0.8192
Cp_3316 tree_3316 0 2.592e-15
Rtr_331_3317 tree_331 tree_3317 0.8192
Cp_3317 tree_3317 0 2.592e-15
Rtr_331_3318 tree_331 tree_3318 0.8192
Cp_3318 tree_3318 0 2.592e-15
Rtr_331_3319 tree_331 tree_3319 0.8192
Cp_3319 tree_3319 0 2.592e-15
Rtr_331_3320 tree_331 tree_3320 0.8192
Cp_3320 tree_3320 0 2.592e-15
Rtr_332_3321 tree_332 tree_3321 0.8192
Cp_3321 tree_3321 0 2.592e-15
Rtr_332_3322 tree_332 tree_3322 0.8192
Cp_3322 tree_3322 0 2.592e-15
Rtr_332_3323 tree_332 tree_3323 0.8192
Cp_3323 tree_3323 0 2.592e-15
Rtr_332_3324 tree_332 tree_3324 0.8192
Cp_3324 tree_3324 0 2.592e-15
Rtr_332_3325 tree_332 tree_3325 0.8192
Cp_3325 tree_3325 0 2.592e-15
Rtr_332_3326 tree_332 tree_3326 0.8192
Cp_3326 tree_3326 0 2.592e-15
Rtr_332_3327 tree_332 tree_3327 0.8192
Cp_3327 tree_3327 0 2.592e-15
Rtr_332_3328 tree_332 tree_3328 0.8192
Cp_3328 tree_3328 0 2.592e-15
Rtr_332_3329 tree_332 tree_3329 0.8192
Cp_3329 tree_3329 0 2.592e-15
Rtr_332_3330 tree_332 tree_3330 0.8192
Cp_3330 tree_3330 0 2.592e-15
Rtr_333_3331 tree_333 tree_3331 0.8192
Cp_3331 tree_3331 0 2.592e-15
Rtr_333_3332 tree_333 tree_3332 0.8192
Cp_3332 tree_3332 0 2.592e-15
Rtr_333_3333 tree_333 tree_3333 0.8192
Cp_3333 tree_3333 0 2.592e-15
Rtr_333_3334 tree_333 tree_3334 0.8192
Cp_3334 tree_3334 0 2.592e-15
Rtr_333_3335 tree_333 tree_3335 0.8192
Cp_3335 tree_3335 0 2.592e-15
Rtr_333_3336 tree_333 tree_3336 0.8192
Cp_3336 tree_3336 0 2.592e-15
Rtr_333_3337 tree_333 tree_3337 0.8192
Cp_3337 tree_3337 0 2.592e-15
Rtr_333_3338 tree_333 tree_3338 0.8192
Cp_3338 tree_3338 0 2.592e-15
Rtr_333_3339 tree_333 tree_3339 0.8192
Cp_3339 tree_3339 0 2.592e-15
Rtr_333_3340 tree_333 tree_3340 0.8192
Cp_3340 tree_3340 0 2.592e-15
Rtr_334_3341 tree_334 tree_3341 0.8192
Cp_3341 tree_3341 0 2.592e-15
Rtr_334_3342 tree_334 tree_3342 0.8192
Cp_3342 tree_3342 0 2.592e-15
Rtr_334_3343 tree_334 tree_3343 0.8192
Cp_3343 tree_3343 0 2.592e-15
Rtr_334_3344 tree_334 tree_3344 0.8192
Cp_3344 tree_3344 0 2.592e-15
Rtr_334_3345 tree_334 tree_3345 0.8192
Cp_3345 tree_3345 0 2.592e-15
Rtr_334_3346 tree_334 tree_3346 0.8192
Cp_3346 tree_3346 0 2.592e-15
Rtr_334_3347 tree_334 tree_3347 0.8192
Cp_3347 tree_3347 0 2.592e-15
Rtr_334_3348 tree_334 tree_3348 0.8192
Cp_3348 tree_3348 0 2.592e-15
Rtr_334_3349 tree_334 tree_3349 0.8192
Cp_3349 tree_3349 0 2.592e-15
Rtr_334_3350 tree_334 tree_3350 0.8192
Cp_3350 tree_3350 0 2.592e-15
Rtr_335_3351 tree_335 tree_3351 0.8192
Cp_3351 tree_3351 0 2.592e-15
Rtr_335_3352 tree_335 tree_3352 0.8192
Cp_3352 tree_3352 0 2.592e-15
Rtr_335_3353 tree_335 tree_3353 0.8192
Cp_3353 tree_3353 0 2.592e-15
Rtr_335_3354 tree_335 tree_3354 0.8192
Cp_3354 tree_3354 0 2.592e-15
Rtr_335_3355 tree_335 tree_3355 0.8192
Cp_3355 tree_3355 0 2.592e-15
Rtr_335_3356 tree_335 tree_3356 0.8192
Cp_3356 tree_3356 0 2.592e-15
Rtr_335_3357 tree_335 tree_3357 0.8192
Cp_3357 tree_3357 0 2.592e-15
Rtr_335_3358 tree_335 tree_3358 0.8192
Cp_3358 tree_3358 0 2.592e-15
Rtr_335_3359 tree_335 tree_3359 0.8192
Cp_3359 tree_3359 0 2.592e-15
Rtr_335_3360 tree_335 tree_3360 0.8192
Cp_3360 tree_3360 0 2.592e-15
Rtr_336_3361 tree_336 tree_3361 0.8192
Cp_3361 tree_3361 0 2.592e-15
Rtr_336_3362 tree_336 tree_3362 0.8192
Cp_3362 tree_3362 0 2.592e-15
Rtr_336_3363 tree_336 tree_3363 0.8192
Cp_3363 tree_3363 0 2.592e-15
Rtr_336_3364 tree_336 tree_3364 0.8192
Cp_3364 tree_3364 0 2.592e-15
Rtr_336_3365 tree_336 tree_3365 0.8192
Cp_3365 tree_3365 0 2.592e-15
Rtr_336_3366 tree_336 tree_3366 0.8192
Cp_3366 tree_3366 0 2.592e-15
Rtr_336_3367 tree_336 tree_3367 0.8192
Cp_3367 tree_3367 0 2.592e-15
Rtr_336_3368 tree_336 tree_3368 0.8192
Cp_3368 tree_3368 0 2.592e-15
Rtr_336_3369 tree_336 tree_3369 0.8192
Cp_3369 tree_3369 0 2.592e-15
Rtr_336_3370 tree_336 tree_3370 0.8192
Cp_3370 tree_3370 0 2.592e-15
Rtr_337_3371 tree_337 tree_3371 0.8192
Cp_3371 tree_3371 0 2.592e-15
Rtr_337_3372 tree_337 tree_3372 0.8192
Cp_3372 tree_3372 0 2.592e-15
Rtr_337_3373 tree_337 tree_3373 0.8192
Cp_3373 tree_3373 0 2.592e-15
Rtr_337_3374 tree_337 tree_3374 0.8192
Cp_3374 tree_3374 0 2.592e-15
Rtr_337_3375 tree_337 tree_3375 0.8192
Cp_3375 tree_3375 0 2.592e-15
Rtr_337_3376 tree_337 tree_3376 0.8192
Cp_3376 tree_3376 0 2.592e-15
Rtr_337_3377 tree_337 tree_3377 0.8192
Cp_3377 tree_3377 0 2.592e-15
Rtr_337_3378 tree_337 tree_3378 0.8192
Cp_3378 tree_3378 0 2.592e-15
Rtr_337_3379 tree_337 tree_3379 0.8192
Cp_3379 tree_3379 0 2.592e-15
Rtr_337_3380 tree_337 tree_3380 0.8192
Cp_3380 tree_3380 0 2.592e-15
Rtr_338_3381 tree_338 tree_3381 0.8192
Cp_3381 tree_3381 0 2.592e-15
Rtr_338_3382 tree_338 tree_3382 0.8192
Cp_3382 tree_3382 0 2.592e-15
Rtr_338_3383 tree_338 tree_3383 0.8192
Cp_3383 tree_3383 0 2.592e-15
Rtr_338_3384 tree_338 tree_3384 0.8192
Cp_3384 tree_3384 0 2.592e-15
Rtr_338_3385 tree_338 tree_3385 0.8192
Cp_3385 tree_3385 0 2.592e-15
Rtr_338_3386 tree_338 tree_3386 0.8192
Cp_3386 tree_3386 0 2.592e-15
Rtr_338_3387 tree_338 tree_3387 0.8192
Cp_3387 tree_3387 0 2.592e-15
Rtr_338_3388 tree_338 tree_3388 0.8192
Cp_3388 tree_3388 0 2.592e-15
Rtr_338_3389 tree_338 tree_3389 0.8192
Cp_3389 tree_3389 0 2.592e-15
Rtr_338_3390 tree_338 tree_3390 0.8192
Cp_3390 tree_3390 0 2.592e-15
Rtr_339_3391 tree_339 tree_3391 0.8192
Cp_3391 tree_3391 0 2.592e-15
Rtr_339_3392 tree_339 tree_3392 0.8192
Cp_3392 tree_3392 0 2.592e-15
Rtr_339_3393 tree_339 tree_3393 0.8192
Cp_3393 tree_3393 0 2.592e-15
Rtr_339_3394 tree_339 tree_3394 0.8192
Cp_3394 tree_3394 0 2.592e-15
Rtr_339_3395 tree_339 tree_3395 0.8192
Cp_3395 tree_3395 0 2.592e-15
Rtr_339_3396 tree_339 tree_3396 0.8192
Cp_3396 tree_3396 0 2.592e-15
Rtr_339_3397 tree_339 tree_3397 0.8192
Cp_3397 tree_3397 0 2.592e-15
Rtr_339_3398 tree_339 tree_3398 0.8192
Cp_3398 tree_3398 0 2.592e-15
Rtr_339_3399 tree_339 tree_3399 0.8192
Cp_3399 tree_3399 0 2.592e-15
Rtr_339_3400 tree_339 tree_3400 0.8192
Cp_3400 tree_3400 0 2.592e-15
Rtr_340_3401 tree_340 tree_3401 0.8192
Cp_3401 tree_3401 0 2.592e-15
Rtr_340_3402 tree_340 tree_3402 0.8192
Cp_3402 tree_3402 0 2.592e-15
Rtr_340_3403 tree_340 tree_3403 0.8192
Cp_3403 tree_3403 0 2.592e-15
Rtr_340_3404 tree_340 tree_3404 0.8192
Cp_3404 tree_3404 0 2.592e-15
Rtr_340_3405 tree_340 tree_3405 0.8192
Cp_3405 tree_3405 0 2.592e-15
Rtr_340_3406 tree_340 tree_3406 0.8192
Cp_3406 tree_3406 0 2.592e-15
Rtr_340_3407 tree_340 tree_3407 0.8192
Cp_3407 tree_3407 0 2.592e-15
Rtr_340_3408 tree_340 tree_3408 0.8192
Cp_3408 tree_3408 0 2.592e-15
Rtr_340_3409 tree_340 tree_3409 0.8192
Cp_3409 tree_3409 0 2.592e-15
Rtr_340_3410 tree_340 tree_3410 0.8192
Cp_3410 tree_3410 0 2.592e-15
Rtr_341_3411 tree_341 tree_3411 0.8192
Cp_3411 tree_3411 0 2.592e-15
Rtr_341_3412 tree_341 tree_3412 0.8192
Cp_3412 tree_3412 0 2.592e-15
Rtr_341_3413 tree_341 tree_3413 0.8192
Cp_3413 tree_3413 0 2.592e-15
Rtr_341_3414 tree_341 tree_3414 0.8192
Cp_3414 tree_3414 0 2.592e-15
Rtr_341_3415 tree_341 tree_3415 0.8192
Cp_3415 tree_3415 0 2.592e-15
Rtr_341_3416 tree_341 tree_3416 0.8192
Cp_3416 tree_3416 0 2.592e-15
Rtr_341_3417 tree_341 tree_3417 0.8192
Cp_3417 tree_3417 0 2.592e-15
Rtr_341_3418 tree_341 tree_3418 0.8192
Cp_3418 tree_3418 0 2.592e-15
Rtr_341_3419 tree_341 tree_3419 0.8192
Cp_3419 tree_3419 0 2.592e-15
Rtr_341_3420 tree_341 tree_3420 0.8192
Cp_3420 tree_3420 0 2.592e-15
Rtr_342_3421 tree_342 tree_3421 0.8192
Cp_3421 tree_3421 0 2.592e-15
Rtr_342_3422 tree_342 tree_3422 0.8192
Cp_3422 tree_3422 0 2.592e-15
Rtr_342_3423 tree_342 tree_3423 0.8192
Cp_3423 tree_3423 0 2.592e-15
Rtr_342_3424 tree_342 tree_3424 0.8192
Cp_3424 tree_3424 0 2.592e-15
Rtr_342_3425 tree_342 tree_3425 0.8192
Cp_3425 tree_3425 0 2.592e-15
Rtr_342_3426 tree_342 tree_3426 0.8192
Cp_3426 tree_3426 0 2.592e-15
Rtr_342_3427 tree_342 tree_3427 0.8192
Cp_3427 tree_3427 0 2.592e-15
Rtr_342_3428 tree_342 tree_3428 0.8192
Cp_3428 tree_3428 0 2.592e-15
Rtr_342_3429 tree_342 tree_3429 0.8192
Cp_3429 tree_3429 0 2.592e-15
Rtr_342_3430 tree_342 tree_3430 0.8192
Cp_3430 tree_3430 0 2.592e-15
Rtr_343_3431 tree_343 tree_3431 0.8192
Cp_3431 tree_3431 0 2.592e-15
Rtr_343_3432 tree_343 tree_3432 0.8192
Cp_3432 tree_3432 0 2.592e-15
Rtr_343_3433 tree_343 tree_3433 0.8192
Cp_3433 tree_3433 0 2.592e-15
Rtr_343_3434 tree_343 tree_3434 0.8192
Cp_3434 tree_3434 0 2.592e-15
Rtr_343_3435 tree_343 tree_3435 0.8192
Cp_3435 tree_3435 0 2.592e-15
Rtr_343_3436 tree_343 tree_3436 0.8192
Cp_3436 tree_3436 0 2.592e-15
Rtr_343_3437 tree_343 tree_3437 0.8192
Cp_3437 tree_3437 0 2.592e-15
Rtr_343_3438 tree_343 tree_3438 0.8192
Cp_3438 tree_3438 0 2.592e-15
Rtr_343_3439 tree_343 tree_3439 0.8192
Cp_3439 tree_3439 0 2.592e-15
Rtr_343_3440 tree_343 tree_3440 0.8192
Cp_3440 tree_3440 0 2.592e-15
Rtr_344_3441 tree_344 tree_3441 0.8192
Cp_3441 tree_3441 0 2.592e-15
Rtr_344_3442 tree_344 tree_3442 0.8192
Cp_3442 tree_3442 0 2.592e-15
Rtr_344_3443 tree_344 tree_3443 0.8192
Cp_3443 tree_3443 0 2.592e-15
Rtr_344_3444 tree_344 tree_3444 0.8192
Cp_3444 tree_3444 0 2.592e-15
Rtr_344_3445 tree_344 tree_3445 0.8192
Cp_3445 tree_3445 0 2.592e-15
Rtr_344_3446 tree_344 tree_3446 0.8192
Cp_3446 tree_3446 0 2.592e-15
Rtr_344_3447 tree_344 tree_3447 0.8192
Cp_3447 tree_3447 0 2.592e-15
Rtr_344_3448 tree_344 tree_3448 0.8192
Cp_3448 tree_3448 0 2.592e-15
Rtr_344_3449 tree_344 tree_3449 0.8192
Cp_3449 tree_3449 0 2.592e-15
Rtr_344_3450 tree_344 tree_3450 0.8192
Cp_3450 tree_3450 0 2.592e-15
Rtr_345_3451 tree_345 tree_3451 0.8192
Cp_3451 tree_3451 0 2.592e-15
Rtr_345_3452 tree_345 tree_3452 0.8192
Cp_3452 tree_3452 0 2.592e-15
Rtr_345_3453 tree_345 tree_3453 0.8192
Cp_3453 tree_3453 0 2.592e-15
Rtr_345_3454 tree_345 tree_3454 0.8192
Cp_3454 tree_3454 0 2.592e-15
Rtr_345_3455 tree_345 tree_3455 0.8192
Cp_3455 tree_3455 0 2.592e-15
Rtr_345_3456 tree_345 tree_3456 0.8192
Cp_3456 tree_3456 0 2.592e-15
Rtr_345_3457 tree_345 tree_3457 0.8192
Cp_3457 tree_3457 0 2.592e-15
Rtr_345_3458 tree_345 tree_3458 0.8192
Cp_3458 tree_3458 0 2.592e-15
Rtr_345_3459 tree_345 tree_3459 0.8192
Cp_3459 tree_3459 0 2.592e-15
Rtr_345_3460 tree_345 tree_3460 0.8192
Cp_3460 tree_3460 0 2.592e-15
Rtr_346_3461 tree_346 tree_3461 0.8192
Cp_3461 tree_3461 0 2.592e-15
Rtr_346_3462 tree_346 tree_3462 0.8192
Cp_3462 tree_3462 0 2.592e-15
Rtr_346_3463 tree_346 tree_3463 0.8192
Cp_3463 tree_3463 0 2.592e-15
Rtr_346_3464 tree_346 tree_3464 0.8192
Cp_3464 tree_3464 0 2.592e-15
Rtr_346_3465 tree_346 tree_3465 0.8192
Cp_3465 tree_3465 0 2.592e-15
Rtr_346_3466 tree_346 tree_3466 0.8192
Cp_3466 tree_3466 0 2.592e-15
Rtr_346_3467 tree_346 tree_3467 0.8192
Cp_3467 tree_3467 0 2.592e-15
Rtr_346_3468 tree_346 tree_3468 0.8192
Cp_3468 tree_3468 0 2.592e-15
Rtr_346_3469 tree_346 tree_3469 0.8192
Cp_3469 tree_3469 0 2.592e-15
Rtr_346_3470 tree_346 tree_3470 0.8192
Cp_3470 tree_3470 0 2.592e-15
Rtr_347_3471 tree_347 tree_3471 0.8192
Cp_3471 tree_3471 0 2.592e-15
Rtr_347_3472 tree_347 tree_3472 0.8192
Cp_3472 tree_3472 0 2.592e-15
Rtr_347_3473 tree_347 tree_3473 0.8192
Cp_3473 tree_3473 0 2.592e-15
Rtr_347_3474 tree_347 tree_3474 0.8192
Cp_3474 tree_3474 0 2.592e-15
Rtr_347_3475 tree_347 tree_3475 0.8192
Cp_3475 tree_3475 0 2.592e-15
Rtr_347_3476 tree_347 tree_3476 0.8192
Cp_3476 tree_3476 0 2.592e-15
Rtr_347_3477 tree_347 tree_3477 0.8192
Cp_3477 tree_3477 0 2.592e-15
Rtr_347_3478 tree_347 tree_3478 0.8192
Cp_3478 tree_3478 0 2.592e-15
Rtr_347_3479 tree_347 tree_3479 0.8192
Cp_3479 tree_3479 0 2.592e-15
Rtr_347_3480 tree_347 tree_3480 0.8192
Cp_3480 tree_3480 0 2.592e-15
Rtr_348_3481 tree_348 tree_3481 0.8192
Cp_3481 tree_3481 0 2.592e-15
Rtr_348_3482 tree_348 tree_3482 0.8192
Cp_3482 tree_3482 0 2.592e-15
Rtr_348_3483 tree_348 tree_3483 0.8192
Cp_3483 tree_3483 0 2.592e-15
Rtr_348_3484 tree_348 tree_3484 0.8192
Cp_3484 tree_3484 0 2.592e-15
Rtr_348_3485 tree_348 tree_3485 0.8192
Cp_3485 tree_3485 0 2.592e-15
Rtr_348_3486 tree_348 tree_3486 0.8192
Cp_3486 tree_3486 0 2.592e-15
Rtr_348_3487 tree_348 tree_3487 0.8192
Cp_3487 tree_3487 0 2.592e-15
Rtr_348_3488 tree_348 tree_3488 0.8192
Cp_3488 tree_3488 0 2.592e-15
Rtr_348_3489 tree_348 tree_3489 0.8192
Cp_3489 tree_3489 0 2.592e-15
Rtr_348_3490 tree_348 tree_3490 0.8192
Cp_3490 tree_3490 0 2.592e-15
Rtr_349_3491 tree_349 tree_3491 0.8192
Cp_3491 tree_3491 0 2.592e-15
Rtr_349_3492 tree_349 tree_3492 0.8192
Cp_3492 tree_3492 0 2.592e-15
Rtr_349_3493 tree_349 tree_3493 0.8192
Cp_3493 tree_3493 0 2.592e-15
Rtr_349_3494 tree_349 tree_3494 0.8192
Cp_3494 tree_3494 0 2.592e-15
Rtr_349_3495 tree_349 tree_3495 0.8192
Cp_3495 tree_3495 0 2.592e-15
Rtr_349_3496 tree_349 tree_3496 0.8192
Cp_3496 tree_3496 0 2.592e-15
Rtr_349_3497 tree_349 tree_3497 0.8192
Cp_3497 tree_3497 0 2.592e-15
Rtr_349_3498 tree_349 tree_3498 0.8192
Cp_3498 tree_3498 0 2.592e-15
Rtr_349_3499 tree_349 tree_3499 0.8192
Cp_3499 tree_3499 0 2.592e-15
Rtr_349_3500 tree_349 tree_3500 0.8192
Cp_3500 tree_3500 0 2.592e-15
Rtr_350_3501 tree_350 tree_3501 0.8192
Cp_3501 tree_3501 0 2.592e-15
Rtr_350_3502 tree_350 tree_3502 0.8192
Cp_3502 tree_3502 0 2.592e-15
Rtr_350_3503 tree_350 tree_3503 0.8192
Cp_3503 tree_3503 0 2.592e-15
Rtr_350_3504 tree_350 tree_3504 0.8192
Cp_3504 tree_3504 0 2.592e-15
Rtr_350_3505 tree_350 tree_3505 0.8192
Cp_3505 tree_3505 0 2.592e-15
Rtr_350_3506 tree_350 tree_3506 0.8192
Cp_3506 tree_3506 0 2.592e-15
Rtr_350_3507 tree_350 tree_3507 0.8192
Cp_3507 tree_3507 0 2.592e-15
Rtr_350_3508 tree_350 tree_3508 0.8192
Cp_3508 tree_3508 0 2.592e-15
Rtr_350_3509 tree_350 tree_3509 0.8192
Cp_3509 tree_3509 0 2.592e-15
Rtr_350_3510 tree_350 tree_3510 0.8192
Cp_3510 tree_3510 0 2.592e-15
Rtr_351_3511 tree_351 tree_3511 0.8192
Cp_3511 tree_3511 0 2.592e-15
Rtr_351_3512 tree_351 tree_3512 0.8192
Cp_3512 tree_3512 0 2.592e-15
Rtr_351_3513 tree_351 tree_3513 0.8192
Cp_3513 tree_3513 0 2.592e-15
Rtr_351_3514 tree_351 tree_3514 0.8192
Cp_3514 tree_3514 0 2.592e-15
Rtr_351_3515 tree_351 tree_3515 0.8192
Cp_3515 tree_3515 0 2.592e-15
Rtr_351_3516 tree_351 tree_3516 0.8192
Cp_3516 tree_3516 0 2.592e-15
Rtr_351_3517 tree_351 tree_3517 0.8192
Cp_3517 tree_3517 0 2.592e-15
Rtr_351_3518 tree_351 tree_3518 0.8192
Cp_3518 tree_3518 0 2.592e-15
Rtr_351_3519 tree_351 tree_3519 0.8192
Cp_3519 tree_3519 0 2.592e-15
Rtr_351_3520 tree_351 tree_3520 0.8192
Cp_3520 tree_3520 0 2.592e-15
Rtr_352_3521 tree_352 tree_3521 0.8192
Cp_3521 tree_3521 0 2.592e-15
Rtr_352_3522 tree_352 tree_3522 0.8192
Cp_3522 tree_3522 0 2.592e-15
Rtr_352_3523 tree_352 tree_3523 0.8192
Cp_3523 tree_3523 0 2.592e-15
Rtr_352_3524 tree_352 tree_3524 0.8192
Cp_3524 tree_3524 0 2.592e-15
Rtr_352_3525 tree_352 tree_3525 0.8192
Cp_3525 tree_3525 0 2.592e-15
Rtr_352_3526 tree_352 tree_3526 0.8192
Cp_3526 tree_3526 0 2.592e-15
Rtr_352_3527 tree_352 tree_3527 0.8192
Cp_3527 tree_3527 0 2.592e-15
Rtr_352_3528 tree_352 tree_3528 0.8192
Cp_3528 tree_3528 0 2.592e-15
Rtr_352_3529 tree_352 tree_3529 0.8192
Cp_3529 tree_3529 0 2.592e-15
Rtr_352_3530 tree_352 tree_3530 0.8192
Cp_3530 tree_3530 0 2.592e-15
Rtr_353_3531 tree_353 tree_3531 0.8192
Cp_3531 tree_3531 0 2.592e-15
Rtr_353_3532 tree_353 tree_3532 0.8192
Cp_3532 tree_3532 0 2.592e-15
Rtr_353_3533 tree_353 tree_3533 0.8192
Cp_3533 tree_3533 0 2.592e-15
Rtr_353_3534 tree_353 tree_3534 0.8192
Cp_3534 tree_3534 0 2.592e-15
Rtr_353_3535 tree_353 tree_3535 0.8192
Cp_3535 tree_3535 0 2.592e-15
Rtr_353_3536 tree_353 tree_3536 0.8192
Cp_3536 tree_3536 0 2.592e-15
Rtr_353_3537 tree_353 tree_3537 0.8192
Cp_3537 tree_3537 0 2.592e-15
Rtr_353_3538 tree_353 tree_3538 0.8192
Cp_3538 tree_3538 0 2.592e-15
Rtr_353_3539 tree_353 tree_3539 0.8192
Cp_3539 tree_3539 0 2.592e-15
Rtr_353_3540 tree_353 tree_3540 0.8192
Cp_3540 tree_3540 0 2.592e-15
Rtr_354_3541 tree_354 tree_3541 0.8192
Cp_3541 tree_3541 0 2.592e-15
Rtr_354_3542 tree_354 tree_3542 0.8192
Cp_3542 tree_3542 0 2.592e-15
Rtr_354_3543 tree_354 tree_3543 0.8192
Cp_3543 tree_3543 0 2.592e-15
Rtr_354_3544 tree_354 tree_3544 0.8192
Cp_3544 tree_3544 0 2.592e-15
Rtr_354_3545 tree_354 tree_3545 0.8192
Cp_3545 tree_3545 0 2.592e-15
Rtr_354_3546 tree_354 tree_3546 0.8192
Cp_3546 tree_3546 0 2.592e-15
Rtr_354_3547 tree_354 tree_3547 0.8192
Cp_3547 tree_3547 0 2.592e-15
Rtr_354_3548 tree_354 tree_3548 0.8192
Cp_3548 tree_3548 0 2.592e-15
Rtr_354_3549 tree_354 tree_3549 0.8192
Cp_3549 tree_3549 0 2.592e-15
Rtr_354_3550 tree_354 tree_3550 0.8192
Cp_3550 tree_3550 0 2.592e-15
Rtr_355_3551 tree_355 tree_3551 0.8192
Cp_3551 tree_3551 0 2.592e-15
Rtr_355_3552 tree_355 tree_3552 0.8192
Cp_3552 tree_3552 0 2.592e-15
Rtr_355_3553 tree_355 tree_3553 0.8192
Cp_3553 tree_3553 0 2.592e-15
Rtr_355_3554 tree_355 tree_3554 0.8192
Cp_3554 tree_3554 0 2.592e-15
Rtr_355_3555 tree_355 tree_3555 0.8192
Cp_3555 tree_3555 0 2.592e-15
Rtr_355_3556 tree_355 tree_3556 0.8192
Cp_3556 tree_3556 0 2.592e-15
Rtr_355_3557 tree_355 tree_3557 0.8192
Cp_3557 tree_3557 0 2.592e-15
Rtr_355_3558 tree_355 tree_3558 0.8192
Cp_3558 tree_3558 0 2.592e-15
Rtr_355_3559 tree_355 tree_3559 0.8192
Cp_3559 tree_3559 0 2.592e-15
Rtr_355_3560 tree_355 tree_3560 0.8192
Cp_3560 tree_3560 0 2.592e-15
Rtr_356_3561 tree_356 tree_3561 0.8192
Cp_3561 tree_3561 0 2.592e-15
Rtr_356_3562 tree_356 tree_3562 0.8192
Cp_3562 tree_3562 0 2.592e-15
Rtr_356_3563 tree_356 tree_3563 0.8192
Cp_3563 tree_3563 0 2.592e-15
Rtr_356_3564 tree_356 tree_3564 0.8192
Cp_3564 tree_3564 0 2.592e-15
Rtr_356_3565 tree_356 tree_3565 0.8192
Cp_3565 tree_3565 0 2.592e-15
Rtr_356_3566 tree_356 tree_3566 0.8192
Cp_3566 tree_3566 0 2.592e-15
Rtr_356_3567 tree_356 tree_3567 0.8192
Cp_3567 tree_3567 0 2.592e-15
Rtr_356_3568 tree_356 tree_3568 0.8192
Cp_3568 tree_3568 0 2.592e-15
Rtr_356_3569 tree_356 tree_3569 0.8192
Cp_3569 tree_3569 0 2.592e-15
Rtr_356_3570 tree_356 tree_3570 0.8192
Cp_3570 tree_3570 0 2.592e-15
Rtr_357_3571 tree_357 tree_3571 0.8192
Cp_3571 tree_3571 0 2.592e-15
Rtr_357_3572 tree_357 tree_3572 0.8192
Cp_3572 tree_3572 0 2.592e-15
Rtr_357_3573 tree_357 tree_3573 0.8192
Cp_3573 tree_3573 0 2.592e-15
Rtr_357_3574 tree_357 tree_3574 0.8192
Cp_3574 tree_3574 0 2.592e-15
Rtr_357_3575 tree_357 tree_3575 0.8192
Cp_3575 tree_3575 0 2.592e-15
Rtr_357_3576 tree_357 tree_3576 0.8192
Cp_3576 tree_3576 0 2.592e-15
Rtr_357_3577 tree_357 tree_3577 0.8192
Cp_3577 tree_3577 0 2.592e-15
Rtr_357_3578 tree_357 tree_3578 0.8192
Cp_3578 tree_3578 0 2.592e-15
Rtr_357_3579 tree_357 tree_3579 0.8192
Cp_3579 tree_3579 0 2.592e-15
Rtr_357_3580 tree_357 tree_3580 0.8192
Cp_3580 tree_3580 0 2.592e-15
Rtr_358_3581 tree_358 tree_3581 0.8192
Cp_3581 tree_3581 0 2.592e-15
Rtr_358_3582 tree_358 tree_3582 0.8192
Cp_3582 tree_3582 0 2.592e-15
Rtr_358_3583 tree_358 tree_3583 0.8192
Cp_3583 tree_3583 0 2.592e-15
Rtr_358_3584 tree_358 tree_3584 0.8192
Cp_3584 tree_3584 0 2.592e-15
Rtr_358_3585 tree_358 tree_3585 0.8192
Cp_3585 tree_3585 0 2.592e-15
Rtr_358_3586 tree_358 tree_3586 0.8192
Cp_3586 tree_3586 0 2.592e-15
Rtr_358_3587 tree_358 tree_3587 0.8192
Cp_3587 tree_3587 0 2.592e-15
Rtr_358_3588 tree_358 tree_3588 0.8192
Cp_3588 tree_3588 0 2.592e-15
Rtr_358_3589 tree_358 tree_3589 0.8192
Cp_3589 tree_3589 0 2.592e-15
Rtr_358_3590 tree_358 tree_3590 0.8192
Cp_3590 tree_3590 0 2.592e-15
Rtr_359_3591 tree_359 tree_3591 0.8192
Cp_3591 tree_3591 0 2.592e-15
Rtr_359_3592 tree_359 tree_3592 0.8192
Cp_3592 tree_3592 0 2.592e-15
Rtr_359_3593 tree_359 tree_3593 0.8192
Cp_3593 tree_3593 0 2.592e-15
Rtr_359_3594 tree_359 tree_3594 0.8192
Cp_3594 tree_3594 0 2.592e-15
Rtr_359_3595 tree_359 tree_3595 0.8192
Cp_3595 tree_3595 0 2.592e-15
Rtr_359_3596 tree_359 tree_3596 0.8192
Cp_3596 tree_3596 0 2.592e-15
Rtr_359_3597 tree_359 tree_3597 0.8192
Cp_3597 tree_3597 0 2.592e-15
Rtr_359_3598 tree_359 tree_3598 0.8192
Cp_3598 tree_3598 0 2.592e-15
Rtr_359_3599 tree_359 tree_3599 0.8192
Cp_3599 tree_3599 0 2.592e-15
Rtr_359_3600 tree_359 tree_3600 0.8192
Cp_3600 tree_3600 0 2.592e-15
Rtr_360_3601 tree_360 tree_3601 0.8192
Cp_3601 tree_3601 0 2.592e-15
Rtr_360_3602 tree_360 tree_3602 0.8192
Cp_3602 tree_3602 0 2.592e-15
Rtr_360_3603 tree_360 tree_3603 0.8192
Cp_3603 tree_3603 0 2.592e-15
Rtr_360_3604 tree_360 tree_3604 0.8192
Cp_3604 tree_3604 0 2.592e-15
Rtr_360_3605 tree_360 tree_3605 0.8192
Cp_3605 tree_3605 0 2.592e-15
Rtr_360_3606 tree_360 tree_3606 0.8192
Cp_3606 tree_3606 0 2.592e-15
Rtr_360_3607 tree_360 tree_3607 0.8192
Cp_3607 tree_3607 0 2.592e-15
Rtr_360_3608 tree_360 tree_3608 0.8192
Cp_3608 tree_3608 0 2.592e-15
Rtr_360_3609 tree_360 tree_3609 0.8192
Cp_3609 tree_3609 0 2.592e-15
Rtr_360_3610 tree_360 tree_3610 0.8192
Cp_3610 tree_3610 0 2.592e-15
Rtr_361_3611 tree_361 tree_3611 0.8192
Cp_3611 tree_3611 0 2.592e-15
Rtr_361_3612 tree_361 tree_3612 0.8192
Cp_3612 tree_3612 0 2.592e-15
Rtr_361_3613 tree_361 tree_3613 0.8192
Cp_3613 tree_3613 0 2.592e-15
Rtr_361_3614 tree_361 tree_3614 0.8192
Cp_3614 tree_3614 0 2.592e-15
Rtr_361_3615 tree_361 tree_3615 0.8192
Cp_3615 tree_3615 0 2.592e-15
Rtr_361_3616 tree_361 tree_3616 0.8192
Cp_3616 tree_3616 0 2.592e-15
Rtr_361_3617 tree_361 tree_3617 0.8192
Cp_3617 tree_3617 0 2.592e-15
Rtr_361_3618 tree_361 tree_3618 0.8192
Cp_3618 tree_3618 0 2.592e-15
Rtr_361_3619 tree_361 tree_3619 0.8192
Cp_3619 tree_3619 0 2.592e-15
Rtr_361_3620 tree_361 tree_3620 0.8192
Cp_3620 tree_3620 0 2.592e-15
Rtr_362_3621 tree_362 tree_3621 0.8192
Cp_3621 tree_3621 0 2.592e-15
Rtr_362_3622 tree_362 tree_3622 0.8192
Cp_3622 tree_3622 0 2.592e-15
Rtr_362_3623 tree_362 tree_3623 0.8192
Cp_3623 tree_3623 0 2.592e-15
Rtr_362_3624 tree_362 tree_3624 0.8192
Cp_3624 tree_3624 0 2.592e-15
Rtr_362_3625 tree_362 tree_3625 0.8192
Cp_3625 tree_3625 0 2.592e-15
Rtr_362_3626 tree_362 tree_3626 0.8192
Cp_3626 tree_3626 0 2.592e-15
Rtr_362_3627 tree_362 tree_3627 0.8192
Cp_3627 tree_3627 0 2.592e-15
Rtr_362_3628 tree_362 tree_3628 0.8192
Cp_3628 tree_3628 0 2.592e-15
Rtr_362_3629 tree_362 tree_3629 0.8192
Cp_3629 tree_3629 0 2.592e-15
Rtr_362_3630 tree_362 tree_3630 0.8192
Cp_3630 tree_3630 0 2.592e-15
Rtr_363_3631 tree_363 tree_3631 0.8192
Cp_3631 tree_3631 0 2.592e-15
Rtr_363_3632 tree_363 tree_3632 0.8192
Cp_3632 tree_3632 0 2.592e-15
Rtr_363_3633 tree_363 tree_3633 0.8192
Cp_3633 tree_3633 0 2.592e-15
Rtr_363_3634 tree_363 tree_3634 0.8192
Cp_3634 tree_3634 0 2.592e-15
Rtr_363_3635 tree_363 tree_3635 0.8192
Cp_3635 tree_3635 0 2.592e-15
Rtr_363_3636 tree_363 tree_3636 0.8192
Cp_3636 tree_3636 0 2.592e-15
Rtr_363_3637 tree_363 tree_3637 0.8192
Cp_3637 tree_3637 0 2.592e-15
Rtr_363_3638 tree_363 tree_3638 0.8192
Cp_3638 tree_3638 0 2.592e-15
Rtr_363_3639 tree_363 tree_3639 0.8192
Cp_3639 tree_3639 0 2.592e-15
Rtr_363_3640 tree_363 tree_3640 0.8192
Cp_3640 tree_3640 0 2.592e-15
Rtr_364_3641 tree_364 tree_3641 0.8192
Cp_3641 tree_3641 0 2.592e-15
Rtr_364_3642 tree_364 tree_3642 0.8192
Cp_3642 tree_3642 0 2.592e-15
Rtr_364_3643 tree_364 tree_3643 0.8192
Cp_3643 tree_3643 0 2.592e-15
Rtr_364_3644 tree_364 tree_3644 0.8192
Cp_3644 tree_3644 0 2.592e-15
Rtr_364_3645 tree_364 tree_3645 0.8192
Cp_3645 tree_3645 0 2.592e-15
Rtr_364_3646 tree_364 tree_3646 0.8192
Cp_3646 tree_3646 0 2.592e-15
Rtr_364_3647 tree_364 tree_3647 0.8192
Cp_3647 tree_3647 0 2.592e-15
Rtr_364_3648 tree_364 tree_3648 0.8192
Cp_3648 tree_3648 0 2.592e-15
Rtr_364_3649 tree_364 tree_3649 0.8192
Cp_3649 tree_3649 0 2.592e-15
Rtr_364_3650 tree_364 tree_3650 0.8192
Cp_3650 tree_3650 0 2.592e-15
Rtr_365_3651 tree_365 tree_3651 0.8192
Cp_3651 tree_3651 0 2.592e-15
Rtr_365_3652 tree_365 tree_3652 0.8192
Cp_3652 tree_3652 0 2.592e-15
Rtr_365_3653 tree_365 tree_3653 0.8192
Cp_3653 tree_3653 0 2.592e-15
Rtr_365_3654 tree_365 tree_3654 0.8192
Cp_3654 tree_3654 0 2.592e-15
Rtr_365_3655 tree_365 tree_3655 0.8192
Cp_3655 tree_3655 0 2.592e-15
Rtr_365_3656 tree_365 tree_3656 0.8192
Cp_3656 tree_3656 0 2.592e-15
Rtr_365_3657 tree_365 tree_3657 0.8192
Cp_3657 tree_3657 0 2.592e-15
Rtr_365_3658 tree_365 tree_3658 0.8192
Cp_3658 tree_3658 0 2.592e-15
Rtr_365_3659 tree_365 tree_3659 0.8192
Cp_3659 tree_3659 0 2.592e-15
Rtr_365_3660 tree_365 tree_3660 0.8192
Cp_3660 tree_3660 0 2.592e-15
Rtr_366_3661 tree_366 tree_3661 0.8192
Cp_3661 tree_3661 0 2.592e-15
Rtr_366_3662 tree_366 tree_3662 0.8192
Cp_3662 tree_3662 0 2.592e-15
Rtr_366_3663 tree_366 tree_3663 0.8192
Cp_3663 tree_3663 0 2.592e-15
Rtr_366_3664 tree_366 tree_3664 0.8192
Cp_3664 tree_3664 0 2.592e-15
Rtr_366_3665 tree_366 tree_3665 0.8192
Cp_3665 tree_3665 0 2.592e-15
Rtr_366_3666 tree_366 tree_3666 0.8192
Cp_3666 tree_3666 0 2.592e-15
Rtr_366_3667 tree_366 tree_3667 0.8192
Cp_3667 tree_3667 0 2.592e-15
Rtr_366_3668 tree_366 tree_3668 0.8192
Cp_3668 tree_3668 0 2.592e-15
Rtr_366_3669 tree_366 tree_3669 0.8192
Cp_3669 tree_3669 0 2.592e-15
Rtr_366_3670 tree_366 tree_3670 0.8192
Cp_3670 tree_3670 0 2.592e-15
Rtr_367_3671 tree_367 tree_3671 0.8192
Cp_3671 tree_3671 0 2.592e-15
Rtr_367_3672 tree_367 tree_3672 0.8192
Cp_3672 tree_3672 0 2.592e-15
Rtr_367_3673 tree_367 tree_3673 0.8192
Cp_3673 tree_3673 0 2.592e-15
Rtr_367_3674 tree_367 tree_3674 0.8192
Cp_3674 tree_3674 0 2.592e-15
Rtr_367_3675 tree_367 tree_3675 0.8192
Cp_3675 tree_3675 0 2.592e-15
Rtr_367_3676 tree_367 tree_3676 0.8192
Cp_3676 tree_3676 0 2.592e-15
Rtr_367_3677 tree_367 tree_3677 0.8192
Cp_3677 tree_3677 0 2.592e-15
Rtr_367_3678 tree_367 tree_3678 0.8192
Cp_3678 tree_3678 0 2.592e-15
Rtr_367_3679 tree_367 tree_3679 0.8192
Cp_3679 tree_3679 0 2.592e-15
Rtr_367_3680 tree_367 tree_3680 0.8192
Cp_3680 tree_3680 0 2.592e-15
Rtr_368_3681 tree_368 tree_3681 0.8192
Cp_3681 tree_3681 0 2.592e-15
Rtr_368_3682 tree_368 tree_3682 0.8192
Cp_3682 tree_3682 0 2.592e-15
Rtr_368_3683 tree_368 tree_3683 0.8192
Cp_3683 tree_3683 0 2.592e-15
Rtr_368_3684 tree_368 tree_3684 0.8192
Cp_3684 tree_3684 0 2.592e-15
Rtr_368_3685 tree_368 tree_3685 0.8192
Cp_3685 tree_3685 0 2.592e-15
Rtr_368_3686 tree_368 tree_3686 0.8192
Cp_3686 tree_3686 0 2.592e-15
Rtr_368_3687 tree_368 tree_3687 0.8192
Cp_3687 tree_3687 0 2.592e-15
Rtr_368_3688 tree_368 tree_3688 0.8192
Cp_3688 tree_3688 0 2.592e-15
Rtr_368_3689 tree_368 tree_3689 0.8192
Cp_3689 tree_3689 0 2.592e-15
Rtr_368_3690 tree_368 tree_3690 0.8192
Cp_3690 tree_3690 0 2.592e-15
Rtr_369_3691 tree_369 tree_3691 0.8192
Cp_3691 tree_3691 0 2.592e-15
Rtr_369_3692 tree_369 tree_3692 0.8192
Cp_3692 tree_3692 0 2.592e-15
Rtr_369_3693 tree_369 tree_3693 0.8192
Cp_3693 tree_3693 0 2.592e-15
Rtr_369_3694 tree_369 tree_3694 0.8192
Cp_3694 tree_3694 0 2.592e-15
Rtr_369_3695 tree_369 tree_3695 0.8192
Cp_3695 tree_3695 0 2.592e-15
Rtr_369_3696 tree_369 tree_3696 0.8192
Cp_3696 tree_3696 0 2.592e-15
Rtr_369_3697 tree_369 tree_3697 0.8192
Cp_3697 tree_3697 0 2.592e-15
Rtr_369_3698 tree_369 tree_3698 0.8192
Cp_3698 tree_3698 0 2.592e-15
Rtr_369_3699 tree_369 tree_3699 0.8192
Cp_3699 tree_3699 0 2.592e-15
Rtr_369_3700 tree_369 tree_3700 0.8192
Cp_3700 tree_3700 0 2.592e-15
Rtr_370_3701 tree_370 tree_3701 0.8192
Cp_3701 tree_3701 0 2.592e-15
Rtr_370_3702 tree_370 tree_3702 0.8192
Cp_3702 tree_3702 0 2.592e-15
Rtr_370_3703 tree_370 tree_3703 0.8192
Cp_3703 tree_3703 0 2.592e-15
Rtr_370_3704 tree_370 tree_3704 0.8192
Cp_3704 tree_3704 0 2.592e-15
Rtr_370_3705 tree_370 tree_3705 0.8192
Cp_3705 tree_3705 0 2.592e-15
Rtr_370_3706 tree_370 tree_3706 0.8192
Cp_3706 tree_3706 0 2.592e-15
Rtr_370_3707 tree_370 tree_3707 0.8192
Cp_3707 tree_3707 0 2.592e-15
Rtr_370_3708 tree_370 tree_3708 0.8192
Cp_3708 tree_3708 0 2.592e-15
Rtr_370_3709 tree_370 tree_3709 0.8192
Cp_3709 tree_3709 0 2.592e-15
Rtr_370_3710 tree_370 tree_3710 0.8192
Cp_3710 tree_3710 0 2.592e-15
Rtr_371_3711 tree_371 tree_3711 0.8192
Cp_3711 tree_3711 0 2.592e-15
Rtr_371_3712 tree_371 tree_3712 0.8192
Cp_3712 tree_3712 0 2.592e-15
Rtr_371_3713 tree_371 tree_3713 0.8192
Cp_3713 tree_3713 0 2.592e-15
Rtr_371_3714 tree_371 tree_3714 0.8192
Cp_3714 tree_3714 0 2.592e-15
Rtr_371_3715 tree_371 tree_3715 0.8192
Cp_3715 tree_3715 0 2.592e-15
Rtr_371_3716 tree_371 tree_3716 0.8192
Cp_3716 tree_3716 0 2.592e-15
Rtr_371_3717 tree_371 tree_3717 0.8192
Cp_3717 tree_3717 0 2.592e-15
Rtr_371_3718 tree_371 tree_3718 0.8192
Cp_3718 tree_3718 0 2.592e-15
Rtr_371_3719 tree_371 tree_3719 0.8192
Cp_3719 tree_3719 0 2.592e-15
Rtr_371_3720 tree_371 tree_3720 0.8192
Cp_3720 tree_3720 0 2.592e-15
Rtr_372_3721 tree_372 tree_3721 0.8192
Cp_3721 tree_3721 0 2.592e-15
Rtr_372_3722 tree_372 tree_3722 0.8192
Cp_3722 tree_3722 0 2.592e-15
Rtr_372_3723 tree_372 tree_3723 0.8192
Cp_3723 tree_3723 0 2.592e-15
Rtr_372_3724 tree_372 tree_3724 0.8192
Cp_3724 tree_3724 0 2.592e-15
Rtr_372_3725 tree_372 tree_3725 0.8192
Cp_3725 tree_3725 0 2.592e-15
Rtr_372_3726 tree_372 tree_3726 0.8192
Cp_3726 tree_3726 0 2.592e-15
Rtr_372_3727 tree_372 tree_3727 0.8192
Cp_3727 tree_3727 0 2.592e-15
Rtr_372_3728 tree_372 tree_3728 0.8192
Cp_3728 tree_3728 0 2.592e-15
Rtr_372_3729 tree_372 tree_3729 0.8192
Cp_3729 tree_3729 0 2.592e-15
Rtr_372_3730 tree_372 tree_3730 0.8192
Cp_3730 tree_3730 0 2.592e-15
Rtr_373_3731 tree_373 tree_3731 0.8192
Cp_3731 tree_3731 0 2.592e-15
Rtr_373_3732 tree_373 tree_3732 0.8192
Cp_3732 tree_3732 0 2.592e-15
Rtr_373_3733 tree_373 tree_3733 0.8192
Cp_3733 tree_3733 0 2.592e-15
Rtr_373_3734 tree_373 tree_3734 0.8192
Cp_3734 tree_3734 0 2.592e-15
Rtr_373_3735 tree_373 tree_3735 0.8192
Cp_3735 tree_3735 0 2.592e-15
Rtr_373_3736 tree_373 tree_3736 0.8192
Cp_3736 tree_3736 0 2.592e-15
Rtr_373_3737 tree_373 tree_3737 0.8192
Cp_3737 tree_3737 0 2.592e-15
Rtr_373_3738 tree_373 tree_3738 0.8192
Cp_3738 tree_3738 0 2.592e-15
Rtr_373_3739 tree_373 tree_3739 0.8192
Cp_3739 tree_3739 0 2.592e-15
Rtr_373_3740 tree_373 tree_3740 0.8192
Cp_3740 tree_3740 0 2.592e-15
Rtr_374_3741 tree_374 tree_3741 0.8192
Cp_3741 tree_3741 0 2.592e-15
Rtr_374_3742 tree_374 tree_3742 0.8192
Cp_3742 tree_3742 0 2.592e-15
Rtr_374_3743 tree_374 tree_3743 0.8192
Cp_3743 tree_3743 0 2.592e-15
Rtr_374_3744 tree_374 tree_3744 0.8192
Cp_3744 tree_3744 0 2.592e-15
Rtr_374_3745 tree_374 tree_3745 0.8192
Cp_3745 tree_3745 0 2.592e-15
Rtr_374_3746 tree_374 tree_3746 0.8192
Cp_3746 tree_3746 0 2.592e-15
Rtr_374_3747 tree_374 tree_3747 0.8192
Cp_3747 tree_3747 0 2.592e-15
Rtr_374_3748 tree_374 tree_3748 0.8192
Cp_3748 tree_3748 0 2.592e-15
Rtr_374_3749 tree_374 tree_3749 0.8192
Cp_3749 tree_3749 0 2.592e-15
Rtr_374_3750 tree_374 tree_3750 0.8192
Cp_3750 tree_3750 0 2.592e-15
Rtr_375_3751 tree_375 tree_3751 0.8192
Cp_3751 tree_3751 0 2.592e-15
Rtr_375_3752 tree_375 tree_3752 0.8192
Cp_3752 tree_3752 0 2.592e-15
Rtr_375_3753 tree_375 tree_3753 0.8192
Cp_3753 tree_3753 0 2.592e-15
Rtr_375_3754 tree_375 tree_3754 0.8192
Cp_3754 tree_3754 0 2.592e-15
Rtr_375_3755 tree_375 tree_3755 0.8192
Cp_3755 tree_3755 0 2.592e-15
Rtr_375_3756 tree_375 tree_3756 0.8192
Cp_3756 tree_3756 0 2.592e-15
Rtr_375_3757 tree_375 tree_3757 0.8192
Cp_3757 tree_3757 0 2.592e-15
Rtr_375_3758 tree_375 tree_3758 0.8192
Cp_3758 tree_3758 0 2.592e-15
Rtr_375_3759 tree_375 tree_3759 0.8192
Cp_3759 tree_3759 0 2.592e-15
Rtr_375_3760 tree_375 tree_3760 0.8192
Cp_3760 tree_3760 0 2.592e-15
Rtr_376_3761 tree_376 tree_3761 0.8192
Cp_3761 tree_3761 0 2.592e-15
Rtr_376_3762 tree_376 tree_3762 0.8192
Cp_3762 tree_3762 0 2.592e-15
Rtr_376_3763 tree_376 tree_3763 0.8192
Cp_3763 tree_3763 0 2.592e-15
Rtr_376_3764 tree_376 tree_3764 0.8192
Cp_3764 tree_3764 0 2.592e-15
Rtr_376_3765 tree_376 tree_3765 0.8192
Cp_3765 tree_3765 0 2.592e-15
Rtr_376_3766 tree_376 tree_3766 0.8192
Cp_3766 tree_3766 0 2.592e-15
Rtr_376_3767 tree_376 tree_3767 0.8192
Cp_3767 tree_3767 0 2.592e-15
Rtr_376_3768 tree_376 tree_3768 0.8192
Cp_3768 tree_3768 0 2.592e-15
Rtr_376_3769 tree_376 tree_3769 0.8192
Cp_3769 tree_3769 0 2.592e-15
Rtr_376_3770 tree_376 tree_3770 0.8192
Cp_3770 tree_3770 0 2.592e-15
Rtr_377_3771 tree_377 tree_3771 0.8192
Cp_3771 tree_3771 0 2.592e-15
Rtr_377_3772 tree_377 tree_3772 0.8192
Cp_3772 tree_3772 0 2.592e-15
Rtr_377_3773 tree_377 tree_3773 0.8192
Cp_3773 tree_3773 0 2.592e-15
Rtr_377_3774 tree_377 tree_3774 0.8192
Cp_3774 tree_3774 0 2.592e-15
Rtr_377_3775 tree_377 tree_3775 0.8192
Cp_3775 tree_3775 0 2.592e-15
Rtr_377_3776 tree_377 tree_3776 0.8192
Cp_3776 tree_3776 0 2.592e-15
Rtr_377_3777 tree_377 tree_3777 0.8192
Cp_3777 tree_3777 0 2.592e-15
Rtr_377_3778 tree_377 tree_3778 0.8192
Cp_3778 tree_3778 0 2.592e-15
Rtr_377_3779 tree_377 tree_3779 0.8192
Cp_3779 tree_3779 0 2.592e-15
Rtr_377_3780 tree_377 tree_3780 0.8192
Cp_3780 tree_3780 0 2.592e-15
Rtr_378_3781 tree_378 tree_3781 0.8192
Cp_3781 tree_3781 0 2.592e-15
Rtr_378_3782 tree_378 tree_3782 0.8192
Cp_3782 tree_3782 0 2.592e-15
Rtr_378_3783 tree_378 tree_3783 0.8192
Cp_3783 tree_3783 0 2.592e-15
Rtr_378_3784 tree_378 tree_3784 0.8192
Cp_3784 tree_3784 0 2.592e-15
Rtr_378_3785 tree_378 tree_3785 0.8192
Cp_3785 tree_3785 0 2.592e-15
Rtr_378_3786 tree_378 tree_3786 0.8192
Cp_3786 tree_3786 0 2.592e-15
Rtr_378_3787 tree_378 tree_3787 0.8192
Cp_3787 tree_3787 0 2.592e-15
Rtr_378_3788 tree_378 tree_3788 0.8192
Cp_3788 tree_3788 0 2.592e-15
Rtr_378_3789 tree_378 tree_3789 0.8192
Cp_3789 tree_3789 0 2.592e-15
Rtr_378_3790 tree_378 tree_3790 0.8192
Cp_3790 tree_3790 0 2.592e-15
Rtr_379_3791 tree_379 tree_3791 0.8192
Cp_3791 tree_3791 0 2.592e-15
Rtr_379_3792 tree_379 tree_3792 0.8192
Cp_3792 tree_3792 0 2.592e-15
Rtr_379_3793 tree_379 tree_3793 0.8192
Cp_3793 tree_3793 0 2.592e-15
Rtr_379_3794 tree_379 tree_3794 0.8192
Cp_3794 tree_3794 0 2.592e-15
Rtr_379_3795 tree_379 tree_3795 0.8192
Cp_3795 tree_3795 0 2.592e-15
Rtr_379_3796 tree_379 tree_3796 0.8192
Cp_3796 tree_3796 0 2.592e-15
Rtr_379_3797 tree_379 tree_3797 0.8192
Cp_3797 tree_3797 0 2.592e-15
Rtr_379_3798 tree_379 tree_3798 0.8192
Cp_3798 tree_3798 0 2.592e-15
Rtr_379_3799 tree_379 tree_3799 0.8192
Cp_3799 tree_3799 0 2.592e-15
Rtr_379_3800 tree_379 tree_3800 0.8192
Cp_3800 tree_3800 0 2.592e-15
Rtr_380_3801 tree_380 tree_3801 0.8192
Cp_3801 tree_3801 0 2.592e-15
Rtr_380_3802 tree_380 tree_3802 0.8192
Cp_3802 tree_3802 0 2.592e-15
Rtr_380_3803 tree_380 tree_3803 0.8192
Cp_3803 tree_3803 0 2.592e-15
Rtr_380_3804 tree_380 tree_3804 0.8192
Cp_3804 tree_3804 0 2.592e-15
Rtr_380_3805 tree_380 tree_3805 0.8192
Cp_3805 tree_3805 0 2.592e-15
Rtr_380_3806 tree_380 tree_3806 0.8192
Cp_3806 tree_3806 0 2.592e-15
Rtr_380_3807 tree_380 tree_3807 0.8192
Cp_3807 tree_3807 0 2.592e-15
Rtr_380_3808 tree_380 tree_3808 0.8192
Cp_3808 tree_3808 0 2.592e-15
Rtr_380_3809 tree_380 tree_3809 0.8192
Cp_3809 tree_3809 0 2.592e-15
Rtr_380_3810 tree_380 tree_3810 0.8192
Cp_3810 tree_3810 0 2.592e-15
Rtr_381_3811 tree_381 tree_3811 0.8192
Cp_3811 tree_3811 0 2.592e-15
Rtr_381_3812 tree_381 tree_3812 0.8192
Cp_3812 tree_3812 0 2.592e-15
Rtr_381_3813 tree_381 tree_3813 0.8192
Cp_3813 tree_3813 0 2.592e-15
Rtr_381_3814 tree_381 tree_3814 0.8192
Cp_3814 tree_3814 0 2.592e-15
Rtr_381_3815 tree_381 tree_3815 0.8192
Cp_3815 tree_3815 0 2.592e-15
Rtr_381_3816 tree_381 tree_3816 0.8192
Cp_3816 tree_3816 0 2.592e-15
Rtr_381_3817 tree_381 tree_3817 0.8192
Cp_3817 tree_3817 0 2.592e-15
Rtr_381_3818 tree_381 tree_3818 0.8192
Cp_3818 tree_3818 0 2.592e-15
Rtr_381_3819 tree_381 tree_3819 0.8192
Cp_3819 tree_3819 0 2.592e-15
Rtr_381_3820 tree_381 tree_3820 0.8192
Cp_3820 tree_3820 0 2.592e-15
Rtr_382_3821 tree_382 tree_3821 0.8192
Cp_3821 tree_3821 0 2.592e-15
Rtr_382_3822 tree_382 tree_3822 0.8192
Cp_3822 tree_3822 0 2.592e-15
Rtr_382_3823 tree_382 tree_3823 0.8192
Cp_3823 tree_3823 0 2.592e-15
Rtr_382_3824 tree_382 tree_3824 0.8192
Cp_3824 tree_3824 0 2.592e-15
Rtr_382_3825 tree_382 tree_3825 0.8192
Cp_3825 tree_3825 0 2.592e-15
Rtr_382_3826 tree_382 tree_3826 0.8192
Cp_3826 tree_3826 0 2.592e-15
Rtr_382_3827 tree_382 tree_3827 0.8192
Cp_3827 tree_3827 0 2.592e-15
Rtr_382_3828 tree_382 tree_3828 0.8192
Cp_3828 tree_3828 0 2.592e-15
Rtr_382_3829 tree_382 tree_3829 0.8192
Cp_3829 tree_3829 0 2.592e-15
Rtr_382_3830 tree_382 tree_3830 0.8192
Cp_3830 tree_3830 0 2.592e-15
Rtr_383_3831 tree_383 tree_3831 0.8192
Cp_3831 tree_3831 0 2.592e-15
Rtr_383_3832 tree_383 tree_3832 0.8192
Cp_3832 tree_3832 0 2.592e-15
Rtr_383_3833 tree_383 tree_3833 0.8192
Cp_3833 tree_3833 0 2.592e-15
Rtr_383_3834 tree_383 tree_3834 0.8192
Cp_3834 tree_3834 0 2.592e-15
Rtr_383_3835 tree_383 tree_3835 0.8192
Cp_3835 tree_3835 0 2.592e-15
Rtr_383_3836 tree_383 tree_3836 0.8192
Cp_3836 tree_3836 0 2.592e-15
Rtr_383_3837 tree_383 tree_3837 0.8192
Cp_3837 tree_3837 0 2.592e-15
Rtr_383_3838 tree_383 tree_3838 0.8192
Cp_3838 tree_3838 0 2.592e-15
Rtr_383_3839 tree_383 tree_3839 0.8192
Cp_3839 tree_3839 0 2.592e-15
Rtr_383_3840 tree_383 tree_3840 0.8192
Cp_3840 tree_3840 0 2.592e-15
Rtr_384_3841 tree_384 tree_3841 0.8192
Cp_3841 tree_3841 0 2.592e-15
Rtr_384_3842 tree_384 tree_3842 0.8192
Cp_3842 tree_3842 0 2.592e-15
Rtr_384_3843 tree_384 tree_3843 0.8192
Cp_3843 tree_3843 0 2.592e-15
Rtr_384_3844 tree_384 tree_3844 0.8192
Cp_3844 tree_3844 0 2.592e-15
Rtr_384_3845 tree_384 tree_3845 0.8192
Cp_3845 tree_3845 0 2.592e-15
Rtr_384_3846 tree_384 tree_3846 0.8192
Cp_3846 tree_3846 0 2.592e-15
Rtr_384_3847 tree_384 tree_3847 0.8192
Cp_3847 tree_3847 0 2.592e-15
Rtr_384_3848 tree_384 tree_3848 0.8192
Cp_3848 tree_3848 0 2.592e-15
Rtr_384_3849 tree_384 tree_3849 0.8192
Cp_3849 tree_3849 0 2.592e-15
Rtr_384_3850 tree_384 tree_3850 0.8192
Cp_3850 tree_3850 0 2.592e-15
Rtr_385_3851 tree_385 tree_3851 0.8192
Cp_3851 tree_3851 0 2.592e-15
Rtr_385_3852 tree_385 tree_3852 0.8192
Cp_3852 tree_3852 0 2.592e-15
Rtr_385_3853 tree_385 tree_3853 0.8192
Cp_3853 tree_3853 0 2.592e-15
Rtr_385_3854 tree_385 tree_3854 0.8192
Cp_3854 tree_3854 0 2.592e-15
Rtr_385_3855 tree_385 tree_3855 0.8192
Cp_3855 tree_3855 0 2.592e-15
Rtr_385_3856 tree_385 tree_3856 0.8192
Cp_3856 tree_3856 0 2.592e-15
Rtr_385_3857 tree_385 tree_3857 0.8192
Cp_3857 tree_3857 0 2.592e-15
Rtr_385_3858 tree_385 tree_3858 0.8192
Cp_3858 tree_3858 0 2.592e-15
Rtr_385_3859 tree_385 tree_3859 0.8192
Cp_3859 tree_3859 0 2.592e-15
Rtr_385_3860 tree_385 tree_3860 0.8192
Cp_3860 tree_3860 0 2.592e-15
Rtr_386_3861 tree_386 tree_3861 0.8192
Cp_3861 tree_3861 0 2.592e-15
Rtr_386_3862 tree_386 tree_3862 0.8192
Cp_3862 tree_3862 0 2.592e-15
Rtr_386_3863 tree_386 tree_3863 0.8192
Cp_3863 tree_3863 0 2.592e-15
Rtr_386_3864 tree_386 tree_3864 0.8192
Cp_3864 tree_3864 0 2.592e-15
Rtr_386_3865 tree_386 tree_3865 0.8192
Cp_3865 tree_3865 0 2.592e-15
Rtr_386_3866 tree_386 tree_3866 0.8192
Cp_3866 tree_3866 0 2.592e-15
Rtr_386_3867 tree_386 tree_3867 0.8192
Cp_3867 tree_3867 0 2.592e-15
Rtr_386_3868 tree_386 tree_3868 0.8192
Cp_3868 tree_3868 0 2.592e-15
Rtr_386_3869 tree_386 tree_3869 0.8192
Cp_3869 tree_3869 0 2.592e-15
Rtr_386_3870 tree_386 tree_3870 0.8192
Cp_3870 tree_3870 0 2.592e-15
Rtr_387_3871 tree_387 tree_3871 0.8192
Cp_3871 tree_3871 0 2.592e-15
Rtr_387_3872 tree_387 tree_3872 0.8192
Cp_3872 tree_3872 0 2.592e-15
Rtr_387_3873 tree_387 tree_3873 0.8192
Cp_3873 tree_3873 0 2.592e-15
Rtr_387_3874 tree_387 tree_3874 0.8192
Cp_3874 tree_3874 0 2.592e-15
Rtr_387_3875 tree_387 tree_3875 0.8192
Cp_3875 tree_3875 0 2.592e-15
Rtr_387_3876 tree_387 tree_3876 0.8192
Cp_3876 tree_3876 0 2.592e-15
Rtr_387_3877 tree_387 tree_3877 0.8192
Cp_3877 tree_3877 0 2.592e-15
Rtr_387_3878 tree_387 tree_3878 0.8192
Cp_3878 tree_3878 0 2.592e-15
Rtr_387_3879 tree_387 tree_3879 0.8192
Cp_3879 tree_3879 0 2.592e-15
Rtr_387_3880 tree_387 tree_3880 0.8192
Cp_3880 tree_3880 0 2.592e-15
Rtr_388_3881 tree_388 tree_3881 0.8192
Cp_3881 tree_3881 0 2.592e-15
Rtr_388_3882 tree_388 tree_3882 0.8192
Cp_3882 tree_3882 0 2.592e-15
Rtr_388_3883 tree_388 tree_3883 0.8192
Cp_3883 tree_3883 0 2.592e-15
Rtr_388_3884 tree_388 tree_3884 0.8192
Cp_3884 tree_3884 0 2.592e-15
Rtr_388_3885 tree_388 tree_3885 0.8192
Cp_3885 tree_3885 0 2.592e-15
Rtr_388_3886 tree_388 tree_3886 0.8192
Cp_3886 tree_3886 0 2.592e-15
Rtr_388_3887 tree_388 tree_3887 0.8192
Cp_3887 tree_3887 0 2.592e-15
Rtr_388_3888 tree_388 tree_3888 0.8192
Cp_3888 tree_3888 0 2.592e-15
Rtr_388_3889 tree_388 tree_3889 0.8192
Cp_3889 tree_3889 0 2.592e-15
Rtr_388_3890 tree_388 tree_3890 0.8192
Cp_3890 tree_3890 0 2.592e-15
Rtr_389_3891 tree_389 tree_3891 0.8192
Cp_3891 tree_3891 0 2.592e-15
Rtr_389_3892 tree_389 tree_3892 0.8192
Cp_3892 tree_3892 0 2.592e-15
Rtr_389_3893 tree_389 tree_3893 0.8192
Cp_3893 tree_3893 0 2.592e-15
Rtr_389_3894 tree_389 tree_3894 0.8192
Cp_3894 tree_3894 0 2.592e-15
Rtr_389_3895 tree_389 tree_3895 0.8192
Cp_3895 tree_3895 0 2.592e-15
Rtr_389_3896 tree_389 tree_3896 0.8192
Cp_3896 tree_3896 0 2.592e-15
Rtr_389_3897 tree_389 tree_3897 0.8192
Cp_3897 tree_3897 0 2.592e-15
Rtr_389_3898 tree_389 tree_3898 0.8192
Cp_3898 tree_3898 0 2.592e-15
Rtr_389_3899 tree_389 tree_3899 0.8192
Cp_3899 tree_3899 0 2.592e-15
Rtr_389_3900 tree_389 tree_3900 0.8192
Cp_3900 tree_3900 0 2.592e-15
Rtr_390_3901 tree_390 tree_3901 0.8192
Cp_3901 tree_3901 0 2.592e-15
Rtr_390_3902 tree_390 tree_3902 0.8192
Cp_3902 tree_3902 0 2.592e-15
Rtr_390_3903 tree_390 tree_3903 0.8192
Cp_3903 tree_3903 0 2.592e-15
Rtr_390_3904 tree_390 tree_3904 0.8192
Cp_3904 tree_3904 0 2.592e-15
Rtr_390_3905 tree_390 tree_3905 0.8192
Cp_3905 tree_3905 0 2.592e-15
Rtr_390_3906 tree_390 tree_3906 0.8192
Cp_3906 tree_3906 0 2.592e-15
Rtr_390_3907 tree_390 tree_3907 0.8192
Cp_3907 tree_3907 0 2.592e-15
Rtr_390_3908 tree_390 tree_3908 0.8192
Cp_3908 tree_3908 0 2.592e-15
Rtr_390_3909 tree_390 tree_3909 0.8192
Cp_3909 tree_3909 0 2.592e-15
Rtr_390_3910 tree_390 tree_3910 0.8192
Cp_3910 tree_3910 0 2.592e-15
Rtr_391_3911 tree_391 tree_3911 0.8192
Cp_3911 tree_3911 0 2.592e-15
Rtr_391_3912 tree_391 tree_3912 0.8192
Cp_3912 tree_3912 0 2.592e-15
Rtr_391_3913 tree_391 tree_3913 0.8192
Cp_3913 tree_3913 0 2.592e-15
Rtr_391_3914 tree_391 tree_3914 0.8192
Cp_3914 tree_3914 0 2.592e-15
Rtr_391_3915 tree_391 tree_3915 0.8192
Cp_3915 tree_3915 0 2.592e-15
Rtr_391_3916 tree_391 tree_3916 0.8192
Cp_3916 tree_3916 0 2.592e-15
Rtr_391_3917 tree_391 tree_3917 0.8192
Cp_3917 tree_3917 0 2.592e-15
Rtr_391_3918 tree_391 tree_3918 0.8192
Cp_3918 tree_3918 0 2.592e-15
Rtr_391_3919 tree_391 tree_3919 0.8192
Cp_3919 tree_3919 0 2.592e-15
Rtr_391_3920 tree_391 tree_3920 0.8192
Cp_3920 tree_3920 0 2.592e-15
Rtr_392_3921 tree_392 tree_3921 0.8192
Cp_3921 tree_3921 0 2.592e-15
Rtr_392_3922 tree_392 tree_3922 0.8192
Cp_3922 tree_3922 0 2.592e-15
Rtr_392_3923 tree_392 tree_3923 0.8192
Cp_3923 tree_3923 0 2.592e-15
Rtr_392_3924 tree_392 tree_3924 0.8192
Cp_3924 tree_3924 0 2.592e-15
Rtr_392_3925 tree_392 tree_3925 0.8192
Cp_3925 tree_3925 0 2.592e-15
Rtr_392_3926 tree_392 tree_3926 0.8192
Cp_3926 tree_3926 0 2.592e-15
Rtr_392_3927 tree_392 tree_3927 0.8192
Cp_3927 tree_3927 0 2.592e-15
Rtr_392_3928 tree_392 tree_3928 0.8192
Cp_3928 tree_3928 0 2.592e-15
Rtr_392_3929 tree_392 tree_3929 0.8192
Cp_3929 tree_3929 0 2.592e-15
Rtr_392_3930 tree_392 tree_3930 0.8192
Cp_3930 tree_3930 0 2.592e-15
Rtr_393_3931 tree_393 tree_3931 0.8192
Cp_3931 tree_3931 0 2.592e-15
Rtr_393_3932 tree_393 tree_3932 0.8192
Cp_3932 tree_3932 0 2.592e-15
Rtr_393_3933 tree_393 tree_3933 0.8192
Cp_3933 tree_3933 0 2.592e-15
Rtr_393_3934 tree_393 tree_3934 0.8192
Cp_3934 tree_3934 0 2.592e-15
Rtr_393_3935 tree_393 tree_3935 0.8192
Cp_3935 tree_3935 0 2.592e-15
Rtr_393_3936 tree_393 tree_3936 0.8192
Cp_3936 tree_3936 0 2.592e-15
Rtr_393_3937 tree_393 tree_3937 0.8192
Cp_3937 tree_3937 0 2.592e-15
Rtr_393_3938 tree_393 tree_3938 0.8192
Cp_3938 tree_3938 0 2.592e-15
Rtr_393_3939 tree_393 tree_3939 0.8192
Cp_3939 tree_3939 0 2.592e-15
Rtr_393_3940 tree_393 tree_3940 0.8192
Cp_3940 tree_3940 0 2.592e-15
Rtr_394_3941 tree_394 tree_3941 0.8192
Cp_3941 tree_3941 0 2.592e-15
Rtr_394_3942 tree_394 tree_3942 0.8192
Cp_3942 tree_3942 0 2.592e-15
Rtr_394_3943 tree_394 tree_3943 0.8192
Cp_3943 tree_3943 0 2.592e-15
Rtr_394_3944 tree_394 tree_3944 0.8192
Cp_3944 tree_3944 0 2.592e-15
Rtr_394_3945 tree_394 tree_3945 0.8192
Cp_3945 tree_3945 0 2.592e-15
Rtr_394_3946 tree_394 tree_3946 0.8192
Cp_3946 tree_3946 0 2.592e-15
Rtr_394_3947 tree_394 tree_3947 0.8192
Cp_3947 tree_3947 0 2.592e-15
Rtr_394_3948 tree_394 tree_3948 0.8192
Cp_3948 tree_3948 0 2.592e-15
Rtr_394_3949 tree_394 tree_3949 0.8192
Cp_3949 tree_3949 0 2.592e-15
Rtr_394_3950 tree_394 tree_3950 0.8192
Cp_3950 tree_3950 0 2.592e-15
Rtr_395_3951 tree_395 tree_3951 0.8192
Cp_3951 tree_3951 0 2.592e-15
Rtr_395_3952 tree_395 tree_3952 0.8192
Cp_3952 tree_3952 0 2.592e-15
Rtr_395_3953 tree_395 tree_3953 0.8192
Cp_3953 tree_3953 0 2.592e-15
Rtr_395_3954 tree_395 tree_3954 0.8192
Cp_3954 tree_3954 0 2.592e-15
Rtr_395_3955 tree_395 tree_3955 0.8192
Cp_3955 tree_3955 0 2.592e-15
Rtr_395_3956 tree_395 tree_3956 0.8192
Cp_3956 tree_3956 0 2.592e-15
Rtr_395_3957 tree_395 tree_3957 0.8192
Cp_3957 tree_3957 0 2.592e-15
Rtr_395_3958 tree_395 tree_3958 0.8192
Cp_3958 tree_3958 0 2.592e-15
Rtr_395_3959 tree_395 tree_3959 0.8192
Cp_3959 tree_3959 0 2.592e-15
Rtr_395_3960 tree_395 tree_3960 0.8192
Cp_3960 tree_3960 0 2.592e-15
Rtr_396_3961 tree_396 tree_3961 0.8192
Cp_3961 tree_3961 0 2.592e-15
Rtr_396_3962 tree_396 tree_3962 0.8192
Cp_3962 tree_3962 0 2.592e-15
Rtr_396_3963 tree_396 tree_3963 0.8192
Cp_3963 tree_3963 0 2.592e-15
Rtr_396_3964 tree_396 tree_3964 0.8192
Cp_3964 tree_3964 0 2.592e-15
Rtr_396_3965 tree_396 tree_3965 0.8192
Cp_3965 tree_3965 0 2.592e-15
Rtr_396_3966 tree_396 tree_3966 0.8192
Cp_3966 tree_3966 0 2.592e-15
Rtr_396_3967 tree_396 tree_3967 0.8192
Cp_3967 tree_3967 0 2.592e-15
Rtr_396_3968 tree_396 tree_3968 0.8192
Cp_3968 tree_3968 0 2.592e-15
Rtr_396_3969 tree_396 tree_3969 0.8192
Cp_3969 tree_3969 0 2.592e-15
Rtr_396_3970 tree_396 tree_3970 0.8192
Cp_3970 tree_3970 0 2.592e-15
Rtr_397_3971 tree_397 tree_3971 0.8192
Cp_3971 tree_3971 0 2.592e-15
Rtr_397_3972 tree_397 tree_3972 0.8192
Cp_3972 tree_3972 0 2.592e-15
Rtr_397_3973 tree_397 tree_3973 0.8192
Cp_3973 tree_3973 0 2.592e-15
Rtr_397_3974 tree_397 tree_3974 0.8192
Cp_3974 tree_3974 0 2.592e-15
Rtr_397_3975 tree_397 tree_3975 0.8192
Cp_3975 tree_3975 0 2.592e-15
Rtr_397_3976 tree_397 tree_3976 0.8192
Cp_3976 tree_3976 0 2.592e-15
Rtr_397_3977 tree_397 tree_3977 0.8192
Cp_3977 tree_3977 0 2.592e-15
Rtr_397_3978 tree_397 tree_3978 0.8192
Cp_3978 tree_3978 0 2.592e-15
Rtr_397_3979 tree_397 tree_3979 0.8192
Cp_3979 tree_3979 0 2.592e-15
Rtr_397_3980 tree_397 tree_3980 0.8192
Cp_3980 tree_3980 0 2.592e-15
Rtr_398_3981 tree_398 tree_3981 0.8192
Cp_3981 tree_3981 0 2.592e-15
Rtr_398_3982 tree_398 tree_3982 0.8192
Cp_3982 tree_3982 0 2.592e-15
Rtr_398_3983 tree_398 tree_3983 0.8192
Cp_3983 tree_3983 0 2.592e-15
Rtr_398_3984 tree_398 tree_3984 0.8192
Cp_3984 tree_3984 0 2.592e-15
Rtr_398_3985 tree_398 tree_3985 0.8192
Cp_3985 tree_3985 0 2.592e-15
Rtr_398_3986 tree_398 tree_3986 0.8192
Cp_3986 tree_3986 0 2.592e-15
Rtr_398_3987 tree_398 tree_3987 0.8192
Cp_3987 tree_3987 0 2.592e-15
Rtr_398_3988 tree_398 tree_3988 0.8192
Cp_3988 tree_3988 0 2.592e-15
Rtr_398_3989 tree_398 tree_3989 0.8192
Cp_3989 tree_3989 0 2.592e-15
Rtr_398_3990 tree_398 tree_3990 0.8192
Cp_3990 tree_3990 0 2.592e-15
Rtr_399_3991 tree_399 tree_3991 0.8192
Cp_3991 tree_3991 0 2.592e-15
Rtr_399_3992 tree_399 tree_3992 0.8192
Cp_3992 tree_3992 0 2.592e-15
Rtr_399_3993 tree_399 tree_3993 0.8192
Cp_3993 tree_3993 0 2.592e-15
Rtr_399_3994 tree_399 tree_3994 0.8192
Cp_3994 tree_3994 0 2.592e-15
Rtr_399_3995 tree_399 tree_3995 0.8192
Cp_3995 tree_3995 0 2.592e-15
Rtr_399_3996 tree_399 tree_3996 0.8192
Cp_3996 tree_3996 0 2.592e-15
Rtr_399_3997 tree_399 tree_3997 0.8192
Cp_3997 tree_3997 0 2.592e-15
Rtr_399_3998 tree_399 tree_3998 0.8192
Cp_3998 tree_3998 0 2.592e-15
Rtr_399_3999 tree_399 tree_3999 0.8192
Cp_3999 tree_3999 0 2.592e-15
Rtr_399_4000 tree_399 tree_4000 0.8192
Cp_4000 tree_4000 0 2.592e-15
Rtr_400_4001 tree_400 tree_4001 0.8192
Cp_4001 tree_4001 0 2.592e-15
Rtr_400_4002 tree_400 tree_4002 0.8192
Cp_4002 tree_4002 0 2.592e-15
Rtr_400_4003 tree_400 tree_4003 0.8192
Cp_4003 tree_4003 0 2.592e-15
Rtr_400_4004 tree_400 tree_4004 0.8192
Cp_4004 tree_4004 0 2.592e-15
Rtr_400_4005 tree_400 tree_4005 0.8192
Cp_4005 tree_4005 0 2.592e-15
Rtr_400_4006 tree_400 tree_4006 0.8192
Cp_4006 tree_4006 0 2.592e-15
Rtr_400_4007 tree_400 tree_4007 0.8192
Cp_4007 tree_4007 0 2.592e-15
Rtr_400_4008 tree_400 tree_4008 0.8192
Cp_4008 tree_4008 0 2.592e-15
Rtr_400_4009 tree_400 tree_4009 0.8192
Cp_4009 tree_4009 0 2.592e-15
Rtr_400_4010 tree_400 tree_4010 0.8192
Cp_4010 tree_4010 0 2.592e-15
Rtr_401_4011 tree_401 tree_4011 0.8192
Cp_4011 tree_4011 0 2.592e-15
Rtr_401_4012 tree_401 tree_4012 0.8192
Cp_4012 tree_4012 0 2.592e-15
Rtr_401_4013 tree_401 tree_4013 0.8192
Cp_4013 tree_4013 0 2.592e-15
Rtr_401_4014 tree_401 tree_4014 0.8192
Cp_4014 tree_4014 0 2.592e-15
Rtr_401_4015 tree_401 tree_4015 0.8192
Cp_4015 tree_4015 0 2.592e-15
Rtr_401_4016 tree_401 tree_4016 0.8192
Cp_4016 tree_4016 0 2.592e-15
Rtr_401_4017 tree_401 tree_4017 0.8192
Cp_4017 tree_4017 0 2.592e-15
Rtr_401_4018 tree_401 tree_4018 0.8192
Cp_4018 tree_4018 0 2.592e-15
Rtr_401_4019 tree_401 tree_4019 0.8192
Cp_4019 tree_4019 0 2.592e-15
Rtr_401_4020 tree_401 tree_4020 0.8192
Cp_4020 tree_4020 0 2.592e-15
Rtr_402_4021 tree_402 tree_4021 0.8192
Cp_4021 tree_4021 0 2.592e-15
Rtr_402_4022 tree_402 tree_4022 0.8192
Cp_4022 tree_4022 0 2.592e-15
Rtr_402_4023 tree_402 tree_4023 0.8192
Cp_4023 tree_4023 0 2.592e-15
Rtr_402_4024 tree_402 tree_4024 0.8192
Cp_4024 tree_4024 0 2.592e-15
Rtr_402_4025 tree_402 tree_4025 0.8192
Cp_4025 tree_4025 0 2.592e-15
Rtr_402_4026 tree_402 tree_4026 0.8192
Cp_4026 tree_4026 0 2.592e-15
Rtr_402_4027 tree_402 tree_4027 0.8192
Cp_4027 tree_4027 0 2.592e-15
Rtr_402_4028 tree_402 tree_4028 0.8192
Cp_4028 tree_4028 0 2.592e-15
Rtr_402_4029 tree_402 tree_4029 0.8192
Cp_4029 tree_4029 0 2.592e-15
Rtr_402_4030 tree_402 tree_4030 0.8192
Cp_4030 tree_4030 0 2.592e-15
Rtr_403_4031 tree_403 tree_4031 0.8192
Cp_4031 tree_4031 0 2.592e-15
Rtr_403_4032 tree_403 tree_4032 0.8192
Cp_4032 tree_4032 0 2.592e-15
Rtr_403_4033 tree_403 tree_4033 0.8192
Cp_4033 tree_4033 0 2.592e-15
Rtr_403_4034 tree_403 tree_4034 0.8192
Cp_4034 tree_4034 0 2.592e-15
Rtr_403_4035 tree_403 tree_4035 0.8192
Cp_4035 tree_4035 0 2.592e-15
Rtr_403_4036 tree_403 tree_4036 0.8192
Cp_4036 tree_4036 0 2.592e-15
Rtr_403_4037 tree_403 tree_4037 0.8192
Cp_4037 tree_4037 0 2.592e-15
Rtr_403_4038 tree_403 tree_4038 0.8192
Cp_4038 tree_4038 0 2.592e-15
Rtr_403_4039 tree_403 tree_4039 0.8192
Cp_4039 tree_4039 0 2.592e-15
Rtr_403_4040 tree_403 tree_4040 0.8192
Cp_4040 tree_4040 0 2.592e-15
Rtr_404_4041 tree_404 tree_4041 0.8192
Cp_4041 tree_4041 0 2.592e-15
Rtr_404_4042 tree_404 tree_4042 0.8192
Cp_4042 tree_4042 0 2.592e-15
Rtr_404_4043 tree_404 tree_4043 0.8192
Cp_4043 tree_4043 0 2.592e-15
Rtr_404_4044 tree_404 tree_4044 0.8192
Cp_4044 tree_4044 0 2.592e-15
Rtr_404_4045 tree_404 tree_4045 0.8192
Cp_4045 tree_4045 0 2.592e-15
Rtr_404_4046 tree_404 tree_4046 0.8192
Cp_4046 tree_4046 0 2.592e-15
Rtr_404_4047 tree_404 tree_4047 0.8192
Cp_4047 tree_4047 0 2.592e-15
Rtr_404_4048 tree_404 tree_4048 0.8192
Cp_4048 tree_4048 0 2.592e-15
Rtr_404_4049 tree_404 tree_4049 0.8192
Cp_4049 tree_4049 0 2.592e-15
Rtr_404_4050 tree_404 tree_4050 0.8192
Cp_4050 tree_4050 0 2.592e-15
Rtr_405_4051 tree_405 tree_4051 0.8192
Cp_4051 tree_4051 0 2.592e-15
Rtr_405_4052 tree_405 tree_4052 0.8192
Cp_4052 tree_4052 0 2.592e-15
Rtr_405_4053 tree_405 tree_4053 0.8192
Cp_4053 tree_4053 0 2.592e-15
Rtr_405_4054 tree_405 tree_4054 0.8192
Cp_4054 tree_4054 0 2.592e-15
Rtr_405_4055 tree_405 tree_4055 0.8192
Cp_4055 tree_4055 0 2.592e-15
Rtr_405_4056 tree_405 tree_4056 0.8192
Cp_4056 tree_4056 0 2.592e-15
Rtr_405_4057 tree_405 tree_4057 0.8192
Cp_4057 tree_4057 0 2.592e-15
Rtr_405_4058 tree_405 tree_4058 0.8192
Cp_4058 tree_4058 0 2.592e-15
Rtr_405_4059 tree_405 tree_4059 0.8192
Cp_4059 tree_4059 0 2.592e-15
Rtr_405_4060 tree_405 tree_4060 0.8192
Cp_4060 tree_4060 0 2.592e-15
Rtr_406_4061 tree_406 tree_4061 0.8192
Cp_4061 tree_4061 0 2.592e-15
Rtr_406_4062 tree_406 tree_4062 0.8192
Cp_4062 tree_4062 0 2.592e-15
Rtr_406_4063 tree_406 tree_4063 0.8192
Cp_4063 tree_4063 0 2.592e-15
Rtr_406_4064 tree_406 tree_4064 0.8192
Cp_4064 tree_4064 0 2.592e-15
Rtr_406_4065 tree_406 tree_4065 0.8192
Cp_4065 tree_4065 0 2.592e-15
Rtr_406_4066 tree_406 tree_4066 0.8192
Cp_4066 tree_4066 0 2.592e-15
Rtr_406_4067 tree_406 tree_4067 0.8192
Cp_4067 tree_4067 0 2.592e-15
Rtr_406_4068 tree_406 tree_4068 0.8192
Cp_4068 tree_4068 0 2.592e-15
Rtr_406_4069 tree_406 tree_4069 0.8192
Cp_4069 tree_4069 0 2.592e-15
Rtr_406_4070 tree_406 tree_4070 0.8192
Cp_4070 tree_4070 0 2.592e-15
Rtr_407_4071 tree_407 tree_4071 0.8192
Cp_4071 tree_4071 0 2.592e-15
Rtr_407_4072 tree_407 tree_4072 0.8192
Cp_4072 tree_4072 0 2.592e-15
Rtr_407_4073 tree_407 tree_4073 0.8192
Cp_4073 tree_4073 0 2.592e-15
Rtr_407_4074 tree_407 tree_4074 0.8192
Cp_4074 tree_4074 0 2.592e-15
Rtr_407_4075 tree_407 tree_4075 0.8192
Cp_4075 tree_4075 0 2.592e-15
Rtr_407_4076 tree_407 tree_4076 0.8192
Cp_4076 tree_4076 0 2.592e-15
Rtr_407_4077 tree_407 tree_4077 0.8192
Cp_4077 tree_4077 0 2.592e-15
Rtr_407_4078 tree_407 tree_4078 0.8192
Cp_4078 tree_4078 0 2.592e-15
Rtr_407_4079 tree_407 tree_4079 0.8192
Cp_4079 tree_4079 0 2.592e-15
Rtr_407_4080 tree_407 tree_4080 0.8192
Cp_4080 tree_4080 0 2.592e-15
Rtr_408_4081 tree_408 tree_4081 0.8192
Cp_4081 tree_4081 0 2.592e-15
Rtr_408_4082 tree_408 tree_4082 0.8192
Cp_4082 tree_4082 0 2.592e-15
Rtr_408_4083 tree_408 tree_4083 0.8192
Cp_4083 tree_4083 0 2.592e-15
Rtr_408_4084 tree_408 tree_4084 0.8192
Cp_4084 tree_4084 0 2.592e-15
Rtr_408_4085 tree_408 tree_4085 0.8192
Cp_4085 tree_4085 0 2.592e-15
Rtr_408_4086 tree_408 tree_4086 0.8192
Cp_4086 tree_4086 0 2.592e-15
Rtr_408_4087 tree_408 tree_4087 0.8192
Cp_4087 tree_4087 0 2.592e-15
Rtr_408_4088 tree_408 tree_4088 0.8192
Cp_4088 tree_4088 0 2.592e-15
Rtr_408_4089 tree_408 tree_4089 0.8192
Cp_4089 tree_4089 0 2.592e-15
Rtr_408_4090 tree_408 tree_4090 0.8192
Cp_4090 tree_4090 0 2.592e-15
Rtr_409_4091 tree_409 tree_4091 0.8192
Cp_4091 tree_4091 0 2.592e-15
Rtr_409_4092 tree_409 tree_4092 0.8192
Cp_4092 tree_4092 0 2.592e-15
Rtr_409_4093 tree_409 tree_4093 0.8192
Cp_4093 tree_4093 0 2.592e-15
Rtr_409_4094 tree_409 tree_4094 0.8192
Cp_4094 tree_4094 0 2.592e-15
Rtr_409_4095 tree_409 tree_4095 0.8192
Cp_4095 tree_4095 0 2.592e-15
Rtr_409_4096 tree_409 tree_4096 0.8192
Cp_4096 tree_4096 0 2.592e-15
Rtr_409_4097 tree_409 tree_4097 0.8192
Cp_4097 tree_4097 0 2.592e-15
Rtr_409_4098 tree_409 tree_4098 0.8192
Cp_4098 tree_4098 0 2.592e-15
Rtr_409_4099 tree_409 tree_4099 0.8192
Cp_4099 tree_4099 0 2.592e-15
Rtr_409_4100 tree_409 tree_4100 0.8192
Cp_4100 tree_4100 0 2.592e-15
Rtr_410_4101 tree_410 tree_4101 0.8192
Cp_4101 tree_4101 0 2.592e-15
Rtr_410_4102 tree_410 tree_4102 0.8192
Cp_4102 tree_4102 0 2.592e-15
Rtr_410_4103 tree_410 tree_4103 0.8192
Cp_4103 tree_4103 0 2.592e-15
Rtr_410_4104 tree_410 tree_4104 0.8192
Cp_4104 tree_4104 0 2.592e-15
Rtr_410_4105 tree_410 tree_4105 0.8192
Cp_4105 tree_4105 0 2.592e-15
Rtr_410_4106 tree_410 tree_4106 0.8192
Cp_4106 tree_4106 0 2.592e-15
Rtr_410_4107 tree_410 tree_4107 0.8192
Cp_4107 tree_4107 0 2.592e-15
Rtr_410_4108 tree_410 tree_4108 0.8192
Cp_4108 tree_4108 0 2.592e-15
Rtr_410_4109 tree_410 tree_4109 0.8192
Cp_4109 tree_4109 0 2.592e-15
Rtr_410_4110 tree_410 tree_4110 0.8192
Cp_4110 tree_4110 0 2.592e-15
Rtr_411_4111 tree_411 tree_4111 0.8192
Cp_4111 tree_4111 0 2.592e-15
Rtr_411_4112 tree_411 tree_4112 0.8192
Cp_4112 tree_4112 0 2.592e-15
Rtr_411_4113 tree_411 tree_4113 0.8192
Cp_4113 tree_4113 0 2.592e-15
Rtr_411_4114 tree_411 tree_4114 0.8192
Cp_4114 tree_4114 0 2.592e-15
Rtr_411_4115 tree_411 tree_4115 0.8192
Cp_4115 tree_4115 0 2.592e-15
Rtr_411_4116 tree_411 tree_4116 0.8192
Cp_4116 tree_4116 0 2.592e-15
Rtr_411_4117 tree_411 tree_4117 0.8192
Cp_4117 tree_4117 0 2.592e-15
Rtr_411_4118 tree_411 tree_4118 0.8192
Cp_4118 tree_4118 0 2.592e-15
Rtr_411_4119 tree_411 tree_4119 0.8192
Cp_4119 tree_4119 0 2.592e-15
Rtr_411_4120 tree_411 tree_4120 0.8192
Cp_4120 tree_4120 0 2.592e-15
Rtr_412_4121 tree_412 tree_4121 0.8192
Cp_4121 tree_4121 0 2.592e-15
Rtr_412_4122 tree_412 tree_4122 0.8192
Cp_4122 tree_4122 0 2.592e-15
Rtr_412_4123 tree_412 tree_4123 0.8192
Cp_4123 tree_4123 0 2.592e-15
Rtr_412_4124 tree_412 tree_4124 0.8192
Cp_4124 tree_4124 0 2.592e-15
Rtr_412_4125 tree_412 tree_4125 0.8192
Cp_4125 tree_4125 0 2.592e-15
Rtr_412_4126 tree_412 tree_4126 0.8192
Cp_4126 tree_4126 0 2.592e-15
Rtr_412_4127 tree_412 tree_4127 0.8192
Cp_4127 tree_4127 0 2.592e-15
Rtr_412_4128 tree_412 tree_4128 0.8192
Cp_4128 tree_4128 0 2.592e-15
Rtr_412_4129 tree_412 tree_4129 0.8192
Cp_4129 tree_4129 0 2.592e-15
Rtr_412_4130 tree_412 tree_4130 0.8192
Cp_4130 tree_4130 0 2.592e-15
Rtr_413_4131 tree_413 tree_4131 0.8192
Cp_4131 tree_4131 0 2.592e-15
Rtr_413_4132 tree_413 tree_4132 0.8192
Cp_4132 tree_4132 0 2.592e-15
Rtr_413_4133 tree_413 tree_4133 0.8192
Cp_4133 tree_4133 0 2.592e-15
Rtr_413_4134 tree_413 tree_4134 0.8192
Cp_4134 tree_4134 0 2.592e-15
Rtr_413_4135 tree_413 tree_4135 0.8192
Cp_4135 tree_4135 0 2.592e-15
Rtr_413_4136 tree_413 tree_4136 0.8192
Cp_4136 tree_4136 0 2.592e-15
Rtr_413_4137 tree_413 tree_4137 0.8192
Cp_4137 tree_4137 0 2.592e-15
Rtr_413_4138 tree_413 tree_4138 0.8192
Cp_4138 tree_4138 0 2.592e-15
Rtr_413_4139 tree_413 tree_4139 0.8192
Cp_4139 tree_4139 0 2.592e-15
Rtr_413_4140 tree_413 tree_4140 0.8192
Cp_4140 tree_4140 0 2.592e-15
Rtr_414_4141 tree_414 tree_4141 0.8192
Cp_4141 tree_4141 0 2.592e-15
Rtr_414_4142 tree_414 tree_4142 0.8192
Cp_4142 tree_4142 0 2.592e-15
Rtr_414_4143 tree_414 tree_4143 0.8192
Cp_4143 tree_4143 0 2.592e-15
Rtr_414_4144 tree_414 tree_4144 0.8192
Cp_4144 tree_4144 0 2.592e-15
Rtr_414_4145 tree_414 tree_4145 0.8192
Cp_4145 tree_4145 0 2.592e-15
Rtr_414_4146 tree_414 tree_4146 0.8192
Cp_4146 tree_4146 0 2.592e-15
Rtr_414_4147 tree_414 tree_4147 0.8192
Cp_4147 tree_4147 0 2.592e-15
Rtr_414_4148 tree_414 tree_4148 0.8192
Cp_4148 tree_4148 0 2.592e-15
Rtr_414_4149 tree_414 tree_4149 0.8192
Cp_4149 tree_4149 0 2.592e-15
Rtr_414_4150 tree_414 tree_4150 0.8192
Cp_4150 tree_4150 0 2.592e-15
Rtr_415_4151 tree_415 tree_4151 0.8192
Cp_4151 tree_4151 0 2.592e-15
Rtr_415_4152 tree_415 tree_4152 0.8192
Cp_4152 tree_4152 0 2.592e-15
Rtr_415_4153 tree_415 tree_4153 0.8192
Cp_4153 tree_4153 0 2.592e-15
Rtr_415_4154 tree_415 tree_4154 0.8192
Cp_4154 tree_4154 0 2.592e-15
Rtr_415_4155 tree_415 tree_4155 0.8192
Cp_4155 tree_4155 0 2.592e-15
Rtr_415_4156 tree_415 tree_4156 0.8192
Cp_4156 tree_4156 0 2.592e-15
Rtr_415_4157 tree_415 tree_4157 0.8192
Cp_4157 tree_4157 0 2.592e-15
Rtr_415_4158 tree_415 tree_4158 0.8192
Cp_4158 tree_4158 0 2.592e-15
Rtr_415_4159 tree_415 tree_4159 0.8192
Cp_4159 tree_4159 0 2.592e-15
Rtr_415_4160 tree_415 tree_4160 0.8192
Cp_4160 tree_4160 0 2.592e-15
Rtr_416_4161 tree_416 tree_4161 0.8192
Cp_4161 tree_4161 0 2.592e-15
Rtr_416_4162 tree_416 tree_4162 0.8192
Cp_4162 tree_4162 0 2.592e-15
Rtr_416_4163 tree_416 tree_4163 0.8192
Cp_4163 tree_4163 0 2.592e-15
Rtr_416_4164 tree_416 tree_4164 0.8192
Cp_4164 tree_4164 0 2.592e-15
Rtr_416_4165 tree_416 tree_4165 0.8192
Cp_4165 tree_4165 0 2.592e-15
Rtr_416_4166 tree_416 tree_4166 0.8192
Cp_4166 tree_4166 0 2.592e-15
Rtr_416_4167 tree_416 tree_4167 0.8192
Cp_4167 tree_4167 0 2.592e-15
Rtr_416_4168 tree_416 tree_4168 0.8192
Cp_4168 tree_4168 0 2.592e-15
Rtr_416_4169 tree_416 tree_4169 0.8192
Cp_4169 tree_4169 0 2.592e-15
Rtr_416_4170 tree_416 tree_4170 0.8192
Cp_4170 tree_4170 0 2.592e-15
Rtr_417_4171 tree_417 tree_4171 0.8192
Cp_4171 tree_4171 0 2.592e-15
Rtr_417_4172 tree_417 tree_4172 0.8192
Cp_4172 tree_4172 0 2.592e-15
Rtr_417_4173 tree_417 tree_4173 0.8192
Cp_4173 tree_4173 0 2.592e-15
Rtr_417_4174 tree_417 tree_4174 0.8192
Cp_4174 tree_4174 0 2.592e-15
Rtr_417_4175 tree_417 tree_4175 0.8192
Cp_4175 tree_4175 0 2.592e-15
Rtr_417_4176 tree_417 tree_4176 0.8192
Cp_4176 tree_4176 0 2.592e-15
Rtr_417_4177 tree_417 tree_4177 0.8192
Cp_4177 tree_4177 0 2.592e-15
Rtr_417_4178 tree_417 tree_4178 0.8192
Cp_4178 tree_4178 0 2.592e-15
Rtr_417_4179 tree_417 tree_4179 0.8192
Cp_4179 tree_4179 0 2.592e-15
Rtr_417_4180 tree_417 tree_4180 0.8192
Cp_4180 tree_4180 0 2.592e-15
Rtr_418_4181 tree_418 tree_4181 0.8192
Cp_4181 tree_4181 0 2.592e-15
Rtr_418_4182 tree_418 tree_4182 0.8192
Cp_4182 tree_4182 0 2.592e-15
Rtr_418_4183 tree_418 tree_4183 0.8192
Cp_4183 tree_4183 0 2.592e-15
Rtr_418_4184 tree_418 tree_4184 0.8192
Cp_4184 tree_4184 0 2.592e-15
Rtr_418_4185 tree_418 tree_4185 0.8192
Cp_4185 tree_4185 0 2.592e-15
Rtr_418_4186 tree_418 tree_4186 0.8192
Cp_4186 tree_4186 0 2.592e-15
Rtr_418_4187 tree_418 tree_4187 0.8192
Cp_4187 tree_4187 0 2.592e-15
Rtr_418_4188 tree_418 tree_4188 0.8192
Cp_4188 tree_4188 0 2.592e-15
Rtr_418_4189 tree_418 tree_4189 0.8192
Cp_4189 tree_4189 0 2.592e-15
Rtr_418_4190 tree_418 tree_4190 0.8192
Cp_4190 tree_4190 0 2.592e-15
Rtr_419_4191 tree_419 tree_4191 0.8192
Cp_4191 tree_4191 0 2.592e-15
Rtr_419_4192 tree_419 tree_4192 0.8192
Cp_4192 tree_4192 0 2.592e-15
Rtr_419_4193 tree_419 tree_4193 0.8192
Cp_4193 tree_4193 0 2.592e-15
Rtr_419_4194 tree_419 tree_4194 0.8192
Cp_4194 tree_4194 0 2.592e-15
Rtr_419_4195 tree_419 tree_4195 0.8192
Cp_4195 tree_4195 0 2.592e-15
Rtr_419_4196 tree_419 tree_4196 0.8192
Cp_4196 tree_4196 0 2.592e-15
Rtr_419_4197 tree_419 tree_4197 0.8192
Cp_4197 tree_4197 0 2.592e-15
Rtr_419_4198 tree_419 tree_4198 0.8192
Cp_4198 tree_4198 0 2.592e-15
Rtr_419_4199 tree_419 tree_4199 0.8192
Cp_4199 tree_4199 0 2.592e-15
Rtr_419_4200 tree_419 tree_4200 0.8192
Cp_4200 tree_4200 0 2.592e-15
Rtr_420_4201 tree_420 tree_4201 0.8192
Cp_4201 tree_4201 0 2.592e-15
Rtr_420_4202 tree_420 tree_4202 0.8192
Cp_4202 tree_4202 0 2.592e-15
Rtr_420_4203 tree_420 tree_4203 0.8192
Cp_4203 tree_4203 0 2.592e-15
Rtr_420_4204 tree_420 tree_4204 0.8192
Cp_4204 tree_4204 0 2.592e-15
Rtr_420_4205 tree_420 tree_4205 0.8192
Cp_4205 tree_4205 0 2.592e-15
Rtr_420_4206 tree_420 tree_4206 0.8192
Cp_4206 tree_4206 0 2.592e-15
Rtr_420_4207 tree_420 tree_4207 0.8192
Cp_4207 tree_4207 0 2.592e-15
Rtr_420_4208 tree_420 tree_4208 0.8192
Cp_4208 tree_4208 0 2.592e-15
Rtr_420_4209 tree_420 tree_4209 0.8192
Cp_4209 tree_4209 0 2.592e-15
Rtr_420_4210 tree_420 tree_4210 0.8192
Cp_4210 tree_4210 0 2.592e-15
Rtr_421_4211 tree_421 tree_4211 0.8192
Cp_4211 tree_4211 0 2.592e-15
Rtr_421_4212 tree_421 tree_4212 0.8192
Cp_4212 tree_4212 0 2.592e-15
Rtr_421_4213 tree_421 tree_4213 0.8192
Cp_4213 tree_4213 0 2.592e-15
Rtr_421_4214 tree_421 tree_4214 0.8192
Cp_4214 tree_4214 0 2.592e-15
Rtr_421_4215 tree_421 tree_4215 0.8192
Cp_4215 tree_4215 0 2.592e-15
Rtr_421_4216 tree_421 tree_4216 0.8192
Cp_4216 tree_4216 0 2.592e-15
Rtr_421_4217 tree_421 tree_4217 0.8192
Cp_4217 tree_4217 0 2.592e-15
Rtr_421_4218 tree_421 tree_4218 0.8192
Cp_4218 tree_4218 0 2.592e-15
Rtr_421_4219 tree_421 tree_4219 0.8192
Cp_4219 tree_4219 0 2.592e-15
Rtr_421_4220 tree_421 tree_4220 0.8192
Cp_4220 tree_4220 0 2.592e-15
Rtr_422_4221 tree_422 tree_4221 0.8192
Cp_4221 tree_4221 0 2.592e-15
Rtr_422_4222 tree_422 tree_4222 0.8192
Cp_4222 tree_4222 0 2.592e-15
Rtr_422_4223 tree_422 tree_4223 0.8192
Cp_4223 tree_4223 0 2.592e-15
Rtr_422_4224 tree_422 tree_4224 0.8192
Cp_4224 tree_4224 0 2.592e-15
Rtr_422_4225 tree_422 tree_4225 0.8192
Cp_4225 tree_4225 0 2.592e-15
Rtr_422_4226 tree_422 tree_4226 0.8192
Cp_4226 tree_4226 0 2.592e-15
Rtr_422_4227 tree_422 tree_4227 0.8192
Cp_4227 tree_4227 0 2.592e-15
Rtr_422_4228 tree_422 tree_4228 0.8192
Cp_4228 tree_4228 0 2.592e-15
Rtr_422_4229 tree_422 tree_4229 0.8192
Cp_4229 tree_4229 0 2.592e-15
Rtr_422_4230 tree_422 tree_4230 0.8192
Cp_4230 tree_4230 0 2.592e-15
Rtr_423_4231 tree_423 tree_4231 0.8192
Cp_4231 tree_4231 0 2.592e-15
Rtr_423_4232 tree_423 tree_4232 0.8192
Cp_4232 tree_4232 0 2.592e-15
Rtr_423_4233 tree_423 tree_4233 0.8192
Cp_4233 tree_4233 0 2.592e-15
Rtr_423_4234 tree_423 tree_4234 0.8192
Cp_4234 tree_4234 0 2.592e-15
Rtr_423_4235 tree_423 tree_4235 0.8192
Cp_4235 tree_4235 0 2.592e-15
Rtr_423_4236 tree_423 tree_4236 0.8192
Cp_4236 tree_4236 0 2.592e-15
Rtr_423_4237 tree_423 tree_4237 0.8192
Cp_4237 tree_4237 0 2.592e-15
Rtr_423_4238 tree_423 tree_4238 0.8192
Cp_4238 tree_4238 0 2.592e-15
Rtr_423_4239 tree_423 tree_4239 0.8192
Cp_4239 tree_4239 0 2.592e-15
Rtr_423_4240 tree_423 tree_4240 0.8192
Cp_4240 tree_4240 0 2.592e-15
Rtr_424_4241 tree_424 tree_4241 0.8192
Cp_4241 tree_4241 0 2.592e-15
Rtr_424_4242 tree_424 tree_4242 0.8192
Cp_4242 tree_4242 0 2.592e-15
Rtr_424_4243 tree_424 tree_4243 0.8192
Cp_4243 tree_4243 0 2.592e-15
Rtr_424_4244 tree_424 tree_4244 0.8192
Cp_4244 tree_4244 0 2.592e-15
Rtr_424_4245 tree_424 tree_4245 0.8192
Cp_4245 tree_4245 0 2.592e-15
Rtr_424_4246 tree_424 tree_4246 0.8192
Cp_4246 tree_4246 0 2.592e-15
Rtr_424_4247 tree_424 tree_4247 0.8192
Cp_4247 tree_4247 0 2.592e-15
Rtr_424_4248 tree_424 tree_4248 0.8192
Cp_4248 tree_4248 0 2.592e-15
Rtr_424_4249 tree_424 tree_4249 0.8192
Cp_4249 tree_4249 0 2.592e-15
Rtr_424_4250 tree_424 tree_4250 0.8192
Cp_4250 tree_4250 0 2.592e-15
Rtr_425_4251 tree_425 tree_4251 0.8192
Cp_4251 tree_4251 0 2.592e-15
Rtr_425_4252 tree_425 tree_4252 0.8192
Cp_4252 tree_4252 0 2.592e-15
Rtr_425_4253 tree_425 tree_4253 0.8192
Cp_4253 tree_4253 0 2.592e-15
Rtr_425_4254 tree_425 tree_4254 0.8192
Cp_4254 tree_4254 0 2.592e-15
Rtr_425_4255 tree_425 tree_4255 0.8192
Cp_4255 tree_4255 0 2.592e-15
Rtr_425_4256 tree_425 tree_4256 0.8192
Cp_4256 tree_4256 0 2.592e-15
Rtr_425_4257 tree_425 tree_4257 0.8192
Cp_4257 tree_4257 0 2.592e-15
Rtr_425_4258 tree_425 tree_4258 0.8192
Cp_4258 tree_4258 0 2.592e-15
Rtr_425_4259 tree_425 tree_4259 0.8192
Cp_4259 tree_4259 0 2.592e-15
Rtr_425_4260 tree_425 tree_4260 0.8192
Cp_4260 tree_4260 0 2.592e-15
Rtr_426_4261 tree_426 tree_4261 0.8192
Cp_4261 tree_4261 0 2.592e-15
Rtr_426_4262 tree_426 tree_4262 0.8192
Cp_4262 tree_4262 0 2.592e-15
Rtr_426_4263 tree_426 tree_4263 0.8192
Cp_4263 tree_4263 0 2.592e-15
Rtr_426_4264 tree_426 tree_4264 0.8192
Cp_4264 tree_4264 0 2.592e-15
Rtr_426_4265 tree_426 tree_4265 0.8192
Cp_4265 tree_4265 0 2.592e-15
Rtr_426_4266 tree_426 tree_4266 0.8192
Cp_4266 tree_4266 0 2.592e-15
Rtr_426_4267 tree_426 tree_4267 0.8192
Cp_4267 tree_4267 0 2.592e-15
Rtr_426_4268 tree_426 tree_4268 0.8192
Cp_4268 tree_4268 0 2.592e-15
Rtr_426_4269 tree_426 tree_4269 0.8192
Cp_4269 tree_4269 0 2.592e-15
Rtr_426_4270 tree_426 tree_4270 0.8192
Cp_4270 tree_4270 0 2.592e-15
Rtr_427_4271 tree_427 tree_4271 0.8192
Cp_4271 tree_4271 0 2.592e-15
Rtr_427_4272 tree_427 tree_4272 0.8192
Cp_4272 tree_4272 0 2.592e-15
Rtr_427_4273 tree_427 tree_4273 0.8192
Cp_4273 tree_4273 0 2.592e-15
Rtr_427_4274 tree_427 tree_4274 0.8192
Cp_4274 tree_4274 0 2.592e-15
Rtr_427_4275 tree_427 tree_4275 0.8192
Cp_4275 tree_4275 0 2.592e-15
Rtr_427_4276 tree_427 tree_4276 0.8192
Cp_4276 tree_4276 0 2.592e-15
Rtr_427_4277 tree_427 tree_4277 0.8192
Cp_4277 tree_4277 0 2.592e-15
Rtr_427_4278 tree_427 tree_4278 0.8192
Cp_4278 tree_4278 0 2.592e-15
Rtr_427_4279 tree_427 tree_4279 0.8192
Cp_4279 tree_4279 0 2.592e-15
Rtr_427_4280 tree_427 tree_4280 0.8192
Cp_4280 tree_4280 0 2.592e-15
Rtr_428_4281 tree_428 tree_4281 0.8192
Cp_4281 tree_4281 0 2.592e-15
Rtr_428_4282 tree_428 tree_4282 0.8192
Cp_4282 tree_4282 0 2.592e-15
Rtr_428_4283 tree_428 tree_4283 0.8192
Cp_4283 tree_4283 0 2.592e-15
Rtr_428_4284 tree_428 tree_4284 0.8192
Cp_4284 tree_4284 0 2.592e-15
Rtr_428_4285 tree_428 tree_4285 0.8192
Cp_4285 tree_4285 0 2.592e-15
Rtr_428_4286 tree_428 tree_4286 0.8192
Cp_4286 tree_4286 0 2.592e-15
Rtr_428_4287 tree_428 tree_4287 0.8192
Cp_4287 tree_4287 0 2.592e-15
Rtr_428_4288 tree_428 tree_4288 0.8192
Cp_4288 tree_4288 0 2.592e-15
Rtr_428_4289 tree_428 tree_4289 0.8192
Cp_4289 tree_4289 0 2.592e-15
Rtr_428_4290 tree_428 tree_4290 0.8192
Cp_4290 tree_4290 0 2.592e-15
Rtr_429_4291 tree_429 tree_4291 0.8192
Cp_4291 tree_4291 0 2.592e-15
Rtr_429_4292 tree_429 tree_4292 0.8192
Cp_4292 tree_4292 0 2.592e-15
Rtr_429_4293 tree_429 tree_4293 0.8192
Cp_4293 tree_4293 0 2.592e-15
Rtr_429_4294 tree_429 tree_4294 0.8192
Cp_4294 tree_4294 0 2.592e-15
Rtr_429_4295 tree_429 tree_4295 0.8192
Cp_4295 tree_4295 0 2.592e-15
Rtr_429_4296 tree_429 tree_4296 0.8192
Cp_4296 tree_4296 0 2.592e-15
Rtr_429_4297 tree_429 tree_4297 0.8192
Cp_4297 tree_4297 0 2.592e-15
Rtr_429_4298 tree_429 tree_4298 0.8192
Cp_4298 tree_4298 0 2.592e-15
Rtr_429_4299 tree_429 tree_4299 0.8192
Cp_4299 tree_4299 0 2.592e-15
Rtr_429_4300 tree_429 tree_4300 0.8192
Cp_4300 tree_4300 0 2.592e-15
Rtr_430_4301 tree_430 tree_4301 0.8192
Cp_4301 tree_4301 0 2.592e-15
Rtr_430_4302 tree_430 tree_4302 0.8192
Cp_4302 tree_4302 0 2.592e-15
Rtr_430_4303 tree_430 tree_4303 0.8192
Cp_4303 tree_4303 0 2.592e-15
Rtr_430_4304 tree_430 tree_4304 0.8192
Cp_4304 tree_4304 0 2.592e-15
Rtr_430_4305 tree_430 tree_4305 0.8192
Cp_4305 tree_4305 0 2.592e-15
Rtr_430_4306 tree_430 tree_4306 0.8192
Cp_4306 tree_4306 0 2.592e-15
Rtr_430_4307 tree_430 tree_4307 0.8192
Cp_4307 tree_4307 0 2.592e-15
Rtr_430_4308 tree_430 tree_4308 0.8192
Cp_4308 tree_4308 0 2.592e-15
Rtr_430_4309 tree_430 tree_4309 0.8192
Cp_4309 tree_4309 0 2.592e-15
Rtr_430_4310 tree_430 tree_4310 0.8192
Cp_4310 tree_4310 0 2.592e-15
Rtr_431_4311 tree_431 tree_4311 0.8192
Cp_4311 tree_4311 0 2.592e-15
Rtr_431_4312 tree_431 tree_4312 0.8192
Cp_4312 tree_4312 0 2.592e-15
Rtr_431_4313 tree_431 tree_4313 0.8192
Cp_4313 tree_4313 0 2.592e-15
Rtr_431_4314 tree_431 tree_4314 0.8192
Cp_4314 tree_4314 0 2.592e-15
Rtr_431_4315 tree_431 tree_4315 0.8192
Cp_4315 tree_4315 0 2.592e-15
Rtr_431_4316 tree_431 tree_4316 0.8192
Cp_4316 tree_4316 0 2.592e-15
Rtr_431_4317 tree_431 tree_4317 0.8192
Cp_4317 tree_4317 0 2.592e-15
Rtr_431_4318 tree_431 tree_4318 0.8192
Cp_4318 tree_4318 0 2.592e-15
Rtr_431_4319 tree_431 tree_4319 0.8192
Cp_4319 tree_4319 0 2.592e-15
Rtr_431_4320 tree_431 tree_4320 0.8192
Cp_4320 tree_4320 0 2.592e-15
Rtr_432_4321 tree_432 tree_4321 0.8192
Cp_4321 tree_4321 0 2.592e-15
Rtr_432_4322 tree_432 tree_4322 0.8192
Cp_4322 tree_4322 0 2.592e-15
Rtr_432_4323 tree_432 tree_4323 0.8192
Cp_4323 tree_4323 0 2.592e-15
Rtr_432_4324 tree_432 tree_4324 0.8192
Cp_4324 tree_4324 0 2.592e-15
Rtr_432_4325 tree_432 tree_4325 0.8192
Cp_4325 tree_4325 0 2.592e-15
Rtr_432_4326 tree_432 tree_4326 0.8192
Cp_4326 tree_4326 0 2.592e-15
Rtr_432_4327 tree_432 tree_4327 0.8192
Cp_4327 tree_4327 0 2.592e-15
Rtr_432_4328 tree_432 tree_4328 0.8192
Cp_4328 tree_4328 0 2.592e-15
Rtr_432_4329 tree_432 tree_4329 0.8192
Cp_4329 tree_4329 0 2.592e-15
Rtr_432_4330 tree_432 tree_4330 0.8192
Cp_4330 tree_4330 0 2.592e-15
Rtr_433_4331 tree_433 tree_4331 0.8192
Cp_4331 tree_4331 0 2.592e-15
Rtr_433_4332 tree_433 tree_4332 0.8192
Cp_4332 tree_4332 0 2.592e-15
Rtr_433_4333 tree_433 tree_4333 0.8192
Cp_4333 tree_4333 0 2.592e-15
Rtr_433_4334 tree_433 tree_4334 0.8192
Cp_4334 tree_4334 0 2.592e-15
Rtr_433_4335 tree_433 tree_4335 0.8192
Cp_4335 tree_4335 0 2.592e-15
Rtr_433_4336 tree_433 tree_4336 0.8192
Cp_4336 tree_4336 0 2.592e-15
Rtr_433_4337 tree_433 tree_4337 0.8192
Cp_4337 tree_4337 0 2.592e-15
Rtr_433_4338 tree_433 tree_4338 0.8192
Cp_4338 tree_4338 0 2.592e-15
Rtr_433_4339 tree_433 tree_4339 0.8192
Cp_4339 tree_4339 0 2.592e-15
Rtr_433_4340 tree_433 tree_4340 0.8192
Cp_4340 tree_4340 0 2.592e-15
Rtr_434_4341 tree_434 tree_4341 0.8192
Cp_4341 tree_4341 0 2.592e-15
Rtr_434_4342 tree_434 tree_4342 0.8192
Cp_4342 tree_4342 0 2.592e-15
Rtr_434_4343 tree_434 tree_4343 0.8192
Cp_4343 tree_4343 0 2.592e-15
Rtr_434_4344 tree_434 tree_4344 0.8192
Cp_4344 tree_4344 0 2.592e-15
Rtr_434_4345 tree_434 tree_4345 0.8192
Cp_4345 tree_4345 0 2.592e-15
Rtr_434_4346 tree_434 tree_4346 0.8192
Cp_4346 tree_4346 0 2.592e-15
Rtr_434_4347 tree_434 tree_4347 0.8192
Cp_4347 tree_4347 0 2.592e-15
Rtr_434_4348 tree_434 tree_4348 0.8192
Cp_4348 tree_4348 0 2.592e-15
Rtr_434_4349 tree_434 tree_4349 0.8192
Cp_4349 tree_4349 0 2.592e-15
Rtr_434_4350 tree_434 tree_4350 0.8192
Cp_4350 tree_4350 0 2.592e-15
Rtr_435_4351 tree_435 tree_4351 0.8192
Cp_4351 tree_4351 0 2.592e-15
Rtr_435_4352 tree_435 tree_4352 0.8192
Cp_4352 tree_4352 0 2.592e-15
Rtr_435_4353 tree_435 tree_4353 0.8192
Cp_4353 tree_4353 0 2.592e-15
Rtr_435_4354 tree_435 tree_4354 0.8192
Cp_4354 tree_4354 0 2.592e-15
Rtr_435_4355 tree_435 tree_4355 0.8192
Cp_4355 tree_4355 0 2.592e-15
Rtr_435_4356 tree_435 tree_4356 0.8192
Cp_4356 tree_4356 0 2.592e-15
Rtr_435_4357 tree_435 tree_4357 0.8192
Cp_4357 tree_4357 0 2.592e-15
Rtr_435_4358 tree_435 tree_4358 0.8192
Cp_4358 tree_4358 0 2.592e-15
Rtr_435_4359 tree_435 tree_4359 0.8192
Cp_4359 tree_4359 0 2.592e-15
Rtr_435_4360 tree_435 tree_4360 0.8192
Cp_4360 tree_4360 0 2.592e-15
Rtr_436_4361 tree_436 tree_4361 0.8192
Cp_4361 tree_4361 0 2.592e-15
Rtr_436_4362 tree_436 tree_4362 0.8192
Cp_4362 tree_4362 0 2.592e-15
Rtr_436_4363 tree_436 tree_4363 0.8192
Cp_4363 tree_4363 0 2.592e-15
Rtr_436_4364 tree_436 tree_4364 0.8192
Cp_4364 tree_4364 0 2.592e-15
Rtr_436_4365 tree_436 tree_4365 0.8192
Cp_4365 tree_4365 0 2.592e-15
Rtr_436_4366 tree_436 tree_4366 0.8192
Cp_4366 tree_4366 0 2.592e-15
Rtr_436_4367 tree_436 tree_4367 0.8192
Cp_4367 tree_4367 0 2.592e-15
Rtr_436_4368 tree_436 tree_4368 0.8192
Cp_4368 tree_4368 0 2.592e-15
Rtr_436_4369 tree_436 tree_4369 0.8192
Cp_4369 tree_4369 0 2.592e-15
Rtr_436_4370 tree_436 tree_4370 0.8192
Cp_4370 tree_4370 0 2.592e-15
Rtr_437_4371 tree_437 tree_4371 0.8192
Cp_4371 tree_4371 0 2.592e-15
Rtr_437_4372 tree_437 tree_4372 0.8192
Cp_4372 tree_4372 0 2.592e-15
Rtr_437_4373 tree_437 tree_4373 0.8192
Cp_4373 tree_4373 0 2.592e-15
Rtr_437_4374 tree_437 tree_4374 0.8192
Cp_4374 tree_4374 0 2.592e-15
Rtr_437_4375 tree_437 tree_4375 0.8192
Cp_4375 tree_4375 0 2.592e-15
Rtr_437_4376 tree_437 tree_4376 0.8192
Cp_4376 tree_4376 0 2.592e-15
Rtr_437_4377 tree_437 tree_4377 0.8192
Cp_4377 tree_4377 0 2.592e-15
Rtr_437_4378 tree_437 tree_4378 0.8192
Cp_4378 tree_4378 0 2.592e-15
Rtr_437_4379 tree_437 tree_4379 0.8192
Cp_4379 tree_4379 0 2.592e-15
Rtr_437_4380 tree_437 tree_4380 0.8192
Cp_4380 tree_4380 0 2.592e-15
Rtr_438_4381 tree_438 tree_4381 0.8192
Cp_4381 tree_4381 0 2.592e-15
Rtr_438_4382 tree_438 tree_4382 0.8192
Cp_4382 tree_4382 0 2.592e-15
Rtr_438_4383 tree_438 tree_4383 0.8192
Cp_4383 tree_4383 0 2.592e-15
Rtr_438_4384 tree_438 tree_4384 0.8192
Cp_4384 tree_4384 0 2.592e-15
Rtr_438_4385 tree_438 tree_4385 0.8192
Cp_4385 tree_4385 0 2.592e-15
Rtr_438_4386 tree_438 tree_4386 0.8192
Cp_4386 tree_4386 0 2.592e-15
Rtr_438_4387 tree_438 tree_4387 0.8192
Cp_4387 tree_4387 0 2.592e-15
Rtr_438_4388 tree_438 tree_4388 0.8192
Cp_4388 tree_4388 0 2.592e-15
Rtr_438_4389 tree_438 tree_4389 0.8192
Cp_4389 tree_4389 0 2.592e-15
Rtr_438_4390 tree_438 tree_4390 0.8192
Cp_4390 tree_4390 0 2.592e-15
Rtr_439_4391 tree_439 tree_4391 0.8192
Cp_4391 tree_4391 0 2.592e-15
Rtr_439_4392 tree_439 tree_4392 0.8192
Cp_4392 tree_4392 0 2.592e-15
Rtr_439_4393 tree_439 tree_4393 0.8192
Cp_4393 tree_4393 0 2.592e-15
Rtr_439_4394 tree_439 tree_4394 0.8192
Cp_4394 tree_4394 0 2.592e-15
Rtr_439_4395 tree_439 tree_4395 0.8192
Cp_4395 tree_4395 0 2.592e-15
Rtr_439_4396 tree_439 tree_4396 0.8192
Cp_4396 tree_4396 0 2.592e-15
Rtr_439_4397 tree_439 tree_4397 0.8192
Cp_4397 tree_4397 0 2.592e-15
Rtr_439_4398 tree_439 tree_4398 0.8192
Cp_4398 tree_4398 0 2.592e-15
Rtr_439_4399 tree_439 tree_4399 0.8192
Cp_4399 tree_4399 0 2.592e-15
Rtr_439_4400 tree_439 tree_4400 0.8192
Cp_4400 tree_4400 0 2.592e-15
Rtr_440_4401 tree_440 tree_4401 0.8192
Cp_4401 tree_4401 0 2.592e-15
Rtr_440_4402 tree_440 tree_4402 0.8192
Cp_4402 tree_4402 0 2.592e-15
Rtr_440_4403 tree_440 tree_4403 0.8192
Cp_4403 tree_4403 0 2.592e-15
Rtr_440_4404 tree_440 tree_4404 0.8192
Cp_4404 tree_4404 0 2.592e-15
Rtr_440_4405 tree_440 tree_4405 0.8192
Cp_4405 tree_4405 0 2.592e-15
Rtr_440_4406 tree_440 tree_4406 0.8192
Cp_4406 tree_4406 0 2.592e-15
Rtr_440_4407 tree_440 tree_4407 0.8192
Cp_4407 tree_4407 0 2.592e-15
Rtr_440_4408 tree_440 tree_4408 0.8192
Cp_4408 tree_4408 0 2.592e-15
Rtr_440_4409 tree_440 tree_4409 0.8192
Cp_4409 tree_4409 0 2.592e-15
Rtr_440_4410 tree_440 tree_4410 0.8192
Cp_4410 tree_4410 0 2.592e-15
Rtr_441_4411 tree_441 tree_4411 0.8192
Cp_4411 tree_4411 0 2.592e-15
Rtr_441_4412 tree_441 tree_4412 0.8192
Cp_4412 tree_4412 0 2.592e-15
Rtr_441_4413 tree_441 tree_4413 0.8192
Cp_4413 tree_4413 0 2.592e-15
Rtr_441_4414 tree_441 tree_4414 0.8192
Cp_4414 tree_4414 0 2.592e-15
Rtr_441_4415 tree_441 tree_4415 0.8192
Cp_4415 tree_4415 0 2.592e-15
Rtr_441_4416 tree_441 tree_4416 0.8192
Cp_4416 tree_4416 0 2.592e-15
Rtr_441_4417 tree_441 tree_4417 0.8192
Cp_4417 tree_4417 0 2.592e-15
Rtr_441_4418 tree_441 tree_4418 0.8192
Cp_4418 tree_4418 0 2.592e-15
Rtr_441_4419 tree_441 tree_4419 0.8192
Cp_4419 tree_4419 0 2.592e-15
Rtr_441_4420 tree_441 tree_4420 0.8192
Cp_4420 tree_4420 0 2.592e-15
Rtr_442_4421 tree_442 tree_4421 0.8192
Cp_4421 tree_4421 0 2.592e-15
Rtr_442_4422 tree_442 tree_4422 0.8192
Cp_4422 tree_4422 0 2.592e-15
Rtr_442_4423 tree_442 tree_4423 0.8192
Cp_4423 tree_4423 0 2.592e-15
Rtr_442_4424 tree_442 tree_4424 0.8192
Cp_4424 tree_4424 0 2.592e-15
Rtr_442_4425 tree_442 tree_4425 0.8192
Cp_4425 tree_4425 0 2.592e-15
Rtr_442_4426 tree_442 tree_4426 0.8192
Cp_4426 tree_4426 0 2.592e-15
Rtr_442_4427 tree_442 tree_4427 0.8192
Cp_4427 tree_4427 0 2.592e-15
Rtr_442_4428 tree_442 tree_4428 0.8192
Cp_4428 tree_4428 0 2.592e-15
Rtr_442_4429 tree_442 tree_4429 0.8192
Cp_4429 tree_4429 0 2.592e-15
Rtr_442_4430 tree_442 tree_4430 0.8192
Cp_4430 tree_4430 0 2.592e-15
Rtr_443_4431 tree_443 tree_4431 0.8192
Cp_4431 tree_4431 0 2.592e-15
Rtr_443_4432 tree_443 tree_4432 0.8192
Cp_4432 tree_4432 0 2.592e-15
Rtr_443_4433 tree_443 tree_4433 0.8192
Cp_4433 tree_4433 0 2.592e-15
Rtr_443_4434 tree_443 tree_4434 0.8192
Cp_4434 tree_4434 0 2.592e-15
Rtr_443_4435 tree_443 tree_4435 0.8192
Cp_4435 tree_4435 0 2.592e-15
Rtr_443_4436 tree_443 tree_4436 0.8192
Cp_4436 tree_4436 0 2.592e-15
Rtr_443_4437 tree_443 tree_4437 0.8192
Cp_4437 tree_4437 0 2.592e-15
Rtr_443_4438 tree_443 tree_4438 0.8192
Cp_4438 tree_4438 0 2.592e-15
Rtr_443_4439 tree_443 tree_4439 0.8192
Cp_4439 tree_4439 0 2.592e-15
Rtr_443_4440 tree_443 tree_4440 0.8192
Cp_4440 tree_4440 0 2.592e-15
Rtr_444_4441 tree_444 tree_4441 0.8192
Cp_4441 tree_4441 0 2.592e-15
Rtr_444_4442 tree_444 tree_4442 0.8192
Cp_4442 tree_4442 0 2.592e-15
Rtr_444_4443 tree_444 tree_4443 0.8192
Cp_4443 tree_4443 0 2.592e-15
Rtr_444_4444 tree_444 tree_4444 0.8192
Cp_4444 tree_4444 0 2.592e-15
Rtr_444_4445 tree_444 tree_4445 0.8192
Cp_4445 tree_4445 0 2.592e-15
Rtr_444_4446 tree_444 tree_4446 0.8192
Cp_4446 tree_4446 0 2.592e-15
Rtr_444_4447 tree_444 tree_4447 0.8192
Cp_4447 tree_4447 0 2.592e-15
Rtr_444_4448 tree_444 tree_4448 0.8192
Cp_4448 tree_4448 0 2.592e-15
Rtr_444_4449 tree_444 tree_4449 0.8192
Cp_4449 tree_4449 0 2.592e-15
Rtr_444_4450 tree_444 tree_4450 0.8192
Cp_4450 tree_4450 0 2.592e-15
Rtr_445_4451 tree_445 tree_4451 0.8192
Cp_4451 tree_4451 0 2.592e-15
Rtr_445_4452 tree_445 tree_4452 0.8192
Cp_4452 tree_4452 0 2.592e-15
Rtr_445_4453 tree_445 tree_4453 0.8192
Cp_4453 tree_4453 0 2.592e-15
Rtr_445_4454 tree_445 tree_4454 0.8192
Cp_4454 tree_4454 0 2.592e-15
Rtr_445_4455 tree_445 tree_4455 0.8192
Cp_4455 tree_4455 0 2.592e-15
Rtr_445_4456 tree_445 tree_4456 0.8192
Cp_4456 tree_4456 0 2.592e-15
Rtr_445_4457 tree_445 tree_4457 0.8192
Cp_4457 tree_4457 0 2.592e-15
Rtr_445_4458 tree_445 tree_4458 0.8192
Cp_4458 tree_4458 0 2.592e-15
Rtr_445_4459 tree_445 tree_4459 0.8192
Cp_4459 tree_4459 0 2.592e-15
Rtr_445_4460 tree_445 tree_4460 0.8192
Cp_4460 tree_4460 0 2.592e-15
Rtr_446_4461 tree_446 tree_4461 0.8192
Cp_4461 tree_4461 0 2.592e-15
Rtr_446_4462 tree_446 tree_4462 0.8192
Cp_4462 tree_4462 0 2.592e-15
Rtr_446_4463 tree_446 tree_4463 0.8192
Cp_4463 tree_4463 0 2.592e-15
Rtr_446_4464 tree_446 tree_4464 0.8192
Cp_4464 tree_4464 0 2.592e-15
Rtr_446_4465 tree_446 tree_4465 0.8192
Cp_4465 tree_4465 0 2.592e-15
Rtr_446_4466 tree_446 tree_4466 0.8192
Cp_4466 tree_4466 0 2.592e-15
Rtr_446_4467 tree_446 tree_4467 0.8192
Cp_4467 tree_4467 0 2.592e-15
Rtr_446_4468 tree_446 tree_4468 0.8192
Cp_4468 tree_4468 0 2.592e-15
Rtr_446_4469 tree_446 tree_4469 0.8192
Cp_4469 tree_4469 0 2.592e-15
Rtr_446_4470 tree_446 tree_4470 0.8192
Cp_4470 tree_4470 0 2.592e-15
Rtr_447_4471 tree_447 tree_4471 0.8192
Cp_4471 tree_4471 0 2.592e-15
Rtr_447_4472 tree_447 tree_4472 0.8192
Cp_4472 tree_4472 0 2.592e-15
Rtr_447_4473 tree_447 tree_4473 0.8192
Cp_4473 tree_4473 0 2.592e-15
Rtr_447_4474 tree_447 tree_4474 0.8192
Cp_4474 tree_4474 0 2.592e-15
Rtr_447_4475 tree_447 tree_4475 0.8192
Cp_4475 tree_4475 0 2.592e-15
Rtr_447_4476 tree_447 tree_4476 0.8192
Cp_4476 tree_4476 0 2.592e-15
Rtr_447_4477 tree_447 tree_4477 0.8192
Cp_4477 tree_4477 0 2.592e-15
Rtr_447_4478 tree_447 tree_4478 0.8192
Cp_4478 tree_4478 0 2.592e-15
Rtr_447_4479 tree_447 tree_4479 0.8192
Cp_4479 tree_4479 0 2.592e-15
Rtr_447_4480 tree_447 tree_4480 0.8192
Cp_4480 tree_4480 0 2.592e-15
Rtr_448_4481 tree_448 tree_4481 0.8192
Cp_4481 tree_4481 0 2.592e-15
Rtr_448_4482 tree_448 tree_4482 0.8192
Cp_4482 tree_4482 0 2.592e-15
Rtr_448_4483 tree_448 tree_4483 0.8192
Cp_4483 tree_4483 0 2.592e-15
Rtr_448_4484 tree_448 tree_4484 0.8192
Cp_4484 tree_4484 0 2.592e-15
Rtr_448_4485 tree_448 tree_4485 0.8192
Cp_4485 tree_4485 0 2.592e-15
Rtr_448_4486 tree_448 tree_4486 0.8192
Cp_4486 tree_4486 0 2.592e-15
Rtr_448_4487 tree_448 tree_4487 0.8192
Cp_4487 tree_4487 0 2.592e-15
Rtr_448_4488 tree_448 tree_4488 0.8192
Cp_4488 tree_4488 0 2.592e-15
Rtr_448_4489 tree_448 tree_4489 0.8192
Cp_4489 tree_4489 0 2.592e-15
Rtr_448_4490 tree_448 tree_4490 0.8192
Cp_4490 tree_4490 0 2.592e-15
Rtr_449_4491 tree_449 tree_4491 0.8192
Cp_4491 tree_4491 0 2.592e-15
Rtr_449_4492 tree_449 tree_4492 0.8192
Cp_4492 tree_4492 0 2.592e-15
Rtr_449_4493 tree_449 tree_4493 0.8192
Cp_4493 tree_4493 0 2.592e-15
Rtr_449_4494 tree_449 tree_4494 0.8192
Cp_4494 tree_4494 0 2.592e-15
Rtr_449_4495 tree_449 tree_4495 0.8192
Cp_4495 tree_4495 0 2.592e-15
Rtr_449_4496 tree_449 tree_4496 0.8192
Cp_4496 tree_4496 0 2.592e-15
Rtr_449_4497 tree_449 tree_4497 0.8192
Cp_4497 tree_4497 0 2.592e-15
Rtr_449_4498 tree_449 tree_4498 0.8192
Cp_4498 tree_4498 0 2.592e-15
Rtr_449_4499 tree_449 tree_4499 0.8192
Cp_4499 tree_4499 0 2.592e-15
Rtr_449_4500 tree_449 tree_4500 0.8192
Cp_4500 tree_4500 0 2.592e-15
Rtr_450_4501 tree_450 tree_4501 0.8192
Cp_4501 tree_4501 0 2.592e-15
Rtr_450_4502 tree_450 tree_4502 0.8192
Cp_4502 tree_4502 0 2.592e-15
Rtr_450_4503 tree_450 tree_4503 0.8192
Cp_4503 tree_4503 0 2.592e-15
Rtr_450_4504 tree_450 tree_4504 0.8192
Cp_4504 tree_4504 0 2.592e-15
Rtr_450_4505 tree_450 tree_4505 0.8192
Cp_4505 tree_4505 0 2.592e-15
Rtr_450_4506 tree_450 tree_4506 0.8192
Cp_4506 tree_4506 0 2.592e-15
Rtr_450_4507 tree_450 tree_4507 0.8192
Cp_4507 tree_4507 0 2.592e-15
Rtr_450_4508 tree_450 tree_4508 0.8192
Cp_4508 tree_4508 0 2.592e-15
Rtr_450_4509 tree_450 tree_4509 0.8192
Cp_4509 tree_4509 0 2.592e-15
Rtr_450_4510 tree_450 tree_4510 0.8192
Cp_4510 tree_4510 0 2.592e-15
Rtr_451_4511 tree_451 tree_4511 0.8192
Cp_4511 tree_4511 0 2.592e-15
Rtr_451_4512 tree_451 tree_4512 0.8192
Cp_4512 tree_4512 0 2.592e-15
Rtr_451_4513 tree_451 tree_4513 0.8192
Cp_4513 tree_4513 0 2.592e-15
Rtr_451_4514 tree_451 tree_4514 0.8192
Cp_4514 tree_4514 0 2.592e-15
Rtr_451_4515 tree_451 tree_4515 0.8192
Cp_4515 tree_4515 0 2.592e-15
Rtr_451_4516 tree_451 tree_4516 0.8192
Cp_4516 tree_4516 0 2.592e-15
Rtr_451_4517 tree_451 tree_4517 0.8192
Cp_4517 tree_4517 0 2.592e-15
Rtr_451_4518 tree_451 tree_4518 0.8192
Cp_4518 tree_4518 0 2.592e-15
Rtr_451_4519 tree_451 tree_4519 0.8192
Cp_4519 tree_4519 0 2.592e-15
Rtr_451_4520 tree_451 tree_4520 0.8192
Cp_4520 tree_4520 0 2.592e-15
Rtr_452_4521 tree_452 tree_4521 0.8192
Cp_4521 tree_4521 0 2.592e-15
Rtr_452_4522 tree_452 tree_4522 0.8192
Cp_4522 tree_4522 0 2.592e-15
Rtr_452_4523 tree_452 tree_4523 0.8192
Cp_4523 tree_4523 0 2.592e-15
Rtr_452_4524 tree_452 tree_4524 0.8192
Cp_4524 tree_4524 0 2.592e-15
Rtr_452_4525 tree_452 tree_4525 0.8192
Cp_4525 tree_4525 0 2.592e-15
Rtr_452_4526 tree_452 tree_4526 0.8192
Cp_4526 tree_4526 0 2.592e-15
Rtr_452_4527 tree_452 tree_4527 0.8192
Cp_4527 tree_4527 0 2.592e-15
Rtr_452_4528 tree_452 tree_4528 0.8192
Cp_4528 tree_4528 0 2.592e-15
Rtr_452_4529 tree_452 tree_4529 0.8192
Cp_4529 tree_4529 0 2.592e-15
Rtr_452_4530 tree_452 tree_4530 0.8192
Cp_4530 tree_4530 0 2.592e-15
Rtr_453_4531 tree_453 tree_4531 0.8192
Cp_4531 tree_4531 0 2.592e-15
Rtr_453_4532 tree_453 tree_4532 0.8192
Cp_4532 tree_4532 0 2.592e-15
Rtr_453_4533 tree_453 tree_4533 0.8192
Cp_4533 tree_4533 0 2.592e-15
Rtr_453_4534 tree_453 tree_4534 0.8192
Cp_4534 tree_4534 0 2.592e-15
Rtr_453_4535 tree_453 tree_4535 0.8192
Cp_4535 tree_4535 0 2.592e-15
Rtr_453_4536 tree_453 tree_4536 0.8192
Cp_4536 tree_4536 0 2.592e-15
Rtr_453_4537 tree_453 tree_4537 0.8192
Cp_4537 tree_4537 0 2.592e-15
Rtr_453_4538 tree_453 tree_4538 0.8192
Cp_4538 tree_4538 0 2.592e-15
Rtr_453_4539 tree_453 tree_4539 0.8192
Cp_4539 tree_4539 0 2.592e-15
Rtr_453_4540 tree_453 tree_4540 0.8192
Cp_4540 tree_4540 0 2.592e-15
Rtr_454_4541 tree_454 tree_4541 0.8192
Cp_4541 tree_4541 0 2.592e-15
Rtr_454_4542 tree_454 tree_4542 0.8192
Cp_4542 tree_4542 0 2.592e-15
Rtr_454_4543 tree_454 tree_4543 0.8192
Cp_4543 tree_4543 0 2.592e-15
Rtr_454_4544 tree_454 tree_4544 0.8192
Cp_4544 tree_4544 0 2.592e-15
Rtr_454_4545 tree_454 tree_4545 0.8192
Cp_4545 tree_4545 0 2.592e-15
Rtr_454_4546 tree_454 tree_4546 0.8192
Cp_4546 tree_4546 0 2.592e-15
Rtr_454_4547 tree_454 tree_4547 0.8192
Cp_4547 tree_4547 0 2.592e-15
Rtr_454_4548 tree_454 tree_4548 0.8192
Cp_4548 tree_4548 0 2.592e-15
Rtr_454_4549 tree_454 tree_4549 0.8192
Cp_4549 tree_4549 0 2.592e-15
Rtr_454_4550 tree_454 tree_4550 0.8192
Cp_4550 tree_4550 0 2.592e-15
Rtr_455_4551 tree_455 tree_4551 0.8192
Cp_4551 tree_4551 0 2.592e-15
Rtr_455_4552 tree_455 tree_4552 0.8192
Cp_4552 tree_4552 0 2.592e-15
Rtr_455_4553 tree_455 tree_4553 0.8192
Cp_4553 tree_4553 0 2.592e-15
Rtr_455_4554 tree_455 tree_4554 0.8192
Cp_4554 tree_4554 0 2.592e-15
Rtr_455_4555 tree_455 tree_4555 0.8192
Cp_4555 tree_4555 0 2.592e-15
Rtr_455_4556 tree_455 tree_4556 0.8192
Cp_4556 tree_4556 0 2.592e-15
Rtr_455_4557 tree_455 tree_4557 0.8192
Cp_4557 tree_4557 0 2.592e-15
Rtr_455_4558 tree_455 tree_4558 0.8192
Cp_4558 tree_4558 0 2.592e-15
Rtr_455_4559 tree_455 tree_4559 0.8192
Cp_4559 tree_4559 0 2.592e-15
Rtr_455_4560 tree_455 tree_4560 0.8192
Cp_4560 tree_4560 0 2.592e-15
Rtr_456_4561 tree_456 tree_4561 0.8192
Cp_4561 tree_4561 0 2.592e-15
Rtr_456_4562 tree_456 tree_4562 0.8192
Cp_4562 tree_4562 0 2.592e-15
Rtr_456_4563 tree_456 tree_4563 0.8192
Cp_4563 tree_4563 0 2.592e-15
Rtr_456_4564 tree_456 tree_4564 0.8192
Cp_4564 tree_4564 0 2.592e-15
Rtr_456_4565 tree_456 tree_4565 0.8192
Cp_4565 tree_4565 0 2.592e-15
Rtr_456_4566 tree_456 tree_4566 0.8192
Cp_4566 tree_4566 0 2.592e-15
Rtr_456_4567 tree_456 tree_4567 0.8192
Cp_4567 tree_4567 0 2.592e-15
Rtr_456_4568 tree_456 tree_4568 0.8192
Cp_4568 tree_4568 0 2.592e-15
Rtr_456_4569 tree_456 tree_4569 0.8192
Cp_4569 tree_4569 0 2.592e-15
Rtr_456_4570 tree_456 tree_4570 0.8192
Cp_4570 tree_4570 0 2.592e-15
Rtr_457_4571 tree_457 tree_4571 0.8192
Cp_4571 tree_4571 0 2.592e-15
Rtr_457_4572 tree_457 tree_4572 0.8192
Cp_4572 tree_4572 0 2.592e-15
Rtr_457_4573 tree_457 tree_4573 0.8192
Cp_4573 tree_4573 0 2.592e-15
Rtr_457_4574 tree_457 tree_4574 0.8192
Cp_4574 tree_4574 0 2.592e-15
Rtr_457_4575 tree_457 tree_4575 0.8192
Cp_4575 tree_4575 0 2.592e-15
Rtr_457_4576 tree_457 tree_4576 0.8192
Cp_4576 tree_4576 0 2.592e-15
Rtr_457_4577 tree_457 tree_4577 0.8192
Cp_4577 tree_4577 0 2.592e-15
Rtr_457_4578 tree_457 tree_4578 0.8192
Cp_4578 tree_4578 0 2.592e-15
Rtr_457_4579 tree_457 tree_4579 0.8192
Cp_4579 tree_4579 0 2.592e-15
Rtr_457_4580 tree_457 tree_4580 0.8192
Cp_4580 tree_4580 0 2.592e-15
Rtr_458_4581 tree_458 tree_4581 0.8192
Cp_4581 tree_4581 0 2.592e-15
Rtr_458_4582 tree_458 tree_4582 0.8192
Cp_4582 tree_4582 0 2.592e-15
Rtr_458_4583 tree_458 tree_4583 0.8192
Cp_4583 tree_4583 0 2.592e-15
Rtr_458_4584 tree_458 tree_4584 0.8192
Cp_4584 tree_4584 0 2.592e-15
Rtr_458_4585 tree_458 tree_4585 0.8192
Cp_4585 tree_4585 0 2.592e-15
Rtr_458_4586 tree_458 tree_4586 0.8192
Cp_4586 tree_4586 0 2.592e-15
Rtr_458_4587 tree_458 tree_4587 0.8192
Cp_4587 tree_4587 0 2.592e-15
Rtr_458_4588 tree_458 tree_4588 0.8192
Cp_4588 tree_4588 0 2.592e-15
Rtr_458_4589 tree_458 tree_4589 0.8192
Cp_4589 tree_4589 0 2.592e-15
Rtr_458_4590 tree_458 tree_4590 0.8192
Cp_4590 tree_4590 0 2.592e-15
Rtr_459_4591 tree_459 tree_4591 0.8192
Cp_4591 tree_4591 0 2.592e-15
Rtr_459_4592 tree_459 tree_4592 0.8192
Cp_4592 tree_4592 0 2.592e-15
Rtr_459_4593 tree_459 tree_4593 0.8192
Cp_4593 tree_4593 0 2.592e-15
Rtr_459_4594 tree_459 tree_4594 0.8192
Cp_4594 tree_4594 0 2.592e-15
Rtr_459_4595 tree_459 tree_4595 0.8192
Cp_4595 tree_4595 0 2.592e-15
Rtr_459_4596 tree_459 tree_4596 0.8192
Cp_4596 tree_4596 0 2.592e-15
Rtr_459_4597 tree_459 tree_4597 0.8192
Cp_4597 tree_4597 0 2.592e-15
Rtr_459_4598 tree_459 tree_4598 0.8192
Cp_4598 tree_4598 0 2.592e-15
Rtr_459_4599 tree_459 tree_4599 0.8192
Cp_4599 tree_4599 0 2.592e-15
Rtr_459_4600 tree_459 tree_4600 0.8192
Cp_4600 tree_4600 0 2.592e-15
Rtr_460_4601 tree_460 tree_4601 0.8192
Cp_4601 tree_4601 0 2.592e-15
Rtr_460_4602 tree_460 tree_4602 0.8192
Cp_4602 tree_4602 0 2.592e-15
Rtr_460_4603 tree_460 tree_4603 0.8192
Cp_4603 tree_4603 0 2.592e-15
Rtr_460_4604 tree_460 tree_4604 0.8192
Cp_4604 tree_4604 0 2.592e-15
Rtr_460_4605 tree_460 tree_4605 0.8192
Cp_4605 tree_4605 0 2.592e-15
Rtr_460_4606 tree_460 tree_4606 0.8192
Cp_4606 tree_4606 0 2.592e-15
Rtr_460_4607 tree_460 tree_4607 0.8192
Cp_4607 tree_4607 0 2.592e-15
Rtr_460_4608 tree_460 tree_4608 0.8192
Cp_4608 tree_4608 0 2.592e-15
Rtr_460_4609 tree_460 tree_4609 0.8192
Cp_4609 tree_4609 0 2.592e-15
Rtr_460_4610 tree_460 tree_4610 0.8192
Cp_4610 tree_4610 0 2.592e-15
Rtr_461_4611 tree_461 tree_4611 0.8192
Cp_4611 tree_4611 0 2.592e-15
Rtr_461_4612 tree_461 tree_4612 0.8192
Cp_4612 tree_4612 0 2.592e-15
Rtr_461_4613 tree_461 tree_4613 0.8192
Cp_4613 tree_4613 0 2.592e-15
Rtr_461_4614 tree_461 tree_4614 0.8192
Cp_4614 tree_4614 0 2.592e-15
Rtr_461_4615 tree_461 tree_4615 0.8192
Cp_4615 tree_4615 0 2.592e-15
Rtr_461_4616 tree_461 tree_4616 0.8192
Cp_4616 tree_4616 0 2.592e-15
Rtr_461_4617 tree_461 tree_4617 0.8192
Cp_4617 tree_4617 0 2.592e-15
Rtr_461_4618 tree_461 tree_4618 0.8192
Cp_4618 tree_4618 0 2.592e-15
Rtr_461_4619 tree_461 tree_4619 0.8192
Cp_4619 tree_4619 0 2.592e-15
Rtr_461_4620 tree_461 tree_4620 0.8192
Cp_4620 tree_4620 0 2.592e-15
Rtr_462_4621 tree_462 tree_4621 0.8192
Cp_4621 tree_4621 0 2.592e-15
Rtr_462_4622 tree_462 tree_4622 0.8192
Cp_4622 tree_4622 0 2.592e-15
Rtr_462_4623 tree_462 tree_4623 0.8192
Cp_4623 tree_4623 0 2.592e-15
Rtr_462_4624 tree_462 tree_4624 0.8192
Cp_4624 tree_4624 0 2.592e-15
Rtr_462_4625 tree_462 tree_4625 0.8192
Cp_4625 tree_4625 0 2.592e-15
Rtr_462_4626 tree_462 tree_4626 0.8192
Cp_4626 tree_4626 0 2.592e-15
Rtr_462_4627 tree_462 tree_4627 0.8192
Cp_4627 tree_4627 0 2.592e-15
Rtr_462_4628 tree_462 tree_4628 0.8192
Cp_4628 tree_4628 0 2.592e-15
Rtr_462_4629 tree_462 tree_4629 0.8192
Cp_4629 tree_4629 0 2.592e-15
Rtr_462_4630 tree_462 tree_4630 0.8192
Cp_4630 tree_4630 0 2.592e-15
Rtr_463_4631 tree_463 tree_4631 0.8192
Cp_4631 tree_4631 0 2.592e-15
Rtr_463_4632 tree_463 tree_4632 0.8192
Cp_4632 tree_4632 0 2.592e-15
Rtr_463_4633 tree_463 tree_4633 0.8192
Cp_4633 tree_4633 0 2.592e-15
Rtr_463_4634 tree_463 tree_4634 0.8192
Cp_4634 tree_4634 0 2.592e-15
Rtr_463_4635 tree_463 tree_4635 0.8192
Cp_4635 tree_4635 0 2.592e-15
Rtr_463_4636 tree_463 tree_4636 0.8192
Cp_4636 tree_4636 0 2.592e-15
Rtr_463_4637 tree_463 tree_4637 0.8192
Cp_4637 tree_4637 0 2.592e-15
Rtr_463_4638 tree_463 tree_4638 0.8192
Cp_4638 tree_4638 0 2.592e-15
Rtr_463_4639 tree_463 tree_4639 0.8192
Cp_4639 tree_4639 0 2.592e-15
Rtr_463_4640 tree_463 tree_4640 0.8192
Cp_4640 tree_4640 0 2.592e-15
Rtr_464_4641 tree_464 tree_4641 0.8192
Cp_4641 tree_4641 0 2.592e-15
Rtr_464_4642 tree_464 tree_4642 0.8192
Cp_4642 tree_4642 0 2.592e-15
Rtr_464_4643 tree_464 tree_4643 0.8192
Cp_4643 tree_4643 0 2.592e-15
Rtr_464_4644 tree_464 tree_4644 0.8192
Cp_4644 tree_4644 0 2.592e-15
Rtr_464_4645 tree_464 tree_4645 0.8192
Cp_4645 tree_4645 0 2.592e-15
Rtr_464_4646 tree_464 tree_4646 0.8192
Cp_4646 tree_4646 0 2.592e-15
Rtr_464_4647 tree_464 tree_4647 0.8192
Cp_4647 tree_4647 0 2.592e-15
Rtr_464_4648 tree_464 tree_4648 0.8192
Cp_4648 tree_4648 0 2.592e-15
Rtr_464_4649 tree_464 tree_4649 0.8192
Cp_4649 tree_4649 0 2.592e-15
Rtr_464_4650 tree_464 tree_4650 0.8192
Cp_4650 tree_4650 0 2.592e-15
Rtr_465_4651 tree_465 tree_4651 0.8192
Cp_4651 tree_4651 0 2.592e-15
Rtr_465_4652 tree_465 tree_4652 0.8192
Cp_4652 tree_4652 0 2.592e-15
Rtr_465_4653 tree_465 tree_4653 0.8192
Cp_4653 tree_4653 0 2.592e-15
Rtr_465_4654 tree_465 tree_4654 0.8192
Cp_4654 tree_4654 0 2.592e-15
Rtr_465_4655 tree_465 tree_4655 0.8192
Cp_4655 tree_4655 0 2.592e-15
Rtr_465_4656 tree_465 tree_4656 0.8192
Cp_4656 tree_4656 0 2.592e-15
Rtr_465_4657 tree_465 tree_4657 0.8192
Cp_4657 tree_4657 0 2.592e-15
Rtr_465_4658 tree_465 tree_4658 0.8192
Cp_4658 tree_4658 0 2.592e-15
Rtr_465_4659 tree_465 tree_4659 0.8192
Cp_4659 tree_4659 0 2.592e-15
Rtr_465_4660 tree_465 tree_4660 0.8192
Cp_4660 tree_4660 0 2.592e-15
Rtr_466_4661 tree_466 tree_4661 0.8192
Cp_4661 tree_4661 0 2.592e-15
Rtr_466_4662 tree_466 tree_4662 0.8192
Cp_4662 tree_4662 0 2.592e-15
Rtr_466_4663 tree_466 tree_4663 0.8192
Cp_4663 tree_4663 0 2.592e-15
Rtr_466_4664 tree_466 tree_4664 0.8192
Cp_4664 tree_4664 0 2.592e-15
Rtr_466_4665 tree_466 tree_4665 0.8192
Cp_4665 tree_4665 0 2.592e-15
Rtr_466_4666 tree_466 tree_4666 0.8192
Cp_4666 tree_4666 0 2.592e-15
Rtr_466_4667 tree_466 tree_4667 0.8192
Cp_4667 tree_4667 0 2.592e-15
Rtr_466_4668 tree_466 tree_4668 0.8192
Cp_4668 tree_4668 0 2.592e-15
Rtr_466_4669 tree_466 tree_4669 0.8192
Cp_4669 tree_4669 0 2.592e-15
Rtr_466_4670 tree_466 tree_4670 0.8192
Cp_4670 tree_4670 0 2.592e-15
Rtr_467_4671 tree_467 tree_4671 0.8192
Cp_4671 tree_4671 0 2.592e-15
Rtr_467_4672 tree_467 tree_4672 0.8192
Cp_4672 tree_4672 0 2.592e-15
Rtr_467_4673 tree_467 tree_4673 0.8192
Cp_4673 tree_4673 0 2.592e-15
Rtr_467_4674 tree_467 tree_4674 0.8192
Cp_4674 tree_4674 0 2.592e-15
Rtr_467_4675 tree_467 tree_4675 0.8192
Cp_4675 tree_4675 0 2.592e-15
Rtr_467_4676 tree_467 tree_4676 0.8192
Cp_4676 tree_4676 0 2.592e-15
Rtr_467_4677 tree_467 tree_4677 0.8192
Cp_4677 tree_4677 0 2.592e-15
Rtr_467_4678 tree_467 tree_4678 0.8192
Cp_4678 tree_4678 0 2.592e-15
Rtr_467_4679 tree_467 tree_4679 0.8192
Cp_4679 tree_4679 0 2.592e-15
Rtr_467_4680 tree_467 tree_4680 0.8192
Cp_4680 tree_4680 0 2.592e-15
Rtr_468_4681 tree_468 tree_4681 0.8192
Cp_4681 tree_4681 0 2.592e-15
Rtr_468_4682 tree_468 tree_4682 0.8192
Cp_4682 tree_4682 0 2.592e-15
Rtr_468_4683 tree_468 tree_4683 0.8192
Cp_4683 tree_4683 0 2.592e-15
Rtr_468_4684 tree_468 tree_4684 0.8192
Cp_4684 tree_4684 0 2.592e-15
Rtr_468_4685 tree_468 tree_4685 0.8192
Cp_4685 tree_4685 0 2.592e-15
Rtr_468_4686 tree_468 tree_4686 0.8192
Cp_4686 tree_4686 0 2.592e-15
Rtr_468_4687 tree_468 tree_4687 0.8192
Cp_4687 tree_4687 0 2.592e-15
Rtr_468_4688 tree_468 tree_4688 0.8192
Cp_4688 tree_4688 0 2.592e-15
Rtr_468_4689 tree_468 tree_4689 0.8192
Cp_4689 tree_4689 0 2.592e-15
Rtr_468_4690 tree_468 tree_4690 0.8192
Cp_4690 tree_4690 0 2.592e-15
Rtr_469_4691 tree_469 tree_4691 0.8192
Cp_4691 tree_4691 0 2.592e-15
Rtr_469_4692 tree_469 tree_4692 0.8192
Cp_4692 tree_4692 0 2.592e-15
Rtr_469_4693 tree_469 tree_4693 0.8192
Cp_4693 tree_4693 0 2.592e-15
Rtr_469_4694 tree_469 tree_4694 0.8192
Cp_4694 tree_4694 0 2.592e-15
Rtr_469_4695 tree_469 tree_4695 0.8192
Cp_4695 tree_4695 0 2.592e-15
Rtr_469_4696 tree_469 tree_4696 0.8192
Cp_4696 tree_4696 0 2.592e-15
Rtr_469_4697 tree_469 tree_4697 0.8192
Cp_4697 tree_4697 0 2.592e-15
Rtr_469_4698 tree_469 tree_4698 0.8192
Cp_4698 tree_4698 0 2.592e-15
Rtr_469_4699 tree_469 tree_4699 0.8192
Cp_4699 tree_4699 0 2.592e-15
Rtr_469_4700 tree_469 tree_4700 0.8192
Cp_4700 tree_4700 0 2.592e-15
Rtr_470_4701 tree_470 tree_4701 0.8192
Cp_4701 tree_4701 0 2.592e-15
Rtr_470_4702 tree_470 tree_4702 0.8192
Cp_4702 tree_4702 0 2.592e-15
Rtr_470_4703 tree_470 tree_4703 0.8192
Cp_4703 tree_4703 0 2.592e-15
Rtr_470_4704 tree_470 tree_4704 0.8192
Cp_4704 tree_4704 0 2.592e-15
Rtr_470_4705 tree_470 tree_4705 0.8192
Cp_4705 tree_4705 0 2.592e-15
Rtr_470_4706 tree_470 tree_4706 0.8192
Cp_4706 tree_4706 0 2.592e-15
Rtr_470_4707 tree_470 tree_4707 0.8192
Cp_4707 tree_4707 0 2.592e-15
Rtr_470_4708 tree_470 tree_4708 0.8192
Cp_4708 tree_4708 0 2.592e-15
Rtr_470_4709 tree_470 tree_4709 0.8192
Cp_4709 tree_4709 0 2.592e-15
Rtr_470_4710 tree_470 tree_4710 0.8192
Cp_4710 tree_4710 0 2.592e-15
Rtr_471_4711 tree_471 tree_4711 0.8192
Cp_4711 tree_4711 0 2.592e-15
Rtr_471_4712 tree_471 tree_4712 0.8192
Cp_4712 tree_4712 0 2.592e-15
Rtr_471_4713 tree_471 tree_4713 0.8192
Cp_4713 tree_4713 0 2.592e-15
Rtr_471_4714 tree_471 tree_4714 0.8192
Cp_4714 tree_4714 0 2.592e-15
Rtr_471_4715 tree_471 tree_4715 0.8192
Cp_4715 tree_4715 0 2.592e-15
Rtr_471_4716 tree_471 tree_4716 0.8192
Cp_4716 tree_4716 0 2.592e-15
Rtr_471_4717 tree_471 tree_4717 0.8192
Cp_4717 tree_4717 0 2.592e-15
Rtr_471_4718 tree_471 tree_4718 0.8192
Cp_4718 tree_4718 0 2.592e-15
Rtr_471_4719 tree_471 tree_4719 0.8192
Cp_4719 tree_4719 0 2.592e-15
Rtr_471_4720 tree_471 tree_4720 0.8192
Cp_4720 tree_4720 0 2.592e-15
Rtr_472_4721 tree_472 tree_4721 0.8192
Cp_4721 tree_4721 0 2.592e-15
Rtr_472_4722 tree_472 tree_4722 0.8192
Cp_4722 tree_4722 0 2.592e-15
Rtr_472_4723 tree_472 tree_4723 0.8192
Cp_4723 tree_4723 0 2.592e-15
Rtr_472_4724 tree_472 tree_4724 0.8192
Cp_4724 tree_4724 0 2.592e-15
Rtr_472_4725 tree_472 tree_4725 0.8192
Cp_4725 tree_4725 0 2.592e-15
Rtr_472_4726 tree_472 tree_4726 0.8192
Cp_4726 tree_4726 0 2.592e-15
Rtr_472_4727 tree_472 tree_4727 0.8192
Cp_4727 tree_4727 0 2.592e-15
Rtr_472_4728 tree_472 tree_4728 0.8192
Cp_4728 tree_4728 0 2.592e-15
Rtr_472_4729 tree_472 tree_4729 0.8192
Cp_4729 tree_4729 0 2.592e-15
Rtr_472_4730 tree_472 tree_4730 0.8192
Cp_4730 tree_4730 0 2.592e-15
Rtr_473_4731 tree_473 tree_4731 0.8192
Cp_4731 tree_4731 0 2.592e-15
Rtr_473_4732 tree_473 tree_4732 0.8192
Cp_4732 tree_4732 0 2.592e-15
Rtr_473_4733 tree_473 tree_4733 0.8192
Cp_4733 tree_4733 0 2.592e-15
Rtr_473_4734 tree_473 tree_4734 0.8192
Cp_4734 tree_4734 0 2.592e-15
Rtr_473_4735 tree_473 tree_4735 0.8192
Cp_4735 tree_4735 0 2.592e-15
Rtr_473_4736 tree_473 tree_4736 0.8192
Cp_4736 tree_4736 0 2.592e-15
Rtr_473_4737 tree_473 tree_4737 0.8192
Cp_4737 tree_4737 0 2.592e-15
Rtr_473_4738 tree_473 tree_4738 0.8192
Cp_4738 tree_4738 0 2.592e-15
Rtr_473_4739 tree_473 tree_4739 0.8192
Cp_4739 tree_4739 0 2.592e-15
Rtr_473_4740 tree_473 tree_4740 0.8192
Cp_4740 tree_4740 0 2.592e-15
Rtr_474_4741 tree_474 tree_4741 0.8192
Cp_4741 tree_4741 0 2.592e-15
Rtr_474_4742 tree_474 tree_4742 0.8192
Cp_4742 tree_4742 0 2.592e-15
Rtr_474_4743 tree_474 tree_4743 0.8192
Cp_4743 tree_4743 0 2.592e-15
Rtr_474_4744 tree_474 tree_4744 0.8192
Cp_4744 tree_4744 0 2.592e-15
Rtr_474_4745 tree_474 tree_4745 0.8192
Cp_4745 tree_4745 0 2.592e-15
Rtr_474_4746 tree_474 tree_4746 0.8192
Cp_4746 tree_4746 0 2.592e-15
Rtr_474_4747 tree_474 tree_4747 0.8192
Cp_4747 tree_4747 0 2.592e-15
Rtr_474_4748 tree_474 tree_4748 0.8192
Cp_4748 tree_4748 0 2.592e-15
Rtr_474_4749 tree_474 tree_4749 0.8192
Cp_4749 tree_4749 0 2.592e-15
Rtr_474_4750 tree_474 tree_4750 0.8192
Cp_4750 tree_4750 0 2.592e-15
Rtr_475_4751 tree_475 tree_4751 0.8192
Cp_4751 tree_4751 0 2.592e-15
Rtr_475_4752 tree_475 tree_4752 0.8192
Cp_4752 tree_4752 0 2.592e-15
Rtr_475_4753 tree_475 tree_4753 0.8192
Cp_4753 tree_4753 0 2.592e-15
Rtr_475_4754 tree_475 tree_4754 0.8192
Cp_4754 tree_4754 0 2.592e-15
Rtr_475_4755 tree_475 tree_4755 0.8192
Cp_4755 tree_4755 0 2.592e-15
Rtr_475_4756 tree_475 tree_4756 0.8192
Cp_4756 tree_4756 0 2.592e-15
Rtr_475_4757 tree_475 tree_4757 0.8192
Cp_4757 tree_4757 0 2.592e-15
Rtr_475_4758 tree_475 tree_4758 0.8192
Cp_4758 tree_4758 0 2.592e-15
Rtr_475_4759 tree_475 tree_4759 0.8192
Cp_4759 tree_4759 0 2.592e-15
Rtr_475_4760 tree_475 tree_4760 0.8192
Cp_4760 tree_4760 0 2.592e-15
Rtr_476_4761 tree_476 tree_4761 0.8192
Cp_4761 tree_4761 0 2.592e-15
Rtr_476_4762 tree_476 tree_4762 0.8192
Cp_4762 tree_4762 0 2.592e-15
Rtr_476_4763 tree_476 tree_4763 0.8192
Cp_4763 tree_4763 0 2.592e-15
Rtr_476_4764 tree_476 tree_4764 0.8192
Cp_4764 tree_4764 0 2.592e-15
Rtr_476_4765 tree_476 tree_4765 0.8192
Cp_4765 tree_4765 0 2.592e-15
Rtr_476_4766 tree_476 tree_4766 0.8192
Cp_4766 tree_4766 0 2.592e-15
Rtr_476_4767 tree_476 tree_4767 0.8192
Cp_4767 tree_4767 0 2.592e-15
Rtr_476_4768 tree_476 tree_4768 0.8192
Cp_4768 tree_4768 0 2.592e-15
Rtr_476_4769 tree_476 tree_4769 0.8192
Cp_4769 tree_4769 0 2.592e-15
Rtr_476_4770 tree_476 tree_4770 0.8192
Cp_4770 tree_4770 0 2.592e-15
Rtr_477_4771 tree_477 tree_4771 0.8192
Cp_4771 tree_4771 0 2.592e-15
Rtr_477_4772 tree_477 tree_4772 0.8192
Cp_4772 tree_4772 0 2.592e-15
Rtr_477_4773 tree_477 tree_4773 0.8192
Cp_4773 tree_4773 0 2.592e-15
Rtr_477_4774 tree_477 tree_4774 0.8192
Cp_4774 tree_4774 0 2.592e-15
Rtr_477_4775 tree_477 tree_4775 0.8192
Cp_4775 tree_4775 0 2.592e-15
Rtr_477_4776 tree_477 tree_4776 0.8192
Cp_4776 tree_4776 0 2.592e-15
Rtr_477_4777 tree_477 tree_4777 0.8192
Cp_4777 tree_4777 0 2.592e-15
Rtr_477_4778 tree_477 tree_4778 0.8192
Cp_4778 tree_4778 0 2.592e-15
Rtr_477_4779 tree_477 tree_4779 0.8192
Cp_4779 tree_4779 0 2.592e-15
Rtr_477_4780 tree_477 tree_4780 0.8192
Cp_4780 tree_4780 0 2.592e-15
Rtr_478_4781 tree_478 tree_4781 0.8192
Cp_4781 tree_4781 0 2.592e-15
Rtr_478_4782 tree_478 tree_4782 0.8192
Cp_4782 tree_4782 0 2.592e-15
Rtr_478_4783 tree_478 tree_4783 0.8192
Cp_4783 tree_4783 0 2.592e-15
Rtr_478_4784 tree_478 tree_4784 0.8192
Cp_4784 tree_4784 0 2.592e-15
Rtr_478_4785 tree_478 tree_4785 0.8192
Cp_4785 tree_4785 0 2.592e-15
Rtr_478_4786 tree_478 tree_4786 0.8192
Cp_4786 tree_4786 0 2.592e-15
Rtr_478_4787 tree_478 tree_4787 0.8192
Cp_4787 tree_4787 0 2.592e-15
Rtr_478_4788 tree_478 tree_4788 0.8192
Cp_4788 tree_4788 0 2.592e-15
Rtr_478_4789 tree_478 tree_4789 0.8192
Cp_4789 tree_4789 0 2.592e-15
Rtr_478_4790 tree_478 tree_4790 0.8192
Cp_4790 tree_4790 0 2.592e-15
Rtr_479_4791 tree_479 tree_4791 0.8192
Cp_4791 tree_4791 0 2.592e-15
Rtr_479_4792 tree_479 tree_4792 0.8192
Cp_4792 tree_4792 0 2.592e-15
Rtr_479_4793 tree_479 tree_4793 0.8192
Cp_4793 tree_4793 0 2.592e-15
Rtr_479_4794 tree_479 tree_4794 0.8192
Cp_4794 tree_4794 0 2.592e-15
Rtr_479_4795 tree_479 tree_4795 0.8192
Cp_4795 tree_4795 0 2.592e-15
Rtr_479_4796 tree_479 tree_4796 0.8192
Cp_4796 tree_4796 0 2.592e-15
Rtr_479_4797 tree_479 tree_4797 0.8192
Cp_4797 tree_4797 0 2.592e-15
Rtr_479_4798 tree_479 tree_4798 0.8192
Cp_4798 tree_4798 0 2.592e-15
Rtr_479_4799 tree_479 tree_4799 0.8192
Cp_4799 tree_4799 0 2.592e-15
Rtr_479_4800 tree_479 tree_4800 0.8192
Cp_4800 tree_4800 0 2.592e-15
Rtr_480_4801 tree_480 tree_4801 0.8192
Cp_4801 tree_4801 0 2.592e-15
Rtr_480_4802 tree_480 tree_4802 0.8192
Cp_4802 tree_4802 0 2.592e-15
Rtr_480_4803 tree_480 tree_4803 0.8192
Cp_4803 tree_4803 0 2.592e-15
Rtr_480_4804 tree_480 tree_4804 0.8192
Cp_4804 tree_4804 0 2.592e-15
Rtr_480_4805 tree_480 tree_4805 0.8192
Cp_4805 tree_4805 0 2.592e-15
Rtr_480_4806 tree_480 tree_4806 0.8192
Cp_4806 tree_4806 0 2.592e-15
Rtr_480_4807 tree_480 tree_4807 0.8192
Cp_4807 tree_4807 0 2.592e-15
Rtr_480_4808 tree_480 tree_4808 0.8192
Cp_4808 tree_4808 0 2.592e-15
Rtr_480_4809 tree_480 tree_4809 0.8192
Cp_4809 tree_4809 0 2.592e-15
Rtr_480_4810 tree_480 tree_4810 0.8192
Cp_4810 tree_4810 0 2.592e-15
Rtr_481_4811 tree_481 tree_4811 0.8192
Cp_4811 tree_4811 0 2.592e-15
Rtr_481_4812 tree_481 tree_4812 0.8192
Cp_4812 tree_4812 0 2.592e-15
Rtr_481_4813 tree_481 tree_4813 0.8192
Cp_4813 tree_4813 0 2.592e-15
Rtr_481_4814 tree_481 tree_4814 0.8192
Cp_4814 tree_4814 0 2.592e-15
Rtr_481_4815 tree_481 tree_4815 0.8192
Cp_4815 tree_4815 0 2.592e-15
Rtr_481_4816 tree_481 tree_4816 0.8192
Cp_4816 tree_4816 0 2.592e-15
Rtr_481_4817 tree_481 tree_4817 0.8192
Cp_4817 tree_4817 0 2.592e-15
Rtr_481_4818 tree_481 tree_4818 0.8192
Cp_4818 tree_4818 0 2.592e-15
Rtr_481_4819 tree_481 tree_4819 0.8192
Cp_4819 tree_4819 0 2.592e-15
Rtr_481_4820 tree_481 tree_4820 0.8192
Cp_4820 tree_4820 0 2.592e-15
Rtr_482_4821 tree_482 tree_4821 0.8192
Cp_4821 tree_4821 0 2.592e-15
Rtr_482_4822 tree_482 tree_4822 0.8192
Cp_4822 tree_4822 0 2.592e-15
Rtr_482_4823 tree_482 tree_4823 0.8192
Cp_4823 tree_4823 0 2.592e-15
Rtr_482_4824 tree_482 tree_4824 0.8192
Cp_4824 tree_4824 0 2.592e-15
Rtr_482_4825 tree_482 tree_4825 0.8192
Cp_4825 tree_4825 0 2.592e-15
Rtr_482_4826 tree_482 tree_4826 0.8192
Cp_4826 tree_4826 0 2.592e-15
Rtr_482_4827 tree_482 tree_4827 0.8192
Cp_4827 tree_4827 0 2.592e-15
Rtr_482_4828 tree_482 tree_4828 0.8192
Cp_4828 tree_4828 0 2.592e-15
Rtr_482_4829 tree_482 tree_4829 0.8192
Cp_4829 tree_4829 0 2.592e-15
Rtr_482_4830 tree_482 tree_4830 0.8192
Cp_4830 tree_4830 0 2.592e-15
Rtr_483_4831 tree_483 tree_4831 0.8192
Cp_4831 tree_4831 0 2.592e-15
Rtr_483_4832 tree_483 tree_4832 0.8192
Cp_4832 tree_4832 0 2.592e-15
Rtr_483_4833 tree_483 tree_4833 0.8192
Cp_4833 tree_4833 0 2.592e-15
Rtr_483_4834 tree_483 tree_4834 0.8192
Cp_4834 tree_4834 0 2.592e-15
Rtr_483_4835 tree_483 tree_4835 0.8192
Cp_4835 tree_4835 0 2.592e-15
Rtr_483_4836 tree_483 tree_4836 0.8192
Cp_4836 tree_4836 0 2.592e-15
Rtr_483_4837 tree_483 tree_4837 0.8192
Cp_4837 tree_4837 0 2.592e-15
Rtr_483_4838 tree_483 tree_4838 0.8192
Cp_4838 tree_4838 0 2.592e-15
Rtr_483_4839 tree_483 tree_4839 0.8192
Cp_4839 tree_4839 0 2.592e-15
Rtr_483_4840 tree_483 tree_4840 0.8192
Cp_4840 tree_4840 0 2.592e-15
Rtr_484_4841 tree_484 tree_4841 0.8192
Cp_4841 tree_4841 0 2.592e-15
Rtr_484_4842 tree_484 tree_4842 0.8192
Cp_4842 tree_4842 0 2.592e-15
Rtr_484_4843 tree_484 tree_4843 0.8192
Cp_4843 tree_4843 0 2.592e-15
Rtr_484_4844 tree_484 tree_4844 0.8192
Cp_4844 tree_4844 0 2.592e-15
Rtr_484_4845 tree_484 tree_4845 0.8192
Cp_4845 tree_4845 0 2.592e-15
Rtr_484_4846 tree_484 tree_4846 0.8192
Cp_4846 tree_4846 0 2.592e-15
Rtr_484_4847 tree_484 tree_4847 0.8192
Cp_4847 tree_4847 0 2.592e-15
Rtr_484_4848 tree_484 tree_4848 0.8192
Cp_4848 tree_4848 0 2.592e-15
Rtr_484_4849 tree_484 tree_4849 0.8192
Cp_4849 tree_4849 0 2.592e-15
Rtr_484_4850 tree_484 tree_4850 0.8192
Cp_4850 tree_4850 0 2.592e-15
Rtr_485_4851 tree_485 tree_4851 0.8192
Cp_4851 tree_4851 0 2.592e-15
Rtr_485_4852 tree_485 tree_4852 0.8192
Cp_4852 tree_4852 0 2.592e-15
Rtr_485_4853 tree_485 tree_4853 0.8192
Cp_4853 tree_4853 0 2.592e-15
Rtr_485_4854 tree_485 tree_4854 0.8192
Cp_4854 tree_4854 0 2.592e-15
Rtr_485_4855 tree_485 tree_4855 0.8192
Cp_4855 tree_4855 0 2.592e-15
Rtr_485_4856 tree_485 tree_4856 0.8192
Cp_4856 tree_4856 0 2.592e-15
Rtr_485_4857 tree_485 tree_4857 0.8192
Cp_4857 tree_4857 0 2.592e-15
Rtr_485_4858 tree_485 tree_4858 0.8192
Cp_4858 tree_4858 0 2.592e-15
Rtr_485_4859 tree_485 tree_4859 0.8192
Cp_4859 tree_4859 0 2.592e-15
Rtr_485_4860 tree_485 tree_4860 0.8192
Cp_4860 tree_4860 0 2.592e-15
Rtr_486_4861 tree_486 tree_4861 0.8192
Cp_4861 tree_4861 0 2.592e-15
Rtr_486_4862 tree_486 tree_4862 0.8192
Cp_4862 tree_4862 0 2.592e-15
Rtr_486_4863 tree_486 tree_4863 0.8192
Cp_4863 tree_4863 0 2.592e-15
Rtr_486_4864 tree_486 tree_4864 0.8192
Cp_4864 tree_4864 0 2.592e-15
Rtr_486_4865 tree_486 tree_4865 0.8192
Cp_4865 tree_4865 0 2.592e-15
Rtr_486_4866 tree_486 tree_4866 0.8192
Cp_4866 tree_4866 0 2.592e-15
Rtr_486_4867 tree_486 tree_4867 0.8192
Cp_4867 tree_4867 0 2.592e-15
Rtr_486_4868 tree_486 tree_4868 0.8192
Cp_4868 tree_4868 0 2.592e-15
Rtr_486_4869 tree_486 tree_4869 0.8192
Cp_4869 tree_4869 0 2.592e-15
Rtr_486_4870 tree_486 tree_4870 0.8192
Cp_4870 tree_4870 0 2.592e-15
Rtr_487_4871 tree_487 tree_4871 0.8192
Cp_4871 tree_4871 0 2.592e-15
Rtr_487_4872 tree_487 tree_4872 0.8192
Cp_4872 tree_4872 0 2.592e-15
Rtr_487_4873 tree_487 tree_4873 0.8192
Cp_4873 tree_4873 0 2.592e-15
Rtr_487_4874 tree_487 tree_4874 0.8192
Cp_4874 tree_4874 0 2.592e-15
Rtr_487_4875 tree_487 tree_4875 0.8192
Cp_4875 tree_4875 0 2.592e-15
Rtr_487_4876 tree_487 tree_4876 0.8192
Cp_4876 tree_4876 0 2.592e-15
Rtr_487_4877 tree_487 tree_4877 0.8192
Cp_4877 tree_4877 0 2.592e-15
Rtr_487_4878 tree_487 tree_4878 0.8192
Cp_4878 tree_4878 0 2.592e-15
Rtr_487_4879 tree_487 tree_4879 0.8192
Cp_4879 tree_4879 0 2.592e-15
Rtr_487_4880 tree_487 tree_4880 0.8192
Cp_4880 tree_4880 0 2.592e-15
Rtr_488_4881 tree_488 tree_4881 0.8192
Cp_4881 tree_4881 0 2.592e-15
Rtr_488_4882 tree_488 tree_4882 0.8192
Cp_4882 tree_4882 0 2.592e-15
Rtr_488_4883 tree_488 tree_4883 0.8192
Cp_4883 tree_4883 0 2.592e-15
Rtr_488_4884 tree_488 tree_4884 0.8192
Cp_4884 tree_4884 0 2.592e-15
Rtr_488_4885 tree_488 tree_4885 0.8192
Cp_4885 tree_4885 0 2.592e-15
Rtr_488_4886 tree_488 tree_4886 0.8192
Cp_4886 tree_4886 0 2.592e-15
Rtr_488_4887 tree_488 tree_4887 0.8192
Cp_4887 tree_4887 0 2.592e-15
Rtr_488_4888 tree_488 tree_4888 0.8192
Cp_4888 tree_4888 0 2.592e-15
Rtr_488_4889 tree_488 tree_4889 0.8192
Cp_4889 tree_4889 0 2.592e-15
Rtr_488_4890 tree_488 tree_4890 0.8192
Cp_4890 tree_4890 0 2.592e-15
Rtr_489_4891 tree_489 tree_4891 0.8192
Cp_4891 tree_4891 0 2.592e-15
Rtr_489_4892 tree_489 tree_4892 0.8192
Cp_4892 tree_4892 0 2.592e-15
Rtr_489_4893 tree_489 tree_4893 0.8192
Cp_4893 tree_4893 0 2.592e-15
Rtr_489_4894 tree_489 tree_4894 0.8192
Cp_4894 tree_4894 0 2.592e-15
Rtr_489_4895 tree_489 tree_4895 0.8192
Cp_4895 tree_4895 0 2.592e-15
Rtr_489_4896 tree_489 tree_4896 0.8192
Cp_4896 tree_4896 0 2.592e-15
Rtr_489_4897 tree_489 tree_4897 0.8192
Cp_4897 tree_4897 0 2.592e-15
Rtr_489_4898 tree_489 tree_4898 0.8192
Cp_4898 tree_4898 0 2.592e-15
Rtr_489_4899 tree_489 tree_4899 0.8192
Cp_4899 tree_4899 0 2.592e-15
Rtr_489_4900 tree_489 tree_4900 0.8192
Cp_4900 tree_4900 0 2.592e-15
Rtr_490_4901 tree_490 tree_4901 0.8192
Cp_4901 tree_4901 0 2.592e-15
Rtr_490_4902 tree_490 tree_4902 0.8192
Cp_4902 tree_4902 0 2.592e-15
Rtr_490_4903 tree_490 tree_4903 0.8192
Cp_4903 tree_4903 0 2.592e-15
Rtr_490_4904 tree_490 tree_4904 0.8192
Cp_4904 tree_4904 0 2.592e-15
Rtr_490_4905 tree_490 tree_4905 0.8192
Cp_4905 tree_4905 0 2.592e-15
Rtr_490_4906 tree_490 tree_4906 0.8192
Cp_4906 tree_4906 0 2.592e-15
Rtr_490_4907 tree_490 tree_4907 0.8192
Cp_4907 tree_4907 0 2.592e-15
Rtr_490_4908 tree_490 tree_4908 0.8192
Cp_4908 tree_4908 0 2.592e-15
Rtr_490_4909 tree_490 tree_4909 0.8192
Cp_4909 tree_4909 0 2.592e-15
Rtr_490_4910 tree_490 tree_4910 0.8192
Cp_4910 tree_4910 0 2.592e-15
Rtr_491_4911 tree_491 tree_4911 0.8192
Cp_4911 tree_4911 0 2.592e-15
Rtr_491_4912 tree_491 tree_4912 0.8192
Cp_4912 tree_4912 0 2.592e-15
Rtr_491_4913 tree_491 tree_4913 0.8192
Cp_4913 tree_4913 0 2.592e-15
Rtr_491_4914 tree_491 tree_4914 0.8192
Cp_4914 tree_4914 0 2.592e-15
Rtr_491_4915 tree_491 tree_4915 0.8192
Cp_4915 tree_4915 0 2.592e-15
Rtr_491_4916 tree_491 tree_4916 0.8192
Cp_4916 tree_4916 0 2.592e-15
Rtr_491_4917 tree_491 tree_4917 0.8192
Cp_4917 tree_4917 0 2.592e-15
Rtr_491_4918 tree_491 tree_4918 0.8192
Cp_4918 tree_4918 0 2.592e-15
Rtr_491_4919 tree_491 tree_4919 0.8192
Cp_4919 tree_4919 0 2.592e-15
Rtr_491_4920 tree_491 tree_4920 0.8192
Cp_4920 tree_4920 0 2.592e-15
Rtr_492_4921 tree_492 tree_4921 0.8192
Cp_4921 tree_4921 0 2.592e-15
Rtr_492_4922 tree_492 tree_4922 0.8192
Cp_4922 tree_4922 0 2.592e-15
Rtr_492_4923 tree_492 tree_4923 0.8192
Cp_4923 tree_4923 0 2.592e-15
Rtr_492_4924 tree_492 tree_4924 0.8192
Cp_4924 tree_4924 0 2.592e-15
Rtr_492_4925 tree_492 tree_4925 0.8192
Cp_4925 tree_4925 0 2.592e-15
Rtr_492_4926 tree_492 tree_4926 0.8192
Cp_4926 tree_4926 0 2.592e-15
Rtr_492_4927 tree_492 tree_4927 0.8192
Cp_4927 tree_4927 0 2.592e-15
Rtr_492_4928 tree_492 tree_4928 0.8192
Cp_4928 tree_4928 0 2.592e-15
Rtr_492_4929 tree_492 tree_4929 0.8192
Cp_4929 tree_4929 0 2.592e-15
Rtr_492_4930 tree_492 tree_4930 0.8192
Cp_4930 tree_4930 0 2.592e-15
Rtr_493_4931 tree_493 tree_4931 0.8192
Cp_4931 tree_4931 0 2.592e-15
Rtr_493_4932 tree_493 tree_4932 0.8192
Cp_4932 tree_4932 0 2.592e-15
Rtr_493_4933 tree_493 tree_4933 0.8192
Cp_4933 tree_4933 0 2.592e-15
Rtr_493_4934 tree_493 tree_4934 0.8192
Cp_4934 tree_4934 0 2.592e-15
Rtr_493_4935 tree_493 tree_4935 0.8192
Cp_4935 tree_4935 0 2.592e-15
Rtr_493_4936 tree_493 tree_4936 0.8192
Cp_4936 tree_4936 0 2.592e-15
Rtr_493_4937 tree_493 tree_4937 0.8192
Cp_4937 tree_4937 0 2.592e-15
Rtr_493_4938 tree_493 tree_4938 0.8192
Cp_4938 tree_4938 0 2.592e-15
Rtr_493_4939 tree_493 tree_4939 0.8192
Cp_4939 tree_4939 0 2.592e-15
Rtr_493_4940 tree_493 tree_4940 0.8192
Cp_4940 tree_4940 0 2.592e-15
Rtr_494_4941 tree_494 tree_4941 0.8192
Cp_4941 tree_4941 0 2.592e-15
Rtr_494_4942 tree_494 tree_4942 0.8192
Cp_4942 tree_4942 0 2.592e-15
Rtr_494_4943 tree_494 tree_4943 0.8192
Cp_4943 tree_4943 0 2.592e-15
Rtr_494_4944 tree_494 tree_4944 0.8192
Cp_4944 tree_4944 0 2.592e-15
Rtr_494_4945 tree_494 tree_4945 0.8192
Cp_4945 tree_4945 0 2.592e-15
Rtr_494_4946 tree_494 tree_4946 0.8192
Cp_4946 tree_4946 0 2.592e-15
Rtr_494_4947 tree_494 tree_4947 0.8192
Cp_4947 tree_4947 0 2.592e-15
Rtr_494_4948 tree_494 tree_4948 0.8192
Cp_4948 tree_4948 0 2.592e-15
Rtr_494_4949 tree_494 tree_4949 0.8192
Cp_4949 tree_4949 0 2.592e-15
Rtr_494_4950 tree_494 tree_4950 0.8192
Cp_4950 tree_4950 0 2.592e-15
Rtr_495_4951 tree_495 tree_4951 0.8192
Cp_4951 tree_4951 0 2.592e-15
Rtr_495_4952 tree_495 tree_4952 0.8192
Cp_4952 tree_4952 0 2.592e-15
Rtr_495_4953 tree_495 tree_4953 0.8192
Cp_4953 tree_4953 0 2.592e-15
Rtr_495_4954 tree_495 tree_4954 0.8192
Cp_4954 tree_4954 0 2.592e-15
Rtr_495_4955 tree_495 tree_4955 0.8192
Cp_4955 tree_4955 0 2.592e-15
Rtr_495_4956 tree_495 tree_4956 0.8192
Cp_4956 tree_4956 0 2.592e-15
Rtr_495_4957 tree_495 tree_4957 0.8192
Cp_4957 tree_4957 0 2.592e-15
Rtr_495_4958 tree_495 tree_4958 0.8192
Cp_4958 tree_4958 0 2.592e-15
Rtr_495_4959 tree_495 tree_4959 0.8192
Cp_4959 tree_4959 0 2.592e-15
Rtr_495_4960 tree_495 tree_4960 0.8192
Cp_4960 tree_4960 0 2.592e-15
Rtr_496_4961 tree_496 tree_4961 0.8192
Cp_4961 tree_4961 0 2.592e-15
Rtr_496_4962 tree_496 tree_4962 0.8192
Cp_4962 tree_4962 0 2.592e-15
Rtr_496_4963 tree_496 tree_4963 0.8192
Cp_4963 tree_4963 0 2.592e-15
Rtr_496_4964 tree_496 tree_4964 0.8192
Cp_4964 tree_4964 0 2.592e-15
Rtr_496_4965 tree_496 tree_4965 0.8192
Cp_4965 tree_4965 0 2.592e-15
Rtr_496_4966 tree_496 tree_4966 0.8192
Cp_4966 tree_4966 0 2.592e-15
Rtr_496_4967 tree_496 tree_4967 0.8192
Cp_4967 tree_4967 0 2.592e-15
Rtr_496_4968 tree_496 tree_4968 0.8192
Cp_4968 tree_4968 0 2.592e-15
Rtr_496_4969 tree_496 tree_4969 0.8192
Cp_4969 tree_4969 0 2.592e-15
Rtr_496_4970 tree_496 tree_4970 0.8192
Cp_4970 tree_4970 0 2.592e-15
Rtr_497_4971 tree_497 tree_4971 0.8192
Cp_4971 tree_4971 0 2.592e-15
Rtr_497_4972 tree_497 tree_4972 0.8192
Cp_4972 tree_4972 0 2.592e-15
Rtr_497_4973 tree_497 tree_4973 0.8192
Cp_4973 tree_4973 0 2.592e-15
Rtr_497_4974 tree_497 tree_4974 0.8192
Cp_4974 tree_4974 0 2.592e-15
Rtr_497_4975 tree_497 tree_4975 0.8192
Cp_4975 tree_4975 0 2.592e-15
Rtr_497_4976 tree_497 tree_4976 0.8192
Cp_4976 tree_4976 0 2.592e-15
Rtr_497_4977 tree_497 tree_4977 0.8192
Cp_4977 tree_4977 0 2.592e-15
Rtr_497_4978 tree_497 tree_4978 0.8192
Cp_4978 tree_4978 0 2.592e-15
Rtr_497_4979 tree_497 tree_4979 0.8192
Cp_4979 tree_4979 0 2.592e-15
Rtr_497_4980 tree_497 tree_4980 0.8192
Cp_4980 tree_4980 0 2.592e-15
Rtr_498_4981 tree_498 tree_4981 0.8192
Cp_4981 tree_4981 0 2.592e-15
Rtr_498_4982 tree_498 tree_4982 0.8192
Cp_4982 tree_4982 0 2.592e-15
Rtr_498_4983 tree_498 tree_4983 0.8192
Cp_4983 tree_4983 0 2.592e-15
Rtr_498_4984 tree_498 tree_4984 0.8192
Cp_4984 tree_4984 0 2.592e-15
Rtr_498_4985 tree_498 tree_4985 0.8192
Cp_4985 tree_4985 0 2.592e-15
Rtr_498_4986 tree_498 tree_4986 0.8192
Cp_4986 tree_4986 0 2.592e-15
Rtr_498_4987 tree_498 tree_4987 0.8192
Cp_4987 tree_4987 0 2.592e-15
Rtr_498_4988 tree_498 tree_4988 0.8192
Cp_4988 tree_4988 0 2.592e-15
Rtr_498_4989 tree_498 tree_4989 0.8192
Cp_4989 tree_4989 0 2.592e-15
Rtr_498_4990 tree_498 tree_4990 0.8192
Cp_4990 tree_4990 0 2.592e-15
Rtr_499_4991 tree_499 tree_4991 0.8192
Cp_4991 tree_4991 0 2.592e-15
Rtr_499_4992 tree_499 tree_4992 0.8192
Cp_4992 tree_4992 0 2.592e-15
Rtr_499_4993 tree_499 tree_4993 0.8192
Cp_4993 tree_4993 0 2.592e-15
Rtr_499_4994 tree_499 tree_4994 0.8192
Cp_4994 tree_4994 0 2.592e-15
Rtr_499_4995 tree_499 tree_4995 0.8192
Cp_4995 tree_4995 0 2.592e-15
Rtr_499_4996 tree_499 tree_4996 0.8192
Cp_4996 tree_4996 0 2.592e-15
Rtr_499_4997 tree_499 tree_4997 0.8192
Cp_4997 tree_4997 0 2.592e-15
Rtr_499_4998 tree_499 tree_4998 0.8192
Cp_4998 tree_4998 0 2.592e-15
Rtr_499_4999 tree_499 tree_4999 0.8192
Cp_4999 tree_4999 0 2.592e-15
Rtr_499_5000 tree_499 tree_5000 0.8192
Cp_5000 tree_5000 0 2.592e-15
Rtr_500_5001 tree_500 tree_5001 0.8192
Cp_5001 tree_5001 0 2.592e-15
Rtr_500_5002 tree_500 tree_5002 0.8192
Cp_5002 tree_5002 0 2.592e-15
Rtr_500_5003 tree_500 tree_5003 0.8192
Cp_5003 tree_5003 0 2.592e-15
Rtr_500_5004 tree_500 tree_5004 0.8192
Cp_5004 tree_5004 0 2.592e-15
Rtr_500_5005 tree_500 tree_5005 0.8192
Cp_5005 tree_5005 0 2.592e-15
Rtr_500_5006 tree_500 tree_5006 0.8192
Cp_5006 tree_5006 0 2.592e-15
Rtr_500_5007 tree_500 tree_5007 0.8192
Cp_5007 tree_5007 0 2.592e-15
Rtr_500_5008 tree_500 tree_5008 0.8192
Cp_5008 tree_5008 0 2.592e-15
Rtr_500_5009 tree_500 tree_5009 0.8192
Cp_5009 tree_5009 0 2.592e-15
Rtr_500_5010 tree_500 tree_5010 0.8192
Cp_5010 tree_5010 0 2.592e-15
Rtr_501_5011 tree_501 tree_5011 0.8192
Cp_5011 tree_5011 0 2.592e-15
Rtr_501_5012 tree_501 tree_5012 0.8192
Cp_5012 tree_5012 0 2.592e-15
Rtr_501_5013 tree_501 tree_5013 0.8192
Cp_5013 tree_5013 0 2.592e-15
Rtr_501_5014 tree_501 tree_5014 0.8192
Cp_5014 tree_5014 0 2.592e-15
Rtr_501_5015 tree_501 tree_5015 0.8192
Cp_5015 tree_5015 0 2.592e-15
Rtr_501_5016 tree_501 tree_5016 0.8192
Cp_5016 tree_5016 0 2.592e-15
Rtr_501_5017 tree_501 tree_5017 0.8192
Cp_5017 tree_5017 0 2.592e-15
Rtr_501_5018 tree_501 tree_5018 0.8192
Cp_5018 tree_5018 0 2.592e-15
Rtr_501_5019 tree_501 tree_5019 0.8192
Cp_5019 tree_5019 0 2.592e-15
Rtr_501_5020 tree_501 tree_5020 0.8192
Cp_5020 tree_5020 0 2.592e-15
Rtr_502_5021 tree_502 tree_5021 0.8192
Cp_5021 tree_5021 0 2.592e-15
Rtr_502_5022 tree_502 tree_5022 0.8192
Cp_5022 tree_5022 0 2.592e-15
Rtr_502_5023 tree_502 tree_5023 0.8192
Cp_5023 tree_5023 0 2.592e-15
Rtr_502_5024 tree_502 tree_5024 0.8192
Cp_5024 tree_5024 0 2.592e-15
Rtr_502_5025 tree_502 tree_5025 0.8192
Cp_5025 tree_5025 0 2.592e-15
Rtr_502_5026 tree_502 tree_5026 0.8192
Cp_5026 tree_5026 0 2.592e-15
Rtr_502_5027 tree_502 tree_5027 0.8192
Cp_5027 tree_5027 0 2.592e-15
Rtr_502_5028 tree_502 tree_5028 0.8192
Cp_5028 tree_5028 0 2.592e-15
Rtr_502_5029 tree_502 tree_5029 0.8192
Cp_5029 tree_5029 0 2.592e-15
Rtr_502_5030 tree_502 tree_5030 0.8192
Cp_5030 tree_5030 0 2.592e-15
Rtr_503_5031 tree_503 tree_5031 0.8192
Cp_5031 tree_5031 0 2.592e-15
Rtr_503_5032 tree_503 tree_5032 0.8192
Cp_5032 tree_5032 0 2.592e-15
Rtr_503_5033 tree_503 tree_5033 0.8192
Cp_5033 tree_5033 0 2.592e-15
Rtr_503_5034 tree_503 tree_5034 0.8192
Cp_5034 tree_5034 0 2.592e-15
Rtr_503_5035 tree_503 tree_5035 0.8192
Cp_5035 tree_5035 0 2.592e-15
Rtr_503_5036 tree_503 tree_5036 0.8192
Cp_5036 tree_5036 0 2.592e-15
Rtr_503_5037 tree_503 tree_5037 0.8192
Cp_5037 tree_5037 0 2.592e-15
Rtr_503_5038 tree_503 tree_5038 0.8192
Cp_5038 tree_5038 0 2.592e-15
Rtr_503_5039 tree_503 tree_5039 0.8192
Cp_5039 tree_5039 0 2.592e-15
Rtr_503_5040 tree_503 tree_5040 0.8192
Cp_5040 tree_5040 0 2.592e-15
Rtr_504_5041 tree_504 tree_5041 0.8192
Cp_5041 tree_5041 0 2.592e-15
Rtr_504_5042 tree_504 tree_5042 0.8192
Cp_5042 tree_5042 0 2.592e-15
Rtr_504_5043 tree_504 tree_5043 0.8192
Cp_5043 tree_5043 0 2.592e-15
Rtr_504_5044 tree_504 tree_5044 0.8192
Cp_5044 tree_5044 0 2.592e-15
Rtr_504_5045 tree_504 tree_5045 0.8192
Cp_5045 tree_5045 0 2.592e-15
Rtr_504_5046 tree_504 tree_5046 0.8192
Cp_5046 tree_5046 0 2.592e-15
Rtr_504_5047 tree_504 tree_5047 0.8192
Cp_5047 tree_5047 0 2.592e-15
Rtr_504_5048 tree_504 tree_5048 0.8192
Cp_5048 tree_5048 0 2.592e-15
Rtr_504_5049 tree_504 tree_5049 0.8192
Cp_5049 tree_5049 0 2.592e-15
Rtr_504_5050 tree_504 tree_5050 0.8192
Cp_5050 tree_5050 0 2.592e-15
Rtr_505_5051 tree_505 tree_5051 0.8192
Cp_5051 tree_5051 0 2.592e-15
Rtr_505_5052 tree_505 tree_5052 0.8192
Cp_5052 tree_5052 0 2.592e-15
Rtr_505_5053 tree_505 tree_5053 0.8192
Cp_5053 tree_5053 0 2.592e-15
Rtr_505_5054 tree_505 tree_5054 0.8192
Cp_5054 tree_5054 0 2.592e-15
Rtr_505_5055 tree_505 tree_5055 0.8192
Cp_5055 tree_5055 0 2.592e-15
Rtr_505_5056 tree_505 tree_5056 0.8192
Cp_5056 tree_5056 0 2.592e-15
Rtr_505_5057 tree_505 tree_5057 0.8192
Cp_5057 tree_5057 0 2.592e-15
Rtr_505_5058 tree_505 tree_5058 0.8192
Cp_5058 tree_5058 0 2.592e-15
Rtr_505_5059 tree_505 tree_5059 0.8192
Cp_5059 tree_5059 0 2.592e-15
Rtr_505_5060 tree_505 tree_5060 0.8192
Cp_5060 tree_5060 0 2.592e-15
Rtr_506_5061 tree_506 tree_5061 0.8192
Cp_5061 tree_5061 0 2.592e-15
Rtr_506_5062 tree_506 tree_5062 0.8192
Cp_5062 tree_5062 0 2.592e-15
Rtr_506_5063 tree_506 tree_5063 0.8192
Cp_5063 tree_5063 0 2.592e-15
Rtr_506_5064 tree_506 tree_5064 0.8192
Cp_5064 tree_5064 0 2.592e-15
Rtr_506_5065 tree_506 tree_5065 0.8192
Cp_5065 tree_5065 0 2.592e-15
Rtr_506_5066 tree_506 tree_5066 0.8192
Cp_5066 tree_5066 0 2.592e-15
Rtr_506_5067 tree_506 tree_5067 0.8192
Cp_5067 tree_5067 0 2.592e-15
Rtr_506_5068 tree_506 tree_5068 0.8192
Cp_5068 tree_5068 0 2.592e-15
Rtr_506_5069 tree_506 tree_5069 0.8192
Cp_5069 tree_5069 0 2.592e-15
Rtr_506_5070 tree_506 tree_5070 0.8192
Cp_5070 tree_5070 0 2.592e-15
Rtr_507_5071 tree_507 tree_5071 0.8192
Cp_5071 tree_5071 0 2.592e-15
Rtr_507_5072 tree_507 tree_5072 0.8192
Cp_5072 tree_5072 0 2.592e-15
Rtr_507_5073 tree_507 tree_5073 0.8192
Cp_5073 tree_5073 0 2.592e-15
Rtr_507_5074 tree_507 tree_5074 0.8192
Cp_5074 tree_5074 0 2.592e-15
Rtr_507_5075 tree_507 tree_5075 0.8192
Cp_5075 tree_5075 0 2.592e-15
Rtr_507_5076 tree_507 tree_5076 0.8192
Cp_5076 tree_5076 0 2.592e-15
Rtr_507_5077 tree_507 tree_5077 0.8192
Cp_5077 tree_5077 0 2.592e-15
Rtr_507_5078 tree_507 tree_5078 0.8192
Cp_5078 tree_5078 0 2.592e-15
Rtr_507_5079 tree_507 tree_5079 0.8192
Cp_5079 tree_5079 0 2.592e-15
Rtr_507_5080 tree_507 tree_5080 0.8192
Cp_5080 tree_5080 0 2.592e-15
Rtr_508_5081 tree_508 tree_5081 0.8192
Cp_5081 tree_5081 0 2.592e-15
Rtr_508_5082 tree_508 tree_5082 0.8192
Cp_5082 tree_5082 0 2.592e-15
Rtr_508_5083 tree_508 tree_5083 0.8192
Cp_5083 tree_5083 0 2.592e-15
Rtr_508_5084 tree_508 tree_5084 0.8192
Cp_5084 tree_5084 0 2.592e-15
Rtr_508_5085 tree_508 tree_5085 0.8192
Cp_5085 tree_5085 0 2.592e-15
Rtr_508_5086 tree_508 tree_5086 0.8192
Cp_5086 tree_5086 0 2.592e-15
Rtr_508_5087 tree_508 tree_5087 0.8192
Cp_5087 tree_5087 0 2.592e-15
Rtr_508_5088 tree_508 tree_5088 0.8192
Cp_5088 tree_5088 0 2.592e-15
Rtr_508_5089 tree_508 tree_5089 0.8192
Cp_5089 tree_5089 0 2.592e-15
Rtr_508_5090 tree_508 tree_5090 0.8192
Cp_5090 tree_5090 0 2.592e-15
Rtr_509_5091 tree_509 tree_5091 0.8192
Cp_5091 tree_5091 0 2.592e-15
Rtr_509_5092 tree_509 tree_5092 0.8192
Cp_5092 tree_5092 0 2.592e-15
Rtr_509_5093 tree_509 tree_5093 0.8192
Cp_5093 tree_5093 0 2.592e-15
Rtr_509_5094 tree_509 tree_5094 0.8192
Cp_5094 tree_5094 0 2.592e-15
Rtr_509_5095 tree_509 tree_5095 0.8192
Cp_5095 tree_5095 0 2.592e-15
Rtr_509_5096 tree_509 tree_5096 0.8192
Cp_5096 tree_5096 0 2.592e-15
Rtr_509_5097 tree_509 tree_5097 0.8192
Cp_5097 tree_5097 0 2.592e-15
Rtr_509_5098 tree_509 tree_5098 0.8192
Cp_5098 tree_5098 0 2.592e-15
Rtr_509_5099 tree_509 tree_5099 0.8192
Cp_5099 tree_5099 0 2.592e-15
Rtr_509_5100 tree_509 tree_5100 0.8192
Cp_5100 tree_5100 0 2.592e-15
Rtr_510_5101 tree_510 tree_5101 0.8192
Cp_5101 tree_5101 0 2.592e-15
Rtr_510_5102 tree_510 tree_5102 0.8192
Cp_5102 tree_5102 0 2.592e-15
Rtr_510_5103 tree_510 tree_5103 0.8192
Cp_5103 tree_5103 0 2.592e-15
Rtr_510_5104 tree_510 tree_5104 0.8192
Cp_5104 tree_5104 0 2.592e-15
Rtr_510_5105 tree_510 tree_5105 0.8192
Cp_5105 tree_5105 0 2.592e-15
Rtr_510_5106 tree_510 tree_5106 0.8192
Cp_5106 tree_5106 0 2.592e-15
Rtr_510_5107 tree_510 tree_5107 0.8192
Cp_5107 tree_5107 0 2.592e-15
Rtr_510_5108 tree_510 tree_5108 0.8192
Cp_5108 tree_5108 0 2.592e-15
Rtr_510_5109 tree_510 tree_5109 0.8192
Cp_5109 tree_5109 0 2.592e-15
Rtr_510_5110 tree_510 tree_5110 0.8192
Cp_5110 tree_5110 0 2.592e-15
Rtr_511_5111 tree_511 tree_5111 0.8192
Cp_5111 tree_5111 0 2.592e-15
Rtr_511_5112 tree_511 tree_5112 0.8192
Cp_5112 tree_5112 0 2.592e-15
Rtr_511_5113 tree_511 tree_5113 0.8192
Cp_5113 tree_5113 0 2.592e-15
Rtr_511_5114 tree_511 tree_5114 0.8192
Cp_5114 tree_5114 0 2.592e-15
Rtr_511_5115 tree_511 tree_5115 0.8192
Cp_5115 tree_5115 0 2.592e-15
Rtr_511_5116 tree_511 tree_5116 0.8192
Cp_5116 tree_5116 0 2.592e-15
Rtr_511_5117 tree_511 tree_5117 0.8192
Cp_5117 tree_5117 0 2.592e-15
Rtr_511_5118 tree_511 tree_5118 0.8192
Cp_5118 tree_5118 0 2.592e-15
Rtr_511_5119 tree_511 tree_5119 0.8192
Cp_5119 tree_5119 0 2.592e-15
Rtr_511_5120 tree_511 tree_5120 0.8192
Cp_5120 tree_5120 0 2.592e-15
Rtr_512_5121 tree_512 tree_5121 0.8192
Cp_5121 tree_5121 0 2.592e-15
Rtr_512_5122 tree_512 tree_5122 0.8192
Cp_5122 tree_5122 0 2.592e-15
Rtr_512_5123 tree_512 tree_5123 0.8192
Cp_5123 tree_5123 0 2.592e-15
Rtr_512_5124 tree_512 tree_5124 0.8192
Cp_5124 tree_5124 0 2.592e-15
Rtr_512_5125 tree_512 tree_5125 0.8192
Cp_5125 tree_5125 0 2.592e-15
Rtr_512_5126 tree_512 tree_5126 0.8192
Cp_5126 tree_5126 0 2.592e-15
Rtr_512_5127 tree_512 tree_5127 0.8192
Cp_5127 tree_5127 0 2.592e-15
Rtr_512_5128 tree_512 tree_5128 0.8192
Cp_5128 tree_5128 0 2.592e-15
Rtr_512_5129 tree_512 tree_5129 0.8192
Cp_5129 tree_5129 0 2.592e-15
Rtr_512_5130 tree_512 tree_5130 0.8192
Cp_5130 tree_5130 0 2.592e-15
Rtr_513_5131 tree_513 tree_5131 0.8192
Cp_5131 tree_5131 0 2.592e-15
Rtr_513_5132 tree_513 tree_5132 0.8192
Cp_5132 tree_5132 0 2.592e-15
Rtr_513_5133 tree_513 tree_5133 0.8192
Cp_5133 tree_5133 0 2.592e-15
Rtr_513_5134 tree_513 tree_5134 0.8192
Cp_5134 tree_5134 0 2.592e-15
Rtr_513_5135 tree_513 tree_5135 0.8192
Cp_5135 tree_5135 0 2.592e-15
Rtr_513_5136 tree_513 tree_5136 0.8192
Cp_5136 tree_5136 0 2.592e-15
Rtr_513_5137 tree_513 tree_5137 0.8192
Cp_5137 tree_5137 0 2.592e-15
Rtr_513_5138 tree_513 tree_5138 0.8192
Cp_5138 tree_5138 0 2.592e-15
Rtr_513_5139 tree_513 tree_5139 0.8192
Cp_5139 tree_5139 0 2.592e-15
Rtr_513_5140 tree_513 tree_5140 0.8192
Cp_5140 tree_5140 0 2.592e-15
Rtr_514_5141 tree_514 tree_5141 0.8192
Cp_5141 tree_5141 0 2.592e-15
Rtr_514_5142 tree_514 tree_5142 0.8192
Cp_5142 tree_5142 0 2.592e-15
Rtr_514_5143 tree_514 tree_5143 0.8192
Cp_5143 tree_5143 0 2.592e-15
Rtr_514_5144 tree_514 tree_5144 0.8192
Cp_5144 tree_5144 0 2.592e-15
Rtr_514_5145 tree_514 tree_5145 0.8192
Cp_5145 tree_5145 0 2.592e-15
Rtr_514_5146 tree_514 tree_5146 0.8192
Cp_5146 tree_5146 0 2.592e-15
Rtr_514_5147 tree_514 tree_5147 0.8192
Cp_5147 tree_5147 0 2.592e-15
Rtr_514_5148 tree_514 tree_5148 0.8192
Cp_5148 tree_5148 0 2.592e-15
Rtr_514_5149 tree_514 tree_5149 0.8192
Cp_5149 tree_5149 0 2.592e-15
Rtr_514_5150 tree_514 tree_5150 0.8192
Cp_5150 tree_5150 0 2.592e-15
Rtr_515_5151 tree_515 tree_5151 0.8192
Cp_5151 tree_5151 0 2.592e-15
Rtr_515_5152 tree_515 tree_5152 0.8192
Cp_5152 tree_5152 0 2.592e-15
Rtr_515_5153 tree_515 tree_5153 0.8192
Cp_5153 tree_5153 0 2.592e-15
Rtr_515_5154 tree_515 tree_5154 0.8192
Cp_5154 tree_5154 0 2.592e-15
Rtr_515_5155 tree_515 tree_5155 0.8192
Cp_5155 tree_5155 0 2.592e-15
Rtr_515_5156 tree_515 tree_5156 0.8192
Cp_5156 tree_5156 0 2.592e-15
Rtr_515_5157 tree_515 tree_5157 0.8192
Cp_5157 tree_5157 0 2.592e-15
Rtr_515_5158 tree_515 tree_5158 0.8192
Cp_5158 tree_5158 0 2.592e-15
Rtr_515_5159 tree_515 tree_5159 0.8192
Cp_5159 tree_5159 0 2.592e-15
Rtr_515_5160 tree_515 tree_5160 0.8192
Cp_5160 tree_5160 0 2.592e-15
Rtr_516_5161 tree_516 tree_5161 0.8192
Cp_5161 tree_5161 0 2.592e-15
Rtr_516_5162 tree_516 tree_5162 0.8192
Cp_5162 tree_5162 0 2.592e-15
Rtr_516_5163 tree_516 tree_5163 0.8192
Cp_5163 tree_5163 0 2.592e-15
Rtr_516_5164 tree_516 tree_5164 0.8192
Cp_5164 tree_5164 0 2.592e-15
Rtr_516_5165 tree_516 tree_5165 0.8192
Cp_5165 tree_5165 0 2.592e-15
Rtr_516_5166 tree_516 tree_5166 0.8192
Cp_5166 tree_5166 0 2.592e-15
Rtr_516_5167 tree_516 tree_5167 0.8192
Cp_5167 tree_5167 0 2.592e-15
Rtr_516_5168 tree_516 tree_5168 0.8192
Cp_5168 tree_5168 0 2.592e-15
Rtr_516_5169 tree_516 tree_5169 0.8192
Cp_5169 tree_5169 0 2.592e-15
Rtr_516_5170 tree_516 tree_5170 0.8192
Cp_5170 tree_5170 0 2.592e-15
Rtr_517_5171 tree_517 tree_5171 0.8192
Cp_5171 tree_5171 0 2.592e-15
Rtr_517_5172 tree_517 tree_5172 0.8192
Cp_5172 tree_5172 0 2.592e-15
Rtr_517_5173 tree_517 tree_5173 0.8192
Cp_5173 tree_5173 0 2.592e-15
Rtr_517_5174 tree_517 tree_5174 0.8192
Cp_5174 tree_5174 0 2.592e-15
Rtr_517_5175 tree_517 tree_5175 0.8192
Cp_5175 tree_5175 0 2.592e-15
Rtr_517_5176 tree_517 tree_5176 0.8192
Cp_5176 tree_5176 0 2.592e-15
Rtr_517_5177 tree_517 tree_5177 0.8192
Cp_5177 tree_5177 0 2.592e-15
Rtr_517_5178 tree_517 tree_5178 0.8192
Cp_5178 tree_5178 0 2.592e-15
Rtr_517_5179 tree_517 tree_5179 0.8192
Cp_5179 tree_5179 0 2.592e-15
Rtr_517_5180 tree_517 tree_5180 0.8192
Cp_5180 tree_5180 0 2.592e-15
Rtr_518_5181 tree_518 tree_5181 0.8192
Cp_5181 tree_5181 0 2.592e-15
Rtr_518_5182 tree_518 tree_5182 0.8192
Cp_5182 tree_5182 0 2.592e-15
Rtr_518_5183 tree_518 tree_5183 0.8192
Cp_5183 tree_5183 0 2.592e-15
Rtr_518_5184 tree_518 tree_5184 0.8192
Cp_5184 tree_5184 0 2.592e-15
Rtr_518_5185 tree_518 tree_5185 0.8192
Cp_5185 tree_5185 0 2.592e-15
Rtr_518_5186 tree_518 tree_5186 0.8192
Cp_5186 tree_5186 0 2.592e-15
Rtr_518_5187 tree_518 tree_5187 0.8192
Cp_5187 tree_5187 0 2.592e-15
Rtr_518_5188 tree_518 tree_5188 0.8192
Cp_5188 tree_5188 0 2.592e-15
Rtr_518_5189 tree_518 tree_5189 0.8192
Cp_5189 tree_5189 0 2.592e-15
Rtr_518_5190 tree_518 tree_5190 0.8192
Cp_5190 tree_5190 0 2.592e-15
Rtr_519_5191 tree_519 tree_5191 0.8192
Cp_5191 tree_5191 0 2.592e-15
Rtr_519_5192 tree_519 tree_5192 0.8192
Cp_5192 tree_5192 0 2.592e-15
Rtr_519_5193 tree_519 tree_5193 0.8192
Cp_5193 tree_5193 0 2.592e-15
Rtr_519_5194 tree_519 tree_5194 0.8192
Cp_5194 tree_5194 0 2.592e-15
Rtr_519_5195 tree_519 tree_5195 0.8192
Cp_5195 tree_5195 0 2.592e-15
Rtr_519_5196 tree_519 tree_5196 0.8192
Cp_5196 tree_5196 0 2.592e-15
Rtr_519_5197 tree_519 tree_5197 0.8192
Cp_5197 tree_5197 0 2.592e-15
Rtr_519_5198 tree_519 tree_5198 0.8192
Cp_5198 tree_5198 0 2.592e-15
Rtr_519_5199 tree_519 tree_5199 0.8192
Cp_5199 tree_5199 0 2.592e-15
Rtr_519_5200 tree_519 tree_5200 0.8192
Cp_5200 tree_5200 0 2.592e-15
Rtr_520_5201 tree_520 tree_5201 0.8192
Cp_5201 tree_5201 0 2.592e-15
Rtr_520_5202 tree_520 tree_5202 0.8192
Cp_5202 tree_5202 0 2.592e-15
Rtr_520_5203 tree_520 tree_5203 0.8192
Cp_5203 tree_5203 0 2.592e-15
Rtr_520_5204 tree_520 tree_5204 0.8192
Cp_5204 tree_5204 0 2.592e-15
Rtr_520_5205 tree_520 tree_5205 0.8192
Cp_5205 tree_5205 0 2.592e-15
Rtr_520_5206 tree_520 tree_5206 0.8192
Cp_5206 tree_5206 0 2.592e-15
Rtr_520_5207 tree_520 tree_5207 0.8192
Cp_5207 tree_5207 0 2.592e-15
Rtr_520_5208 tree_520 tree_5208 0.8192
Cp_5208 tree_5208 0 2.592e-15
Rtr_520_5209 tree_520 tree_5209 0.8192
Cp_5209 tree_5209 0 2.592e-15
Rtr_520_5210 tree_520 tree_5210 0.8192
Cp_5210 tree_5210 0 2.592e-15
Rtr_521_5211 tree_521 tree_5211 0.8192
Cp_5211 tree_5211 0 2.592e-15
Rtr_521_5212 tree_521 tree_5212 0.8192
Cp_5212 tree_5212 0 2.592e-15
Rtr_521_5213 tree_521 tree_5213 0.8192
Cp_5213 tree_5213 0 2.592e-15
Rtr_521_5214 tree_521 tree_5214 0.8192
Cp_5214 tree_5214 0 2.592e-15
Rtr_521_5215 tree_521 tree_5215 0.8192
Cp_5215 tree_5215 0 2.592e-15
Rtr_521_5216 tree_521 tree_5216 0.8192
Cp_5216 tree_5216 0 2.592e-15
Rtr_521_5217 tree_521 tree_5217 0.8192
Cp_5217 tree_5217 0 2.592e-15
Rtr_521_5218 tree_521 tree_5218 0.8192
Cp_5218 tree_5218 0 2.592e-15
Rtr_521_5219 tree_521 tree_5219 0.8192
Cp_5219 tree_5219 0 2.592e-15
Rtr_521_5220 tree_521 tree_5220 0.8192
Cp_5220 tree_5220 0 2.592e-15
Rtr_522_5221 tree_522 tree_5221 0.8192
Cp_5221 tree_5221 0 2.592e-15
Rtr_522_5222 tree_522 tree_5222 0.8192
Cp_5222 tree_5222 0 2.592e-15
Rtr_522_5223 tree_522 tree_5223 0.8192
Cp_5223 tree_5223 0 2.592e-15
Rtr_522_5224 tree_522 tree_5224 0.8192
Cp_5224 tree_5224 0 2.592e-15
Rtr_522_5225 tree_522 tree_5225 0.8192
Cp_5225 tree_5225 0 2.592e-15
Rtr_522_5226 tree_522 tree_5226 0.8192
Cp_5226 tree_5226 0 2.592e-15
Rtr_522_5227 tree_522 tree_5227 0.8192
Cp_5227 tree_5227 0 2.592e-15
Rtr_522_5228 tree_522 tree_5228 0.8192
Cp_5228 tree_5228 0 2.592e-15
Rtr_522_5229 tree_522 tree_5229 0.8192
Cp_5229 tree_5229 0 2.592e-15
Rtr_522_5230 tree_522 tree_5230 0.8192
Cp_5230 tree_5230 0 2.592e-15
Rtr_523_5231 tree_523 tree_5231 0.8192
Cp_5231 tree_5231 0 2.592e-15
Rtr_523_5232 tree_523 tree_5232 0.8192
Cp_5232 tree_5232 0 2.592e-15
Rtr_523_5233 tree_523 tree_5233 0.8192
Cp_5233 tree_5233 0 2.592e-15
Rtr_523_5234 tree_523 tree_5234 0.8192
Cp_5234 tree_5234 0 2.592e-15
Rtr_523_5235 tree_523 tree_5235 0.8192
Cp_5235 tree_5235 0 2.592e-15
Rtr_523_5236 tree_523 tree_5236 0.8192
Cp_5236 tree_5236 0 2.592e-15
Rtr_523_5237 tree_523 tree_5237 0.8192
Cp_5237 tree_5237 0 2.592e-15
Rtr_523_5238 tree_523 tree_5238 0.8192
Cp_5238 tree_5238 0 2.592e-15
Rtr_523_5239 tree_523 tree_5239 0.8192
Cp_5239 tree_5239 0 2.592e-15
Rtr_523_5240 tree_523 tree_5240 0.8192
Cp_5240 tree_5240 0 2.592e-15
Rtr_524_5241 tree_524 tree_5241 0.8192
Cp_5241 tree_5241 0 2.592e-15
Rtr_524_5242 tree_524 tree_5242 0.8192
Cp_5242 tree_5242 0 2.592e-15
Rtr_524_5243 tree_524 tree_5243 0.8192
Cp_5243 tree_5243 0 2.592e-15
Rtr_524_5244 tree_524 tree_5244 0.8192
Cp_5244 tree_5244 0 2.592e-15
Rtr_524_5245 tree_524 tree_5245 0.8192
Cp_5245 tree_5245 0 2.592e-15
Rtr_524_5246 tree_524 tree_5246 0.8192
Cp_5246 tree_5246 0 2.592e-15
Rtr_524_5247 tree_524 tree_5247 0.8192
Cp_5247 tree_5247 0 2.592e-15
Rtr_524_5248 tree_524 tree_5248 0.8192
Cp_5248 tree_5248 0 2.592e-15
Rtr_524_5249 tree_524 tree_5249 0.8192
Cp_5249 tree_5249 0 2.592e-15
Rtr_524_5250 tree_524 tree_5250 0.8192
Cp_5250 tree_5250 0 2.592e-15
Rtr_525_5251 tree_525 tree_5251 0.8192
Cp_5251 tree_5251 0 2.592e-15
Rtr_525_5252 tree_525 tree_5252 0.8192
Cp_5252 tree_5252 0 2.592e-15
Rtr_525_5253 tree_525 tree_5253 0.8192
Cp_5253 tree_5253 0 2.592e-15
Rtr_525_5254 tree_525 tree_5254 0.8192
Cp_5254 tree_5254 0 2.592e-15
Rtr_525_5255 tree_525 tree_5255 0.8192
Cp_5255 tree_5255 0 2.592e-15
Rtr_525_5256 tree_525 tree_5256 0.8192
Cp_5256 tree_5256 0 2.592e-15
Rtr_525_5257 tree_525 tree_5257 0.8192
Cp_5257 tree_5257 0 2.592e-15
Rtr_525_5258 tree_525 tree_5258 0.8192
Cp_5258 tree_5258 0 2.592e-15
Rtr_525_5259 tree_525 tree_5259 0.8192
Cp_5259 tree_5259 0 2.592e-15
Rtr_525_5260 tree_525 tree_5260 0.8192
Cp_5260 tree_5260 0 2.592e-15
Rtr_526_5261 tree_526 tree_5261 0.8192
Cp_5261 tree_5261 0 2.592e-15
Rtr_526_5262 tree_526 tree_5262 0.8192
Cp_5262 tree_5262 0 2.592e-15
Rtr_526_5263 tree_526 tree_5263 0.8192
Cp_5263 tree_5263 0 2.592e-15
Rtr_526_5264 tree_526 tree_5264 0.8192
Cp_5264 tree_5264 0 2.592e-15
Rtr_526_5265 tree_526 tree_5265 0.8192
Cp_5265 tree_5265 0 2.592e-15
Rtr_526_5266 tree_526 tree_5266 0.8192
Cp_5266 tree_5266 0 2.592e-15
Rtr_526_5267 tree_526 tree_5267 0.8192
Cp_5267 tree_5267 0 2.592e-15
Rtr_526_5268 tree_526 tree_5268 0.8192
Cp_5268 tree_5268 0 2.592e-15
Rtr_526_5269 tree_526 tree_5269 0.8192
Cp_5269 tree_5269 0 2.592e-15
Rtr_526_5270 tree_526 tree_5270 0.8192
Cp_5270 tree_5270 0 2.592e-15
Rtr_527_5271 tree_527 tree_5271 0.8192
Cp_5271 tree_5271 0 2.592e-15
Rtr_527_5272 tree_527 tree_5272 0.8192
Cp_5272 tree_5272 0 2.592e-15
Rtr_527_5273 tree_527 tree_5273 0.8192
Cp_5273 tree_5273 0 2.592e-15
Rtr_527_5274 tree_527 tree_5274 0.8192
Cp_5274 tree_5274 0 2.592e-15
Rtr_527_5275 tree_527 tree_5275 0.8192
Cp_5275 tree_5275 0 2.592e-15
Rtr_527_5276 tree_527 tree_5276 0.8192
Cp_5276 tree_5276 0 2.592e-15
Rtr_527_5277 tree_527 tree_5277 0.8192
Cp_5277 tree_5277 0 2.592e-15
Rtr_527_5278 tree_527 tree_5278 0.8192
Cp_5278 tree_5278 0 2.592e-15
Rtr_527_5279 tree_527 tree_5279 0.8192
Cp_5279 tree_5279 0 2.592e-15
Rtr_527_5280 tree_527 tree_5280 0.8192
Cp_5280 tree_5280 0 2.592e-15
Rtr_528_5281 tree_528 tree_5281 0.8192
Cp_5281 tree_5281 0 2.592e-15
Rtr_528_5282 tree_528 tree_5282 0.8192
Cp_5282 tree_5282 0 2.592e-15
Rtr_528_5283 tree_528 tree_5283 0.8192
Cp_5283 tree_5283 0 2.592e-15
Rtr_528_5284 tree_528 tree_5284 0.8192
Cp_5284 tree_5284 0 2.592e-15
Rtr_528_5285 tree_528 tree_5285 0.8192
Cp_5285 tree_5285 0 2.592e-15
Rtr_528_5286 tree_528 tree_5286 0.8192
Cp_5286 tree_5286 0 2.592e-15
Rtr_528_5287 tree_528 tree_5287 0.8192
Cp_5287 tree_5287 0 2.592e-15
Rtr_528_5288 tree_528 tree_5288 0.8192
Cp_5288 tree_5288 0 2.592e-15
Rtr_528_5289 tree_528 tree_5289 0.8192
Cp_5289 tree_5289 0 2.592e-15
Rtr_528_5290 tree_528 tree_5290 0.8192
Cp_5290 tree_5290 0 2.592e-15
Rtr_529_5291 tree_529 tree_5291 0.8192
Cp_5291 tree_5291 0 2.592e-15
Rtr_529_5292 tree_529 tree_5292 0.8192
Cp_5292 tree_5292 0 2.592e-15
Rtr_529_5293 tree_529 tree_5293 0.8192
Cp_5293 tree_5293 0 2.592e-15
Rtr_529_5294 tree_529 tree_5294 0.8192
Cp_5294 tree_5294 0 2.592e-15
Rtr_529_5295 tree_529 tree_5295 0.8192
Cp_5295 tree_5295 0 2.592e-15
Rtr_529_5296 tree_529 tree_5296 0.8192
Cp_5296 tree_5296 0 2.592e-15
Rtr_529_5297 tree_529 tree_5297 0.8192
Cp_5297 tree_5297 0 2.592e-15
Rtr_529_5298 tree_529 tree_5298 0.8192
Cp_5298 tree_5298 0 2.592e-15
Rtr_529_5299 tree_529 tree_5299 0.8192
Cp_5299 tree_5299 0 2.592e-15
Rtr_529_5300 tree_529 tree_5300 0.8192
Cp_5300 tree_5300 0 2.592e-15
Rtr_530_5301 tree_530 tree_5301 0.8192
Cp_5301 tree_5301 0 2.592e-15
Rtr_530_5302 tree_530 tree_5302 0.8192
Cp_5302 tree_5302 0 2.592e-15
Rtr_530_5303 tree_530 tree_5303 0.8192
Cp_5303 tree_5303 0 2.592e-15
Rtr_530_5304 tree_530 tree_5304 0.8192
Cp_5304 tree_5304 0 2.592e-15
Rtr_530_5305 tree_530 tree_5305 0.8192
Cp_5305 tree_5305 0 2.592e-15
Rtr_530_5306 tree_530 tree_5306 0.8192
Cp_5306 tree_5306 0 2.592e-15
Rtr_530_5307 tree_530 tree_5307 0.8192
Cp_5307 tree_5307 0 2.592e-15
Rtr_530_5308 tree_530 tree_5308 0.8192
Cp_5308 tree_5308 0 2.592e-15
Rtr_530_5309 tree_530 tree_5309 0.8192
Cp_5309 tree_5309 0 2.592e-15
Rtr_530_5310 tree_530 tree_5310 0.8192
Cp_5310 tree_5310 0 2.592e-15
Rtr_531_5311 tree_531 tree_5311 0.8192
Cp_5311 tree_5311 0 2.592e-15
Rtr_531_5312 tree_531 tree_5312 0.8192
Cp_5312 tree_5312 0 2.592e-15
Rtr_531_5313 tree_531 tree_5313 0.8192
Cp_5313 tree_5313 0 2.592e-15
Rtr_531_5314 tree_531 tree_5314 0.8192
Cp_5314 tree_5314 0 2.592e-15
Rtr_531_5315 tree_531 tree_5315 0.8192
Cp_5315 tree_5315 0 2.592e-15
Rtr_531_5316 tree_531 tree_5316 0.8192
Cp_5316 tree_5316 0 2.592e-15
Rtr_531_5317 tree_531 tree_5317 0.8192
Cp_5317 tree_5317 0 2.592e-15
Rtr_531_5318 tree_531 tree_5318 0.8192
Cp_5318 tree_5318 0 2.592e-15
Rtr_531_5319 tree_531 tree_5319 0.8192
Cp_5319 tree_5319 0 2.592e-15
Rtr_531_5320 tree_531 tree_5320 0.8192
Cp_5320 tree_5320 0 2.592e-15
Rtr_532_5321 tree_532 tree_5321 0.8192
Cp_5321 tree_5321 0 2.592e-15
Rtr_532_5322 tree_532 tree_5322 0.8192
Cp_5322 tree_5322 0 2.592e-15
Rtr_532_5323 tree_532 tree_5323 0.8192
Cp_5323 tree_5323 0 2.592e-15
Rtr_532_5324 tree_532 tree_5324 0.8192
Cp_5324 tree_5324 0 2.592e-15
Rtr_532_5325 tree_532 tree_5325 0.8192
Cp_5325 tree_5325 0 2.592e-15
Rtr_532_5326 tree_532 tree_5326 0.8192
Cp_5326 tree_5326 0 2.592e-15
Rtr_532_5327 tree_532 tree_5327 0.8192
Cp_5327 tree_5327 0 2.592e-15
Rtr_532_5328 tree_532 tree_5328 0.8192
Cp_5328 tree_5328 0 2.592e-15
Rtr_532_5329 tree_532 tree_5329 0.8192
Cp_5329 tree_5329 0 2.592e-15
Rtr_532_5330 tree_532 tree_5330 0.8192
Cp_5330 tree_5330 0 2.592e-15
Rtr_533_5331 tree_533 tree_5331 0.8192
Cp_5331 tree_5331 0 2.592e-15
Rtr_533_5332 tree_533 tree_5332 0.8192
Cp_5332 tree_5332 0 2.592e-15
Rtr_533_5333 tree_533 tree_5333 0.8192
Cp_5333 tree_5333 0 2.592e-15
Rtr_533_5334 tree_533 tree_5334 0.8192
Cp_5334 tree_5334 0 2.592e-15
Rtr_533_5335 tree_533 tree_5335 0.8192
Cp_5335 tree_5335 0 2.592e-15
Rtr_533_5336 tree_533 tree_5336 0.8192
Cp_5336 tree_5336 0 2.592e-15
Rtr_533_5337 tree_533 tree_5337 0.8192
Cp_5337 tree_5337 0 2.592e-15
Rtr_533_5338 tree_533 tree_5338 0.8192
Cp_5338 tree_5338 0 2.592e-15
Rtr_533_5339 tree_533 tree_5339 0.8192
Cp_5339 tree_5339 0 2.592e-15
Rtr_533_5340 tree_533 tree_5340 0.8192
Cp_5340 tree_5340 0 2.592e-15
Rtr_534_5341 tree_534 tree_5341 0.8192
Cp_5341 tree_5341 0 2.592e-15
Rtr_534_5342 tree_534 tree_5342 0.8192
Cp_5342 tree_5342 0 2.592e-15
Rtr_534_5343 tree_534 tree_5343 0.8192
Cp_5343 tree_5343 0 2.592e-15
Rtr_534_5344 tree_534 tree_5344 0.8192
Cp_5344 tree_5344 0 2.592e-15
Rtr_534_5345 tree_534 tree_5345 0.8192
Cp_5345 tree_5345 0 2.592e-15
Rtr_534_5346 tree_534 tree_5346 0.8192
Cp_5346 tree_5346 0 2.592e-15
Rtr_534_5347 tree_534 tree_5347 0.8192
Cp_5347 tree_5347 0 2.592e-15
Rtr_534_5348 tree_534 tree_5348 0.8192
Cp_5348 tree_5348 0 2.592e-15
Rtr_534_5349 tree_534 tree_5349 0.8192
Cp_5349 tree_5349 0 2.592e-15
Rtr_534_5350 tree_534 tree_5350 0.8192
Cp_5350 tree_5350 0 2.592e-15
Rtr_535_5351 tree_535 tree_5351 0.8192
Cp_5351 tree_5351 0 2.592e-15
Rtr_535_5352 tree_535 tree_5352 0.8192
Cp_5352 tree_5352 0 2.592e-15
Rtr_535_5353 tree_535 tree_5353 0.8192
Cp_5353 tree_5353 0 2.592e-15
Rtr_535_5354 tree_535 tree_5354 0.8192
Cp_5354 tree_5354 0 2.592e-15
Rtr_535_5355 tree_535 tree_5355 0.8192
Cp_5355 tree_5355 0 2.592e-15
Rtr_535_5356 tree_535 tree_5356 0.8192
Cp_5356 tree_5356 0 2.592e-15
Rtr_535_5357 tree_535 tree_5357 0.8192
Cp_5357 tree_5357 0 2.592e-15
Rtr_535_5358 tree_535 tree_5358 0.8192
Cp_5358 tree_5358 0 2.592e-15
Rtr_535_5359 tree_535 tree_5359 0.8192
Cp_5359 tree_5359 0 2.592e-15
Rtr_535_5360 tree_535 tree_5360 0.8192
Cp_5360 tree_5360 0 2.592e-15
Rtr_536_5361 tree_536 tree_5361 0.8192
Cp_5361 tree_5361 0 2.592e-15
Rtr_536_5362 tree_536 tree_5362 0.8192
Cp_5362 tree_5362 0 2.592e-15
Rtr_536_5363 tree_536 tree_5363 0.8192
Cp_5363 tree_5363 0 2.592e-15
Rtr_536_5364 tree_536 tree_5364 0.8192
Cp_5364 tree_5364 0 2.592e-15
Rtr_536_5365 tree_536 tree_5365 0.8192
Cp_5365 tree_5365 0 2.592e-15
Rtr_536_5366 tree_536 tree_5366 0.8192
Cp_5366 tree_5366 0 2.592e-15
Rtr_536_5367 tree_536 tree_5367 0.8192
Cp_5367 tree_5367 0 2.592e-15
Rtr_536_5368 tree_536 tree_5368 0.8192
Cp_5368 tree_5368 0 2.592e-15
Rtr_536_5369 tree_536 tree_5369 0.8192
Cp_5369 tree_5369 0 2.592e-15
Rtr_536_5370 tree_536 tree_5370 0.8192
Cp_5370 tree_5370 0 2.592e-15
Rtr_537_5371 tree_537 tree_5371 0.8192
Cp_5371 tree_5371 0 2.592e-15
Rtr_537_5372 tree_537 tree_5372 0.8192
Cp_5372 tree_5372 0 2.592e-15
Rtr_537_5373 tree_537 tree_5373 0.8192
Cp_5373 tree_5373 0 2.592e-15
Rtr_537_5374 tree_537 tree_5374 0.8192
Cp_5374 tree_5374 0 2.592e-15
Rtr_537_5375 tree_537 tree_5375 0.8192
Cp_5375 tree_5375 0 2.592e-15
Rtr_537_5376 tree_537 tree_5376 0.8192
Cp_5376 tree_5376 0 2.592e-15
Rtr_537_5377 tree_537 tree_5377 0.8192
Cp_5377 tree_5377 0 2.592e-15
Rtr_537_5378 tree_537 tree_5378 0.8192
Cp_5378 tree_5378 0 2.592e-15
Rtr_537_5379 tree_537 tree_5379 0.8192
Cp_5379 tree_5379 0 2.592e-15
Rtr_537_5380 tree_537 tree_5380 0.8192
Cp_5380 tree_5380 0 2.592e-15
Rtr_538_5381 tree_538 tree_5381 0.8192
Cp_5381 tree_5381 0 2.592e-15
Rtr_538_5382 tree_538 tree_5382 0.8192
Cp_5382 tree_5382 0 2.592e-15
Rtr_538_5383 tree_538 tree_5383 0.8192
Cp_5383 tree_5383 0 2.592e-15
Rtr_538_5384 tree_538 tree_5384 0.8192
Cp_5384 tree_5384 0 2.592e-15
Rtr_538_5385 tree_538 tree_5385 0.8192
Cp_5385 tree_5385 0 2.592e-15
Rtr_538_5386 tree_538 tree_5386 0.8192
Cp_5386 tree_5386 0 2.592e-15
Rtr_538_5387 tree_538 tree_5387 0.8192
Cp_5387 tree_5387 0 2.592e-15
Rtr_538_5388 tree_538 tree_5388 0.8192
Cp_5388 tree_5388 0 2.592e-15
Rtr_538_5389 tree_538 tree_5389 0.8192
Cp_5389 tree_5389 0 2.592e-15
Rtr_538_5390 tree_538 tree_5390 0.8192
Cp_5390 tree_5390 0 2.592e-15
Rtr_539_5391 tree_539 tree_5391 0.8192
Cp_5391 tree_5391 0 2.592e-15
Rtr_539_5392 tree_539 tree_5392 0.8192
Cp_5392 tree_5392 0 2.592e-15
Rtr_539_5393 tree_539 tree_5393 0.8192
Cp_5393 tree_5393 0 2.592e-15
Rtr_539_5394 tree_539 tree_5394 0.8192
Cp_5394 tree_5394 0 2.592e-15
Rtr_539_5395 tree_539 tree_5395 0.8192
Cp_5395 tree_5395 0 2.592e-15
Rtr_539_5396 tree_539 tree_5396 0.8192
Cp_5396 tree_5396 0 2.592e-15
Rtr_539_5397 tree_539 tree_5397 0.8192
Cp_5397 tree_5397 0 2.592e-15
Rtr_539_5398 tree_539 tree_5398 0.8192
Cp_5398 tree_5398 0 2.592e-15
Rtr_539_5399 tree_539 tree_5399 0.8192
Cp_5399 tree_5399 0 2.592e-15
Rtr_539_5400 tree_539 tree_5400 0.8192
Cp_5400 tree_5400 0 2.592e-15
Rtr_540_5401 tree_540 tree_5401 0.8192
Cp_5401 tree_5401 0 2.592e-15
Rtr_540_5402 tree_540 tree_5402 0.8192
Cp_5402 tree_5402 0 2.592e-15
Rtr_540_5403 tree_540 tree_5403 0.8192
Cp_5403 tree_5403 0 2.592e-15
Rtr_540_5404 tree_540 tree_5404 0.8192
Cp_5404 tree_5404 0 2.592e-15
Rtr_540_5405 tree_540 tree_5405 0.8192
Cp_5405 tree_5405 0 2.592e-15
Rtr_540_5406 tree_540 tree_5406 0.8192
Cp_5406 tree_5406 0 2.592e-15
Rtr_540_5407 tree_540 tree_5407 0.8192
Cp_5407 tree_5407 0 2.592e-15
Rtr_540_5408 tree_540 tree_5408 0.8192
Cp_5408 tree_5408 0 2.592e-15
Rtr_540_5409 tree_540 tree_5409 0.8192
Cp_5409 tree_5409 0 2.592e-15
Rtr_540_5410 tree_540 tree_5410 0.8192
Cp_5410 tree_5410 0 2.592e-15
Rtr_541_5411 tree_541 tree_5411 0.8192
Cp_5411 tree_5411 0 2.592e-15
Rtr_541_5412 tree_541 tree_5412 0.8192
Cp_5412 tree_5412 0 2.592e-15
Rtr_541_5413 tree_541 tree_5413 0.8192
Cp_5413 tree_5413 0 2.592e-15
Rtr_541_5414 tree_541 tree_5414 0.8192
Cp_5414 tree_5414 0 2.592e-15
Rtr_541_5415 tree_541 tree_5415 0.8192
Cp_5415 tree_5415 0 2.592e-15
Rtr_541_5416 tree_541 tree_5416 0.8192
Cp_5416 tree_5416 0 2.592e-15
Rtr_541_5417 tree_541 tree_5417 0.8192
Cp_5417 tree_5417 0 2.592e-15
Rtr_541_5418 tree_541 tree_5418 0.8192
Cp_5418 tree_5418 0 2.592e-15
Rtr_541_5419 tree_541 tree_5419 0.8192
Cp_5419 tree_5419 0 2.592e-15
Rtr_541_5420 tree_541 tree_5420 0.8192
Cp_5420 tree_5420 0 2.592e-15
Rtr_542_5421 tree_542 tree_5421 0.8192
Cp_5421 tree_5421 0 2.592e-15
Rtr_542_5422 tree_542 tree_5422 0.8192
Cp_5422 tree_5422 0 2.592e-15
Rtr_542_5423 tree_542 tree_5423 0.8192
Cp_5423 tree_5423 0 2.592e-15
Rtr_542_5424 tree_542 tree_5424 0.8192
Cp_5424 tree_5424 0 2.592e-15
Rtr_542_5425 tree_542 tree_5425 0.8192
Cp_5425 tree_5425 0 2.592e-15
Rtr_542_5426 tree_542 tree_5426 0.8192
Cp_5426 tree_5426 0 2.592e-15
Rtr_542_5427 tree_542 tree_5427 0.8192
Cp_5427 tree_5427 0 2.592e-15
Rtr_542_5428 tree_542 tree_5428 0.8192
Cp_5428 tree_5428 0 2.592e-15
Rtr_542_5429 tree_542 tree_5429 0.8192
Cp_5429 tree_5429 0 2.592e-15
Rtr_542_5430 tree_542 tree_5430 0.8192
Cp_5430 tree_5430 0 2.592e-15
Rtr_543_5431 tree_543 tree_5431 0.8192
Cp_5431 tree_5431 0 2.592e-15
Rtr_543_5432 tree_543 tree_5432 0.8192
Cp_5432 tree_5432 0 2.592e-15
Rtr_543_5433 tree_543 tree_5433 0.8192
Cp_5433 tree_5433 0 2.592e-15
Rtr_543_5434 tree_543 tree_5434 0.8192
Cp_5434 tree_5434 0 2.592e-15
Rtr_543_5435 tree_543 tree_5435 0.8192
Cp_5435 tree_5435 0 2.592e-15
Rtr_543_5436 tree_543 tree_5436 0.8192
Cp_5436 tree_5436 0 2.592e-15
Rtr_543_5437 tree_543 tree_5437 0.8192
Cp_5437 tree_5437 0 2.592e-15
Rtr_543_5438 tree_543 tree_5438 0.8192
Cp_5438 tree_5438 0 2.592e-15
Rtr_543_5439 tree_543 tree_5439 0.8192
Cp_5439 tree_5439 0 2.592e-15
Rtr_543_5440 tree_543 tree_5440 0.8192
Cp_5440 tree_5440 0 2.592e-15
Rtr_544_5441 tree_544 tree_5441 0.8192
Cp_5441 tree_5441 0 2.592e-15
Rtr_544_5442 tree_544 tree_5442 0.8192
Cp_5442 tree_5442 0 2.592e-15
Rtr_544_5443 tree_544 tree_5443 0.8192
Cp_5443 tree_5443 0 2.592e-15
Rtr_544_5444 tree_544 tree_5444 0.8192
Cp_5444 tree_5444 0 2.592e-15
Rtr_544_5445 tree_544 tree_5445 0.8192
Cp_5445 tree_5445 0 2.592e-15
Rtr_544_5446 tree_544 tree_5446 0.8192
Cp_5446 tree_5446 0 2.592e-15
Rtr_544_5447 tree_544 tree_5447 0.8192
Cp_5447 tree_5447 0 2.592e-15
Rtr_544_5448 tree_544 tree_5448 0.8192
Cp_5448 tree_5448 0 2.592e-15
Rtr_544_5449 tree_544 tree_5449 0.8192
Cp_5449 tree_5449 0 2.592e-15
Rtr_544_5450 tree_544 tree_5450 0.8192
Cp_5450 tree_5450 0 2.592e-15
Rtr_545_5451 tree_545 tree_5451 0.8192
Cp_5451 tree_5451 0 2.592e-15
Rtr_545_5452 tree_545 tree_5452 0.8192
Cp_5452 tree_5452 0 2.592e-15
Rtr_545_5453 tree_545 tree_5453 0.8192
Cp_5453 tree_5453 0 2.592e-15
Rtr_545_5454 tree_545 tree_5454 0.8192
Cp_5454 tree_5454 0 2.592e-15
Rtr_545_5455 tree_545 tree_5455 0.8192
Cp_5455 tree_5455 0 2.592e-15
Rtr_545_5456 tree_545 tree_5456 0.8192
Cp_5456 tree_5456 0 2.592e-15
Rtr_545_5457 tree_545 tree_5457 0.8192
Cp_5457 tree_5457 0 2.592e-15
Rtr_545_5458 tree_545 tree_5458 0.8192
Cp_5458 tree_5458 0 2.592e-15
Rtr_545_5459 tree_545 tree_5459 0.8192
Cp_5459 tree_5459 0 2.592e-15
Rtr_545_5460 tree_545 tree_5460 0.8192
Cp_5460 tree_5460 0 2.592e-15
Rtr_546_5461 tree_546 tree_5461 0.8192
Cp_5461 tree_5461 0 2.592e-15
Rtr_546_5462 tree_546 tree_5462 0.8192
Cp_5462 tree_5462 0 2.592e-15
Rtr_546_5463 tree_546 tree_5463 0.8192
Cp_5463 tree_5463 0 2.592e-15
Rtr_546_5464 tree_546 tree_5464 0.8192
Cp_5464 tree_5464 0 2.592e-15
Rtr_546_5465 tree_546 tree_5465 0.8192
Cp_5465 tree_5465 0 2.592e-15
Rtr_546_5466 tree_546 tree_5466 0.8192
Cp_5466 tree_5466 0 2.592e-15
Rtr_546_5467 tree_546 tree_5467 0.8192
Cp_5467 tree_5467 0 2.592e-15
Rtr_546_5468 tree_546 tree_5468 0.8192
Cp_5468 tree_5468 0 2.592e-15
Rtr_546_5469 tree_546 tree_5469 0.8192
Cp_5469 tree_5469 0 2.592e-15
Rtr_546_5470 tree_546 tree_5470 0.8192
Cp_5470 tree_5470 0 2.592e-15
Rtr_547_5471 tree_547 tree_5471 0.8192
Cp_5471 tree_5471 0 2.592e-15
Rtr_547_5472 tree_547 tree_5472 0.8192
Cp_5472 tree_5472 0 2.592e-15
Rtr_547_5473 tree_547 tree_5473 0.8192
Cp_5473 tree_5473 0 2.592e-15
Rtr_547_5474 tree_547 tree_5474 0.8192
Cp_5474 tree_5474 0 2.592e-15
Rtr_547_5475 tree_547 tree_5475 0.8192
Cp_5475 tree_5475 0 2.592e-15
Rtr_547_5476 tree_547 tree_5476 0.8192
Cp_5476 tree_5476 0 2.592e-15
Rtr_547_5477 tree_547 tree_5477 0.8192
Cp_5477 tree_5477 0 2.592e-15
Rtr_547_5478 tree_547 tree_5478 0.8192
Cp_5478 tree_5478 0 2.592e-15
Rtr_547_5479 tree_547 tree_5479 0.8192
Cp_5479 tree_5479 0 2.592e-15
Rtr_547_5480 tree_547 tree_5480 0.8192
Cp_5480 tree_5480 0 2.592e-15
Rtr_548_5481 tree_548 tree_5481 0.8192
Cp_5481 tree_5481 0 2.592e-15
Rtr_548_5482 tree_548 tree_5482 0.8192
Cp_5482 tree_5482 0 2.592e-15
Rtr_548_5483 tree_548 tree_5483 0.8192
Cp_5483 tree_5483 0 2.592e-15
Rtr_548_5484 tree_548 tree_5484 0.8192
Cp_5484 tree_5484 0 2.592e-15
Rtr_548_5485 tree_548 tree_5485 0.8192
Cp_5485 tree_5485 0 2.592e-15
Rtr_548_5486 tree_548 tree_5486 0.8192
Cp_5486 tree_5486 0 2.592e-15
Rtr_548_5487 tree_548 tree_5487 0.8192
Cp_5487 tree_5487 0 2.592e-15
Rtr_548_5488 tree_548 tree_5488 0.8192
Cp_5488 tree_5488 0 2.592e-15
Rtr_548_5489 tree_548 tree_5489 0.8192
Cp_5489 tree_5489 0 2.592e-15
Rtr_548_5490 tree_548 tree_5490 0.8192
Cp_5490 tree_5490 0 2.592e-15
Rtr_549_5491 tree_549 tree_5491 0.8192
Cp_5491 tree_5491 0 2.592e-15
Rtr_549_5492 tree_549 tree_5492 0.8192
Cp_5492 tree_5492 0 2.592e-15
Rtr_549_5493 tree_549 tree_5493 0.8192
Cp_5493 tree_5493 0 2.592e-15
Rtr_549_5494 tree_549 tree_5494 0.8192
Cp_5494 tree_5494 0 2.592e-15
Rtr_549_5495 tree_549 tree_5495 0.8192
Cp_5495 tree_5495 0 2.592e-15
Rtr_549_5496 tree_549 tree_5496 0.8192
Cp_5496 tree_5496 0 2.592e-15
Rtr_549_5497 tree_549 tree_5497 0.8192
Cp_5497 tree_5497 0 2.592e-15
Rtr_549_5498 tree_549 tree_5498 0.8192
Cp_5498 tree_5498 0 2.592e-15
Rtr_549_5499 tree_549 tree_5499 0.8192
Cp_5499 tree_5499 0 2.592e-15
Rtr_549_5500 tree_549 tree_5500 0.8192
Cp_5500 tree_5500 0 2.592e-15
Rtr_550_5501 tree_550 tree_5501 0.8192
Cp_5501 tree_5501 0 2.592e-15
Rtr_550_5502 tree_550 tree_5502 0.8192
Cp_5502 tree_5502 0 2.592e-15
Rtr_550_5503 tree_550 tree_5503 0.8192
Cp_5503 tree_5503 0 2.592e-15
Rtr_550_5504 tree_550 tree_5504 0.8192
Cp_5504 tree_5504 0 2.592e-15
Rtr_550_5505 tree_550 tree_5505 0.8192
Cp_5505 tree_5505 0 2.592e-15
Rtr_550_5506 tree_550 tree_5506 0.8192
Cp_5506 tree_5506 0 2.592e-15
Rtr_550_5507 tree_550 tree_5507 0.8192
Cp_5507 tree_5507 0 2.592e-15
Rtr_550_5508 tree_550 tree_5508 0.8192
Cp_5508 tree_5508 0 2.592e-15
Rtr_550_5509 tree_550 tree_5509 0.8192
Cp_5509 tree_5509 0 2.592e-15
Rtr_550_5510 tree_550 tree_5510 0.8192
Cp_5510 tree_5510 0 2.592e-15
Rtr_551_5511 tree_551 tree_5511 0.8192
Cp_5511 tree_5511 0 2.592e-15
Rtr_551_5512 tree_551 tree_5512 0.8192
Cp_5512 tree_5512 0 2.592e-15
Rtr_551_5513 tree_551 tree_5513 0.8192
Cp_5513 tree_5513 0 2.592e-15
Rtr_551_5514 tree_551 tree_5514 0.8192
Cp_5514 tree_5514 0 2.592e-15
Rtr_551_5515 tree_551 tree_5515 0.8192
Cp_5515 tree_5515 0 2.592e-15
Rtr_551_5516 tree_551 tree_5516 0.8192
Cp_5516 tree_5516 0 2.592e-15
Rtr_551_5517 tree_551 tree_5517 0.8192
Cp_5517 tree_5517 0 2.592e-15
Rtr_551_5518 tree_551 tree_5518 0.8192
Cp_5518 tree_5518 0 2.592e-15
Rtr_551_5519 tree_551 tree_5519 0.8192
Cp_5519 tree_5519 0 2.592e-15
Rtr_551_5520 tree_551 tree_5520 0.8192
Cp_5520 tree_5520 0 2.592e-15
Rtr_552_5521 tree_552 tree_5521 0.8192
Cp_5521 tree_5521 0 2.592e-15
Rtr_552_5522 tree_552 tree_5522 0.8192
Cp_5522 tree_5522 0 2.592e-15
Rtr_552_5523 tree_552 tree_5523 0.8192
Cp_5523 tree_5523 0 2.592e-15
Rtr_552_5524 tree_552 tree_5524 0.8192
Cp_5524 tree_5524 0 2.592e-15
Rtr_552_5525 tree_552 tree_5525 0.8192
Cp_5525 tree_5525 0 2.592e-15
Rtr_552_5526 tree_552 tree_5526 0.8192
Cp_5526 tree_5526 0 2.592e-15
Rtr_552_5527 tree_552 tree_5527 0.8192
Cp_5527 tree_5527 0 2.592e-15
Rtr_552_5528 tree_552 tree_5528 0.8192
Cp_5528 tree_5528 0 2.592e-15
Rtr_552_5529 tree_552 tree_5529 0.8192
Cp_5529 tree_5529 0 2.592e-15
Rtr_552_5530 tree_552 tree_5530 0.8192
Cp_5530 tree_5530 0 2.592e-15
Rtr_553_5531 tree_553 tree_5531 0.8192
Cp_5531 tree_5531 0 2.592e-15
Rtr_553_5532 tree_553 tree_5532 0.8192
Cp_5532 tree_5532 0 2.592e-15
Rtr_553_5533 tree_553 tree_5533 0.8192
Cp_5533 tree_5533 0 2.592e-15
Rtr_553_5534 tree_553 tree_5534 0.8192
Cp_5534 tree_5534 0 2.592e-15
Rtr_553_5535 tree_553 tree_5535 0.8192
Cp_5535 tree_5535 0 2.592e-15
Rtr_553_5536 tree_553 tree_5536 0.8192
Cp_5536 tree_5536 0 2.592e-15
Rtr_553_5537 tree_553 tree_5537 0.8192
Cp_5537 tree_5537 0 2.592e-15
Rtr_553_5538 tree_553 tree_5538 0.8192
Cp_5538 tree_5538 0 2.592e-15
Rtr_553_5539 tree_553 tree_5539 0.8192
Cp_5539 tree_5539 0 2.592e-15
Rtr_553_5540 tree_553 tree_5540 0.8192
Cp_5540 tree_5540 0 2.592e-15
Rtr_554_5541 tree_554 tree_5541 0.8192
Cp_5541 tree_5541 0 2.592e-15
Rtr_554_5542 tree_554 tree_5542 0.8192
Cp_5542 tree_5542 0 2.592e-15
Rtr_554_5543 tree_554 tree_5543 0.8192
Cp_5543 tree_5543 0 2.592e-15
Rtr_554_5544 tree_554 tree_5544 0.8192
Cp_5544 tree_5544 0 2.592e-15
Rtr_554_5545 tree_554 tree_5545 0.8192
Cp_5545 tree_5545 0 2.592e-15
Rtr_554_5546 tree_554 tree_5546 0.8192
Cp_5546 tree_5546 0 2.592e-15
Rtr_554_5547 tree_554 tree_5547 0.8192
Cp_5547 tree_5547 0 2.592e-15
Rtr_554_5548 tree_554 tree_5548 0.8192
Cp_5548 tree_5548 0 2.592e-15
Rtr_554_5549 tree_554 tree_5549 0.8192
Cp_5549 tree_5549 0 2.592e-15
Rtr_554_5550 tree_554 tree_5550 0.8192
Cp_5550 tree_5550 0 2.592e-15
Rtr_555_5551 tree_555 tree_5551 0.8192
Cp_5551 tree_5551 0 2.592e-15
Rtr_555_5552 tree_555 tree_5552 0.8192
Cp_5552 tree_5552 0 2.592e-15
Rtr_555_5553 tree_555 tree_5553 0.8192
Cp_5553 tree_5553 0 2.592e-15
Rtr_555_5554 tree_555 tree_5554 0.8192
Cp_5554 tree_5554 0 2.592e-15
Rtr_555_5555 tree_555 tree_5555 0.8192
Cp_5555 tree_5555 0 2.592e-15
Rtr_555_5556 tree_555 tree_5556 0.8192
Cp_5556 tree_5556 0 2.592e-15
Rtr_555_5557 tree_555 tree_5557 0.8192
Cp_5557 tree_5557 0 2.592e-15
Rtr_555_5558 tree_555 tree_5558 0.8192
Cp_5558 tree_5558 0 2.592e-15
Rtr_555_5559 tree_555 tree_5559 0.8192
Cp_5559 tree_5559 0 2.592e-15
Rtr_555_5560 tree_555 tree_5560 0.8192
Cp_5560 tree_5560 0 2.592e-15
Rtr_556_5561 tree_556 tree_5561 0.8192
Cp_5561 tree_5561 0 2.592e-15
Rtr_556_5562 tree_556 tree_5562 0.8192
Cp_5562 tree_5562 0 2.592e-15
Rtr_556_5563 tree_556 tree_5563 0.8192
Cp_5563 tree_5563 0 2.592e-15
Rtr_556_5564 tree_556 tree_5564 0.8192
Cp_5564 tree_5564 0 2.592e-15
Rtr_556_5565 tree_556 tree_5565 0.8192
Cp_5565 tree_5565 0 2.592e-15
Rtr_556_5566 tree_556 tree_5566 0.8192
Cp_5566 tree_5566 0 2.592e-15
Rtr_556_5567 tree_556 tree_5567 0.8192
Cp_5567 tree_5567 0 2.592e-15
Rtr_556_5568 tree_556 tree_5568 0.8192
Cp_5568 tree_5568 0 2.592e-15
Rtr_556_5569 tree_556 tree_5569 0.8192
Cp_5569 tree_5569 0 2.592e-15
Rtr_556_5570 tree_556 tree_5570 0.8192
Cp_5570 tree_5570 0 2.592e-15
Rtr_557_5571 tree_557 tree_5571 0.8192
Cp_5571 tree_5571 0 2.592e-15
Rtr_557_5572 tree_557 tree_5572 0.8192
Cp_5572 tree_5572 0 2.592e-15
Rtr_557_5573 tree_557 tree_5573 0.8192
Cp_5573 tree_5573 0 2.592e-15
Rtr_557_5574 tree_557 tree_5574 0.8192
Cp_5574 tree_5574 0 2.592e-15
Rtr_557_5575 tree_557 tree_5575 0.8192
Cp_5575 tree_5575 0 2.592e-15
Rtr_557_5576 tree_557 tree_5576 0.8192
Cp_5576 tree_5576 0 2.592e-15
Rtr_557_5577 tree_557 tree_5577 0.8192
Cp_5577 tree_5577 0 2.592e-15
Rtr_557_5578 tree_557 tree_5578 0.8192
Cp_5578 tree_5578 0 2.592e-15
Rtr_557_5579 tree_557 tree_5579 0.8192
Cp_5579 tree_5579 0 2.592e-15
Rtr_557_5580 tree_557 tree_5580 0.8192
Cp_5580 tree_5580 0 2.592e-15
Rtr_558_5581 tree_558 tree_5581 0.8192
Cp_5581 tree_5581 0 2.592e-15
Rtr_558_5582 tree_558 tree_5582 0.8192
Cp_5582 tree_5582 0 2.592e-15
Rtr_558_5583 tree_558 tree_5583 0.8192
Cp_5583 tree_5583 0 2.592e-15
Rtr_558_5584 tree_558 tree_5584 0.8192
Cp_5584 tree_5584 0 2.592e-15
Rtr_558_5585 tree_558 tree_5585 0.8192
Cp_5585 tree_5585 0 2.592e-15
Rtr_558_5586 tree_558 tree_5586 0.8192
Cp_5586 tree_5586 0 2.592e-15
Rtr_558_5587 tree_558 tree_5587 0.8192
Cp_5587 tree_5587 0 2.592e-15
Rtr_558_5588 tree_558 tree_5588 0.8192
Cp_5588 tree_5588 0 2.592e-15
Rtr_558_5589 tree_558 tree_5589 0.8192
Cp_5589 tree_5589 0 2.592e-15
Rtr_558_5590 tree_558 tree_5590 0.8192
Cp_5590 tree_5590 0 2.592e-15
Rtr_559_5591 tree_559 tree_5591 0.8192
Cp_5591 tree_5591 0 2.592e-15
Rtr_559_5592 tree_559 tree_5592 0.8192
Cp_5592 tree_5592 0 2.592e-15
Rtr_559_5593 tree_559 tree_5593 0.8192
Cp_5593 tree_5593 0 2.592e-15
Rtr_559_5594 tree_559 tree_5594 0.8192
Cp_5594 tree_5594 0 2.592e-15
Rtr_559_5595 tree_559 tree_5595 0.8192
Cp_5595 tree_5595 0 2.592e-15
Rtr_559_5596 tree_559 tree_5596 0.8192
Cp_5596 tree_5596 0 2.592e-15
Rtr_559_5597 tree_559 tree_5597 0.8192
Cp_5597 tree_5597 0 2.592e-15
Rtr_559_5598 tree_559 tree_5598 0.8192
Cp_5598 tree_5598 0 2.592e-15
Rtr_559_5599 tree_559 tree_5599 0.8192
Cp_5599 tree_5599 0 2.592e-15
Rtr_559_5600 tree_559 tree_5600 0.8192
Cp_5600 tree_5600 0 2.592e-15
Rtr_560_5601 tree_560 tree_5601 0.8192
Cp_5601 tree_5601 0 2.592e-15
Rtr_560_5602 tree_560 tree_5602 0.8192
Cp_5602 tree_5602 0 2.592e-15
Rtr_560_5603 tree_560 tree_5603 0.8192
Cp_5603 tree_5603 0 2.592e-15
Rtr_560_5604 tree_560 tree_5604 0.8192
Cp_5604 tree_5604 0 2.592e-15
Rtr_560_5605 tree_560 tree_5605 0.8192
Cp_5605 tree_5605 0 2.592e-15
Rtr_560_5606 tree_560 tree_5606 0.8192
Cp_5606 tree_5606 0 2.592e-15
Rtr_560_5607 tree_560 tree_5607 0.8192
Cp_5607 tree_5607 0 2.592e-15
Rtr_560_5608 tree_560 tree_5608 0.8192
Cp_5608 tree_5608 0 2.592e-15
Rtr_560_5609 tree_560 tree_5609 0.8192
Cp_5609 tree_5609 0 2.592e-15
Rtr_560_5610 tree_560 tree_5610 0.8192
Cp_5610 tree_5610 0 2.592e-15
Rtr_561_5611 tree_561 tree_5611 0.8192
Cp_5611 tree_5611 0 2.592e-15
Rtr_561_5612 tree_561 tree_5612 0.8192
Cp_5612 tree_5612 0 2.592e-15
Rtr_561_5613 tree_561 tree_5613 0.8192
Cp_5613 tree_5613 0 2.592e-15
Rtr_561_5614 tree_561 tree_5614 0.8192
Cp_5614 tree_5614 0 2.592e-15
Rtr_561_5615 tree_561 tree_5615 0.8192
Cp_5615 tree_5615 0 2.592e-15
Rtr_561_5616 tree_561 tree_5616 0.8192
Cp_5616 tree_5616 0 2.592e-15
Rtr_561_5617 tree_561 tree_5617 0.8192
Cp_5617 tree_5617 0 2.592e-15
Rtr_561_5618 tree_561 tree_5618 0.8192
Cp_5618 tree_5618 0 2.592e-15
Rtr_561_5619 tree_561 tree_5619 0.8192
Cp_5619 tree_5619 0 2.592e-15
Rtr_561_5620 tree_561 tree_5620 0.8192
Cp_5620 tree_5620 0 2.592e-15
Rtr_562_5621 tree_562 tree_5621 0.8192
Cp_5621 tree_5621 0 2.592e-15
Rtr_562_5622 tree_562 tree_5622 0.8192
Cp_5622 tree_5622 0 2.592e-15
Rtr_562_5623 tree_562 tree_5623 0.8192
Cp_5623 tree_5623 0 2.592e-15
Rtr_562_5624 tree_562 tree_5624 0.8192
Cp_5624 tree_5624 0 2.592e-15
Rtr_562_5625 tree_562 tree_5625 0.8192
Cp_5625 tree_5625 0 2.592e-15
Rtr_562_5626 tree_562 tree_5626 0.8192
Cp_5626 tree_5626 0 2.592e-15
Rtr_562_5627 tree_562 tree_5627 0.8192
Cp_5627 tree_5627 0 2.592e-15
Rtr_562_5628 tree_562 tree_5628 0.8192
Cp_5628 tree_5628 0 2.592e-15
Rtr_562_5629 tree_562 tree_5629 0.8192
Cp_5629 tree_5629 0 2.592e-15
Rtr_562_5630 tree_562 tree_5630 0.8192
Cp_5630 tree_5630 0 2.592e-15
Rtr_563_5631 tree_563 tree_5631 0.8192
Cp_5631 tree_5631 0 2.592e-15
Rtr_563_5632 tree_563 tree_5632 0.8192
Cp_5632 tree_5632 0 2.592e-15
Rtr_563_5633 tree_563 tree_5633 0.8192
Cp_5633 tree_5633 0 2.592e-15
Rtr_563_5634 tree_563 tree_5634 0.8192
Cp_5634 tree_5634 0 2.592e-15
Rtr_563_5635 tree_563 tree_5635 0.8192
Cp_5635 tree_5635 0 2.592e-15
Rtr_563_5636 tree_563 tree_5636 0.8192
Cp_5636 tree_5636 0 2.592e-15
Rtr_563_5637 tree_563 tree_5637 0.8192
Cp_5637 tree_5637 0 2.592e-15
Rtr_563_5638 tree_563 tree_5638 0.8192
Cp_5638 tree_5638 0 2.592e-15
Rtr_563_5639 tree_563 tree_5639 0.8192
Cp_5639 tree_5639 0 2.592e-15
Rtr_563_5640 tree_563 tree_5640 0.8192
Cp_5640 tree_5640 0 2.592e-15
Rtr_564_5641 tree_564 tree_5641 0.8192
Cp_5641 tree_5641 0 2.592e-15
Rtr_564_5642 tree_564 tree_5642 0.8192
Cp_5642 tree_5642 0 2.592e-15
Rtr_564_5643 tree_564 tree_5643 0.8192
Cp_5643 tree_5643 0 2.592e-15
Rtr_564_5644 tree_564 tree_5644 0.8192
Cp_5644 tree_5644 0 2.592e-15
Rtr_564_5645 tree_564 tree_5645 0.8192
Cp_5645 tree_5645 0 2.592e-15
Rtr_564_5646 tree_564 tree_5646 0.8192
Cp_5646 tree_5646 0 2.592e-15
Rtr_564_5647 tree_564 tree_5647 0.8192
Cp_5647 tree_5647 0 2.592e-15
Rtr_564_5648 tree_564 tree_5648 0.8192
Cp_5648 tree_5648 0 2.592e-15
Rtr_564_5649 tree_564 tree_5649 0.8192
Cp_5649 tree_5649 0 2.592e-15
Rtr_564_5650 tree_564 tree_5650 0.8192
Cp_5650 tree_5650 0 2.592e-15
Rtr_565_5651 tree_565 tree_5651 0.8192
Cp_5651 tree_5651 0 2.592e-15
Rtr_565_5652 tree_565 tree_5652 0.8192
Cp_5652 tree_5652 0 2.592e-15
Rtr_565_5653 tree_565 tree_5653 0.8192
Cp_5653 tree_5653 0 2.592e-15
Rtr_565_5654 tree_565 tree_5654 0.8192
Cp_5654 tree_5654 0 2.592e-15
Rtr_565_5655 tree_565 tree_5655 0.8192
Cp_5655 tree_5655 0 2.592e-15
Rtr_565_5656 tree_565 tree_5656 0.8192
Cp_5656 tree_5656 0 2.592e-15
Rtr_565_5657 tree_565 tree_5657 0.8192
Cp_5657 tree_5657 0 2.592e-15
Rtr_565_5658 tree_565 tree_5658 0.8192
Cp_5658 tree_5658 0 2.592e-15
Rtr_565_5659 tree_565 tree_5659 0.8192
Cp_5659 tree_5659 0 2.592e-15
Rtr_565_5660 tree_565 tree_5660 0.8192
Cp_5660 tree_5660 0 2.592e-15
Rtr_566_5661 tree_566 tree_5661 0.8192
Cp_5661 tree_5661 0 2.592e-15
Rtr_566_5662 tree_566 tree_5662 0.8192
Cp_5662 tree_5662 0 2.592e-15
Rtr_566_5663 tree_566 tree_5663 0.8192
Cp_5663 tree_5663 0 2.592e-15
Rtr_566_5664 tree_566 tree_5664 0.8192
Cp_5664 tree_5664 0 2.592e-15
Rtr_566_5665 tree_566 tree_5665 0.8192
Cp_5665 tree_5665 0 2.592e-15
Rtr_566_5666 tree_566 tree_5666 0.8192
Cp_5666 tree_5666 0 2.592e-15
Rtr_566_5667 tree_566 tree_5667 0.8192
Cp_5667 tree_5667 0 2.592e-15
Rtr_566_5668 tree_566 tree_5668 0.8192
Cp_5668 tree_5668 0 2.592e-15
Rtr_566_5669 tree_566 tree_5669 0.8192
Cp_5669 tree_5669 0 2.592e-15
Rtr_566_5670 tree_566 tree_5670 0.8192
Cp_5670 tree_5670 0 2.592e-15
Rtr_567_5671 tree_567 tree_5671 0.8192
Cp_5671 tree_5671 0 2.592e-15
Rtr_567_5672 tree_567 tree_5672 0.8192
Cp_5672 tree_5672 0 2.592e-15
Rtr_567_5673 tree_567 tree_5673 0.8192
Cp_5673 tree_5673 0 2.592e-15
Rtr_567_5674 tree_567 tree_5674 0.8192
Cp_5674 tree_5674 0 2.592e-15
Rtr_567_5675 tree_567 tree_5675 0.8192
Cp_5675 tree_5675 0 2.592e-15
Rtr_567_5676 tree_567 tree_5676 0.8192
Cp_5676 tree_5676 0 2.592e-15
Rtr_567_5677 tree_567 tree_5677 0.8192
Cp_5677 tree_5677 0 2.592e-15
Rtr_567_5678 tree_567 tree_5678 0.8192
Cp_5678 tree_5678 0 2.592e-15
Rtr_567_5679 tree_567 tree_5679 0.8192
Cp_5679 tree_5679 0 2.592e-15
Rtr_567_5680 tree_567 tree_5680 0.8192
Cp_5680 tree_5680 0 2.592e-15
Rtr_568_5681 tree_568 tree_5681 0.8192
Cp_5681 tree_5681 0 2.592e-15
Rtr_568_5682 tree_568 tree_5682 0.8192
Cp_5682 tree_5682 0 2.592e-15
Rtr_568_5683 tree_568 tree_5683 0.8192
Cp_5683 tree_5683 0 2.592e-15
Rtr_568_5684 tree_568 tree_5684 0.8192
Cp_5684 tree_5684 0 2.592e-15
Rtr_568_5685 tree_568 tree_5685 0.8192
Cp_5685 tree_5685 0 2.592e-15
Rtr_568_5686 tree_568 tree_5686 0.8192
Cp_5686 tree_5686 0 2.592e-15
Rtr_568_5687 tree_568 tree_5687 0.8192
Cp_5687 tree_5687 0 2.592e-15
Rtr_568_5688 tree_568 tree_5688 0.8192
Cp_5688 tree_5688 0 2.592e-15
Rtr_568_5689 tree_568 tree_5689 0.8192
Cp_5689 tree_5689 0 2.592e-15
Rtr_568_5690 tree_568 tree_5690 0.8192
Cp_5690 tree_5690 0 2.592e-15
Rtr_569_5691 tree_569 tree_5691 0.8192
Cp_5691 tree_5691 0 2.592e-15
Rtr_569_5692 tree_569 tree_5692 0.8192
Cp_5692 tree_5692 0 2.592e-15
Rtr_569_5693 tree_569 tree_5693 0.8192
Cp_5693 tree_5693 0 2.592e-15
Rtr_569_5694 tree_569 tree_5694 0.8192
Cp_5694 tree_5694 0 2.592e-15
Rtr_569_5695 tree_569 tree_5695 0.8192
Cp_5695 tree_5695 0 2.592e-15
Rtr_569_5696 tree_569 tree_5696 0.8192
Cp_5696 tree_5696 0 2.592e-15
Rtr_569_5697 tree_569 tree_5697 0.8192
Cp_5697 tree_5697 0 2.592e-15
Rtr_569_5698 tree_569 tree_5698 0.8192
Cp_5698 tree_5698 0 2.592e-15
Rtr_569_5699 tree_569 tree_5699 0.8192
Cp_5699 tree_5699 0 2.592e-15
Rtr_569_5700 tree_569 tree_5700 0.8192
Cp_5700 tree_5700 0 2.592e-15
Rtr_570_5701 tree_570 tree_5701 0.8192
Cp_5701 tree_5701 0 2.592e-15
Rtr_570_5702 tree_570 tree_5702 0.8192
Cp_5702 tree_5702 0 2.592e-15
Rtr_570_5703 tree_570 tree_5703 0.8192
Cp_5703 tree_5703 0 2.592e-15
Rtr_570_5704 tree_570 tree_5704 0.8192
Cp_5704 tree_5704 0 2.592e-15
Rtr_570_5705 tree_570 tree_5705 0.8192
Cp_5705 tree_5705 0 2.592e-15
Rtr_570_5706 tree_570 tree_5706 0.8192
Cp_5706 tree_5706 0 2.592e-15
Rtr_570_5707 tree_570 tree_5707 0.8192
Cp_5707 tree_5707 0 2.592e-15
Rtr_570_5708 tree_570 tree_5708 0.8192
Cp_5708 tree_5708 0 2.592e-15
Rtr_570_5709 tree_570 tree_5709 0.8192
Cp_5709 tree_5709 0 2.592e-15
Rtr_570_5710 tree_570 tree_5710 0.8192
Cp_5710 tree_5710 0 2.592e-15
Rtr_571_5711 tree_571 tree_5711 0.8192
Cp_5711 tree_5711 0 2.592e-15
Rtr_571_5712 tree_571 tree_5712 0.8192
Cp_5712 tree_5712 0 2.592e-15
Rtr_571_5713 tree_571 tree_5713 0.8192
Cp_5713 tree_5713 0 2.592e-15
Rtr_571_5714 tree_571 tree_5714 0.8192
Cp_5714 tree_5714 0 2.592e-15
Rtr_571_5715 tree_571 tree_5715 0.8192
Cp_5715 tree_5715 0 2.592e-15
Rtr_571_5716 tree_571 tree_5716 0.8192
Cp_5716 tree_5716 0 2.592e-15
Rtr_571_5717 tree_571 tree_5717 0.8192
Cp_5717 tree_5717 0 2.592e-15
Rtr_571_5718 tree_571 tree_5718 0.8192
Cp_5718 tree_5718 0 2.592e-15
Rtr_571_5719 tree_571 tree_5719 0.8192
Cp_5719 tree_5719 0 2.592e-15
Rtr_571_5720 tree_571 tree_5720 0.8192
Cp_5720 tree_5720 0 2.592e-15
Rtr_572_5721 tree_572 tree_5721 0.8192
Cp_5721 tree_5721 0 2.592e-15
Rtr_572_5722 tree_572 tree_5722 0.8192
Cp_5722 tree_5722 0 2.592e-15
Rtr_572_5723 tree_572 tree_5723 0.8192
Cp_5723 tree_5723 0 2.592e-15
Rtr_572_5724 tree_572 tree_5724 0.8192
Cp_5724 tree_5724 0 2.592e-15
Rtr_572_5725 tree_572 tree_5725 0.8192
Cp_5725 tree_5725 0 2.592e-15
Rtr_572_5726 tree_572 tree_5726 0.8192
Cp_5726 tree_5726 0 2.592e-15
Rtr_572_5727 tree_572 tree_5727 0.8192
Cp_5727 tree_5727 0 2.592e-15
Rtr_572_5728 tree_572 tree_5728 0.8192
Cp_5728 tree_5728 0 2.592e-15
Rtr_572_5729 tree_572 tree_5729 0.8192
Cp_5729 tree_5729 0 2.592e-15
Rtr_572_5730 tree_572 tree_5730 0.8192
Cp_5730 tree_5730 0 2.592e-15
Rtr_573_5731 tree_573 tree_5731 0.8192
Cp_5731 tree_5731 0 2.592e-15
Rtr_573_5732 tree_573 tree_5732 0.8192
Cp_5732 tree_5732 0 2.592e-15
Rtr_573_5733 tree_573 tree_5733 0.8192
Cp_5733 tree_5733 0 2.592e-15
Rtr_573_5734 tree_573 tree_5734 0.8192
Cp_5734 tree_5734 0 2.592e-15
Rtr_573_5735 tree_573 tree_5735 0.8192
Cp_5735 tree_5735 0 2.592e-15
Rtr_573_5736 tree_573 tree_5736 0.8192
Cp_5736 tree_5736 0 2.592e-15
Rtr_573_5737 tree_573 tree_5737 0.8192
Cp_5737 tree_5737 0 2.592e-15
Rtr_573_5738 tree_573 tree_5738 0.8192
Cp_5738 tree_5738 0 2.592e-15
Rtr_573_5739 tree_573 tree_5739 0.8192
Cp_5739 tree_5739 0 2.592e-15
Rtr_573_5740 tree_573 tree_5740 0.8192
Cp_5740 tree_5740 0 2.592e-15
Rtr_574_5741 tree_574 tree_5741 0.8192
Cp_5741 tree_5741 0 2.592e-15
Rtr_574_5742 tree_574 tree_5742 0.8192
Cp_5742 tree_5742 0 2.592e-15
Rtr_574_5743 tree_574 tree_5743 0.8192
Cp_5743 tree_5743 0 2.592e-15
Rtr_574_5744 tree_574 tree_5744 0.8192
Cp_5744 tree_5744 0 2.592e-15
Rtr_574_5745 tree_574 tree_5745 0.8192
Cp_5745 tree_5745 0 2.592e-15
Rtr_574_5746 tree_574 tree_5746 0.8192
Cp_5746 tree_5746 0 2.592e-15
Rtr_574_5747 tree_574 tree_5747 0.8192
Cp_5747 tree_5747 0 2.592e-15
Rtr_574_5748 tree_574 tree_5748 0.8192
Cp_5748 tree_5748 0 2.592e-15
Rtr_574_5749 tree_574 tree_5749 0.8192
Cp_5749 tree_5749 0 2.592e-15
Rtr_574_5750 tree_574 tree_5750 0.8192
Cp_5750 tree_5750 0 2.592e-15
Rtr_575_5751 tree_575 tree_5751 0.8192
Cp_5751 tree_5751 0 2.592e-15
Rtr_575_5752 tree_575 tree_5752 0.8192
Cp_5752 tree_5752 0 2.592e-15
Rtr_575_5753 tree_575 tree_5753 0.8192
Cp_5753 tree_5753 0 2.592e-15
Rtr_575_5754 tree_575 tree_5754 0.8192
Cp_5754 tree_5754 0 2.592e-15
Rtr_575_5755 tree_575 tree_5755 0.8192
Cp_5755 tree_5755 0 2.592e-15
Rtr_575_5756 tree_575 tree_5756 0.8192
Cp_5756 tree_5756 0 2.592e-15
Rtr_575_5757 tree_575 tree_5757 0.8192
Cp_5757 tree_5757 0 2.592e-15
Rtr_575_5758 tree_575 tree_5758 0.8192
Cp_5758 tree_5758 0 2.592e-15
Rtr_575_5759 tree_575 tree_5759 0.8192
Cp_5759 tree_5759 0 2.592e-15
Rtr_575_5760 tree_575 tree_5760 0.8192
Cp_5760 tree_5760 0 2.592e-15
Rtr_576_5761 tree_576 tree_5761 0.8192
Cp_5761 tree_5761 0 2.592e-15
Rtr_576_5762 tree_576 tree_5762 0.8192
Cp_5762 tree_5762 0 2.592e-15
Rtr_576_5763 tree_576 tree_5763 0.8192
Cp_5763 tree_5763 0 2.592e-15
Rtr_576_5764 tree_576 tree_5764 0.8192
Cp_5764 tree_5764 0 2.592e-15
Rtr_576_5765 tree_576 tree_5765 0.8192
Cp_5765 tree_5765 0 2.592e-15
Rtr_576_5766 tree_576 tree_5766 0.8192
Cp_5766 tree_5766 0 2.592e-15
Rtr_576_5767 tree_576 tree_5767 0.8192
Cp_5767 tree_5767 0 2.592e-15
Rtr_576_5768 tree_576 tree_5768 0.8192
Cp_5768 tree_5768 0 2.592e-15
Rtr_576_5769 tree_576 tree_5769 0.8192
Cp_5769 tree_5769 0 2.592e-15
Rtr_576_5770 tree_576 tree_5770 0.8192
Cp_5770 tree_5770 0 2.592e-15
Rtr_577_5771 tree_577 tree_5771 0.8192
Cp_5771 tree_5771 0 2.592e-15
Rtr_577_5772 tree_577 tree_5772 0.8192
Cp_5772 tree_5772 0 2.592e-15
Rtr_577_5773 tree_577 tree_5773 0.8192
Cp_5773 tree_5773 0 2.592e-15
Rtr_577_5774 tree_577 tree_5774 0.8192
Cp_5774 tree_5774 0 2.592e-15
Rtr_577_5775 tree_577 tree_5775 0.8192
Cp_5775 tree_5775 0 2.592e-15
Rtr_577_5776 tree_577 tree_5776 0.8192
Cp_5776 tree_5776 0 2.592e-15
Rtr_577_5777 tree_577 tree_5777 0.8192
Cp_5777 tree_5777 0 2.592e-15
Rtr_577_5778 tree_577 tree_5778 0.8192
Cp_5778 tree_5778 0 2.592e-15
Rtr_577_5779 tree_577 tree_5779 0.8192
Cp_5779 tree_5779 0 2.592e-15
Rtr_577_5780 tree_577 tree_5780 0.8192
Cp_5780 tree_5780 0 2.592e-15
Rtr_578_5781 tree_578 tree_5781 0.8192
Cp_5781 tree_5781 0 2.592e-15
Rtr_578_5782 tree_578 tree_5782 0.8192
Cp_5782 tree_5782 0 2.592e-15
Rtr_578_5783 tree_578 tree_5783 0.8192
Cp_5783 tree_5783 0 2.592e-15
Rtr_578_5784 tree_578 tree_5784 0.8192
Cp_5784 tree_5784 0 2.592e-15
Rtr_578_5785 tree_578 tree_5785 0.8192
Cp_5785 tree_5785 0 2.592e-15
Rtr_578_5786 tree_578 tree_5786 0.8192
Cp_5786 tree_5786 0 2.592e-15
Rtr_578_5787 tree_578 tree_5787 0.8192
Cp_5787 tree_5787 0 2.592e-15
Rtr_578_5788 tree_578 tree_5788 0.8192
Cp_5788 tree_5788 0 2.592e-15
Rtr_578_5789 tree_578 tree_5789 0.8192
Cp_5789 tree_5789 0 2.592e-15
Rtr_578_5790 tree_578 tree_5790 0.8192
Cp_5790 tree_5790 0 2.592e-15
Rtr_579_5791 tree_579 tree_5791 0.8192
Cp_5791 tree_5791 0 2.592e-15
Rtr_579_5792 tree_579 tree_5792 0.8192
Cp_5792 tree_5792 0 2.592e-15
Rtr_579_5793 tree_579 tree_5793 0.8192
Cp_5793 tree_5793 0 2.592e-15
Rtr_579_5794 tree_579 tree_5794 0.8192
Cp_5794 tree_5794 0 2.592e-15
Rtr_579_5795 tree_579 tree_5795 0.8192
Cp_5795 tree_5795 0 2.592e-15
Rtr_579_5796 tree_579 tree_5796 0.8192
Cp_5796 tree_5796 0 2.592e-15
Rtr_579_5797 tree_579 tree_5797 0.8192
Cp_5797 tree_5797 0 2.592e-15
Rtr_579_5798 tree_579 tree_5798 0.8192
Cp_5798 tree_5798 0 2.592e-15
Rtr_579_5799 tree_579 tree_5799 0.8192
Cp_5799 tree_5799 0 2.592e-15
Rtr_579_5800 tree_579 tree_5800 0.8192
Cp_5800 tree_5800 0 2.592e-15
Rtr_580_5801 tree_580 tree_5801 0.8192
Cp_5801 tree_5801 0 2.592e-15
Rtr_580_5802 tree_580 tree_5802 0.8192
Cp_5802 tree_5802 0 2.592e-15
Rtr_580_5803 tree_580 tree_5803 0.8192
Cp_5803 tree_5803 0 2.592e-15
Rtr_580_5804 tree_580 tree_5804 0.8192
Cp_5804 tree_5804 0 2.592e-15
Rtr_580_5805 tree_580 tree_5805 0.8192
Cp_5805 tree_5805 0 2.592e-15
Rtr_580_5806 tree_580 tree_5806 0.8192
Cp_5806 tree_5806 0 2.592e-15
Rtr_580_5807 tree_580 tree_5807 0.8192
Cp_5807 tree_5807 0 2.592e-15
Rtr_580_5808 tree_580 tree_5808 0.8192
Cp_5808 tree_5808 0 2.592e-15
Rtr_580_5809 tree_580 tree_5809 0.8192
Cp_5809 tree_5809 0 2.592e-15
Rtr_580_5810 tree_580 tree_5810 0.8192
Cp_5810 tree_5810 0 2.592e-15
Rtr_581_5811 tree_581 tree_5811 0.8192
Cp_5811 tree_5811 0 2.592e-15
Rtr_581_5812 tree_581 tree_5812 0.8192
Cp_5812 tree_5812 0 2.592e-15
Rtr_581_5813 tree_581 tree_5813 0.8192
Cp_5813 tree_5813 0 2.592e-15
Rtr_581_5814 tree_581 tree_5814 0.8192
Cp_5814 tree_5814 0 2.592e-15
Rtr_581_5815 tree_581 tree_5815 0.8192
Cp_5815 tree_5815 0 2.592e-15
Rtr_581_5816 tree_581 tree_5816 0.8192
Cp_5816 tree_5816 0 2.592e-15
Rtr_581_5817 tree_581 tree_5817 0.8192
Cp_5817 tree_5817 0 2.592e-15
Rtr_581_5818 tree_581 tree_5818 0.8192
Cp_5818 tree_5818 0 2.592e-15
Rtr_581_5819 tree_581 tree_5819 0.8192
Cp_5819 tree_5819 0 2.592e-15
Rtr_581_5820 tree_581 tree_5820 0.8192
Cp_5820 tree_5820 0 2.592e-15
Rtr_582_5821 tree_582 tree_5821 0.8192
Cp_5821 tree_5821 0 2.592e-15
Rtr_582_5822 tree_582 tree_5822 0.8192
Cp_5822 tree_5822 0 2.592e-15
Rtr_582_5823 tree_582 tree_5823 0.8192
Cp_5823 tree_5823 0 2.592e-15
Rtr_582_5824 tree_582 tree_5824 0.8192
Cp_5824 tree_5824 0 2.592e-15
Rtr_582_5825 tree_582 tree_5825 0.8192
Cp_5825 tree_5825 0 2.592e-15
Rtr_582_5826 tree_582 tree_5826 0.8192
Cp_5826 tree_5826 0 2.592e-15
Rtr_582_5827 tree_582 tree_5827 0.8192
Cp_5827 tree_5827 0 2.592e-15
Rtr_582_5828 tree_582 tree_5828 0.8192
Cp_5828 tree_5828 0 2.592e-15
Rtr_582_5829 tree_582 tree_5829 0.8192
Cp_5829 tree_5829 0 2.592e-15
Rtr_582_5830 tree_582 tree_5830 0.8192
Cp_5830 tree_5830 0 2.592e-15
Rtr_583_5831 tree_583 tree_5831 0.8192
Cp_5831 tree_5831 0 2.592e-15
Rtr_583_5832 tree_583 tree_5832 0.8192
Cp_5832 tree_5832 0 2.592e-15
Rtr_583_5833 tree_583 tree_5833 0.8192
Cp_5833 tree_5833 0 2.592e-15
Rtr_583_5834 tree_583 tree_5834 0.8192
Cp_5834 tree_5834 0 2.592e-15
Rtr_583_5835 tree_583 tree_5835 0.8192
Cp_5835 tree_5835 0 2.592e-15
Rtr_583_5836 tree_583 tree_5836 0.8192
Cp_5836 tree_5836 0 2.592e-15
Rtr_583_5837 tree_583 tree_5837 0.8192
Cp_5837 tree_5837 0 2.592e-15
Rtr_583_5838 tree_583 tree_5838 0.8192
Cp_5838 tree_5838 0 2.592e-15
Rtr_583_5839 tree_583 tree_5839 0.8192
Cp_5839 tree_5839 0 2.592e-15
Rtr_583_5840 tree_583 tree_5840 0.8192
Cp_5840 tree_5840 0 2.592e-15
Rtr_584_5841 tree_584 tree_5841 0.8192
Cp_5841 tree_5841 0 2.592e-15
Rtr_584_5842 tree_584 tree_5842 0.8192
Cp_5842 tree_5842 0 2.592e-15
Rtr_584_5843 tree_584 tree_5843 0.8192
Cp_5843 tree_5843 0 2.592e-15
Rtr_584_5844 tree_584 tree_5844 0.8192
Cp_5844 tree_5844 0 2.592e-15
Rtr_584_5845 tree_584 tree_5845 0.8192
Cp_5845 tree_5845 0 2.592e-15
Rtr_584_5846 tree_584 tree_5846 0.8192
Cp_5846 tree_5846 0 2.592e-15
Rtr_584_5847 tree_584 tree_5847 0.8192
Cp_5847 tree_5847 0 2.592e-15
Rtr_584_5848 tree_584 tree_5848 0.8192
Cp_5848 tree_5848 0 2.592e-15
Rtr_584_5849 tree_584 tree_5849 0.8192
Cp_5849 tree_5849 0 2.592e-15
Rtr_584_5850 tree_584 tree_5850 0.8192
Cp_5850 tree_5850 0 2.592e-15
Rtr_585_5851 tree_585 tree_5851 0.8192
Cp_5851 tree_5851 0 2.592e-15
Rtr_585_5852 tree_585 tree_5852 0.8192
Cp_5852 tree_5852 0 2.592e-15
Rtr_585_5853 tree_585 tree_5853 0.8192
Cp_5853 tree_5853 0 2.592e-15
Rtr_585_5854 tree_585 tree_5854 0.8192
Cp_5854 tree_5854 0 2.592e-15
Rtr_585_5855 tree_585 tree_5855 0.8192
Cp_5855 tree_5855 0 2.592e-15
Rtr_585_5856 tree_585 tree_5856 0.8192
Cp_5856 tree_5856 0 2.592e-15
Rtr_585_5857 tree_585 tree_5857 0.8192
Cp_5857 tree_5857 0 2.592e-15
Rtr_585_5858 tree_585 tree_5858 0.8192
Cp_5858 tree_5858 0 2.592e-15
Rtr_585_5859 tree_585 tree_5859 0.8192
Cp_5859 tree_5859 0 2.592e-15
Rtr_585_5860 tree_585 tree_5860 0.8192
Cp_5860 tree_5860 0 2.592e-15
Rtr_586_5861 tree_586 tree_5861 0.8192
Cp_5861 tree_5861 0 2.592e-15
Rtr_586_5862 tree_586 tree_5862 0.8192
Cp_5862 tree_5862 0 2.592e-15
Rtr_586_5863 tree_586 tree_5863 0.8192
Cp_5863 tree_5863 0 2.592e-15
Rtr_586_5864 tree_586 tree_5864 0.8192
Cp_5864 tree_5864 0 2.592e-15
Rtr_586_5865 tree_586 tree_5865 0.8192
Cp_5865 tree_5865 0 2.592e-15
Rtr_586_5866 tree_586 tree_5866 0.8192
Cp_5866 tree_5866 0 2.592e-15
Rtr_586_5867 tree_586 tree_5867 0.8192
Cp_5867 tree_5867 0 2.592e-15
Rtr_586_5868 tree_586 tree_5868 0.8192
Cp_5868 tree_5868 0 2.592e-15
Rtr_586_5869 tree_586 tree_5869 0.8192
Cp_5869 tree_5869 0 2.592e-15
Rtr_586_5870 tree_586 tree_5870 0.8192
Cp_5870 tree_5870 0 2.592e-15
Rtr_587_5871 tree_587 tree_5871 0.8192
Cp_5871 tree_5871 0 2.592e-15
Rtr_587_5872 tree_587 tree_5872 0.8192
Cp_5872 tree_5872 0 2.592e-15
Rtr_587_5873 tree_587 tree_5873 0.8192
Cp_5873 tree_5873 0 2.592e-15
Rtr_587_5874 tree_587 tree_5874 0.8192
Cp_5874 tree_5874 0 2.592e-15
Rtr_587_5875 tree_587 tree_5875 0.8192
Cp_5875 tree_5875 0 2.592e-15
Rtr_587_5876 tree_587 tree_5876 0.8192
Cp_5876 tree_5876 0 2.592e-15
Rtr_587_5877 tree_587 tree_5877 0.8192
Cp_5877 tree_5877 0 2.592e-15
Rtr_587_5878 tree_587 tree_5878 0.8192
Cp_5878 tree_5878 0 2.592e-15
Rtr_587_5879 tree_587 tree_5879 0.8192
Cp_5879 tree_5879 0 2.592e-15
Rtr_587_5880 tree_587 tree_5880 0.8192
Cp_5880 tree_5880 0 2.592e-15
Rtr_588_5881 tree_588 tree_5881 0.8192
Cp_5881 tree_5881 0 2.592e-15
Rtr_588_5882 tree_588 tree_5882 0.8192
Cp_5882 tree_5882 0 2.592e-15
Rtr_588_5883 tree_588 tree_5883 0.8192
Cp_5883 tree_5883 0 2.592e-15
Rtr_588_5884 tree_588 tree_5884 0.8192
Cp_5884 tree_5884 0 2.592e-15
Rtr_588_5885 tree_588 tree_5885 0.8192
Cp_5885 tree_5885 0 2.592e-15
Rtr_588_5886 tree_588 tree_5886 0.8192
Cp_5886 tree_5886 0 2.592e-15
Rtr_588_5887 tree_588 tree_5887 0.8192
Cp_5887 tree_5887 0 2.592e-15
Rtr_588_5888 tree_588 tree_5888 0.8192
Cp_5888 tree_5888 0 2.592e-15
Rtr_588_5889 tree_588 tree_5889 0.8192
Cp_5889 tree_5889 0 2.592e-15
Rtr_588_5890 tree_588 tree_5890 0.8192
Cp_5890 tree_5890 0 2.592e-15
Rtr_589_5891 tree_589 tree_5891 0.8192
Cp_5891 tree_5891 0 2.592e-15
Rtr_589_5892 tree_589 tree_5892 0.8192
Cp_5892 tree_5892 0 2.592e-15
Rtr_589_5893 tree_589 tree_5893 0.8192
Cp_5893 tree_5893 0 2.592e-15
Rtr_589_5894 tree_589 tree_5894 0.8192
Cp_5894 tree_5894 0 2.592e-15
Rtr_589_5895 tree_589 tree_5895 0.8192
Cp_5895 tree_5895 0 2.592e-15
Rtr_589_5896 tree_589 tree_5896 0.8192
Cp_5896 tree_5896 0 2.592e-15
Rtr_589_5897 tree_589 tree_5897 0.8192
Cp_5897 tree_5897 0 2.592e-15
Rtr_589_5898 tree_589 tree_5898 0.8192
Cp_5898 tree_5898 0 2.592e-15
Rtr_589_5899 tree_589 tree_5899 0.8192
Cp_5899 tree_5899 0 2.592e-15
Rtr_589_5900 tree_589 tree_5900 0.8192
Cp_5900 tree_5900 0 2.592e-15
Rtr_590_5901 tree_590 tree_5901 0.8192
Cp_5901 tree_5901 0 2.592e-15
Rtr_590_5902 tree_590 tree_5902 0.8192
Cp_5902 tree_5902 0 2.592e-15
Rtr_590_5903 tree_590 tree_5903 0.8192
Cp_5903 tree_5903 0 2.592e-15
Rtr_590_5904 tree_590 tree_5904 0.8192
Cp_5904 tree_5904 0 2.592e-15
Rtr_590_5905 tree_590 tree_5905 0.8192
Cp_5905 tree_5905 0 2.592e-15
Rtr_590_5906 tree_590 tree_5906 0.8192
Cp_5906 tree_5906 0 2.592e-15
Rtr_590_5907 tree_590 tree_5907 0.8192
Cp_5907 tree_5907 0 2.592e-15
Rtr_590_5908 tree_590 tree_5908 0.8192
Cp_5908 tree_5908 0 2.592e-15
Rtr_590_5909 tree_590 tree_5909 0.8192
Cp_5909 tree_5909 0 2.592e-15
Rtr_590_5910 tree_590 tree_5910 0.8192
Cp_5910 tree_5910 0 2.592e-15
Rtr_591_5911 tree_591 tree_5911 0.8192
Cp_5911 tree_5911 0 2.592e-15
Rtr_591_5912 tree_591 tree_5912 0.8192
Cp_5912 tree_5912 0 2.592e-15
Rtr_591_5913 tree_591 tree_5913 0.8192
Cp_5913 tree_5913 0 2.592e-15
Rtr_591_5914 tree_591 tree_5914 0.8192
Cp_5914 tree_5914 0 2.592e-15
Rtr_591_5915 tree_591 tree_5915 0.8192
Cp_5915 tree_5915 0 2.592e-15
Rtr_591_5916 tree_591 tree_5916 0.8192
Cp_5916 tree_5916 0 2.592e-15
Rtr_591_5917 tree_591 tree_5917 0.8192
Cp_5917 tree_5917 0 2.592e-15
Rtr_591_5918 tree_591 tree_5918 0.8192
Cp_5918 tree_5918 0 2.592e-15
Rtr_591_5919 tree_591 tree_5919 0.8192
Cp_5919 tree_5919 0 2.592e-15
Rtr_591_5920 tree_591 tree_5920 0.8192
Cp_5920 tree_5920 0 2.592e-15
Rtr_592_5921 tree_592 tree_5921 0.8192
Cp_5921 tree_5921 0 2.592e-15
Rtr_592_5922 tree_592 tree_5922 0.8192
Cp_5922 tree_5922 0 2.592e-15
Rtr_592_5923 tree_592 tree_5923 0.8192
Cp_5923 tree_5923 0 2.592e-15
Rtr_592_5924 tree_592 tree_5924 0.8192
Cp_5924 tree_5924 0 2.592e-15
Rtr_592_5925 tree_592 tree_5925 0.8192
Cp_5925 tree_5925 0 2.592e-15
Rtr_592_5926 tree_592 tree_5926 0.8192
Cp_5926 tree_5926 0 2.592e-15
Rtr_592_5927 tree_592 tree_5927 0.8192
Cp_5927 tree_5927 0 2.592e-15
Rtr_592_5928 tree_592 tree_5928 0.8192
Cp_5928 tree_5928 0 2.592e-15
Rtr_592_5929 tree_592 tree_5929 0.8192
Cp_5929 tree_5929 0 2.592e-15
Rtr_592_5930 tree_592 tree_5930 0.8192
Cp_5930 tree_5930 0 2.592e-15
Rtr_593_5931 tree_593 tree_5931 0.8192
Cp_5931 tree_5931 0 2.592e-15
Rtr_593_5932 tree_593 tree_5932 0.8192
Cp_5932 tree_5932 0 2.592e-15
Rtr_593_5933 tree_593 tree_5933 0.8192
Cp_5933 tree_5933 0 2.592e-15
Rtr_593_5934 tree_593 tree_5934 0.8192
Cp_5934 tree_5934 0 2.592e-15
Rtr_593_5935 tree_593 tree_5935 0.8192
Cp_5935 tree_5935 0 2.592e-15
Rtr_593_5936 tree_593 tree_5936 0.8192
Cp_5936 tree_5936 0 2.592e-15
Rtr_593_5937 tree_593 tree_5937 0.8192
Cp_5937 tree_5937 0 2.592e-15
Rtr_593_5938 tree_593 tree_5938 0.8192
Cp_5938 tree_5938 0 2.592e-15
Rtr_593_5939 tree_593 tree_5939 0.8192
Cp_5939 tree_5939 0 2.592e-15
Rtr_593_5940 tree_593 tree_5940 0.8192
Cp_5940 tree_5940 0 2.592e-15
Rtr_594_5941 tree_594 tree_5941 0.8192
Cp_5941 tree_5941 0 2.592e-15
Rtr_594_5942 tree_594 tree_5942 0.8192
Cp_5942 tree_5942 0 2.592e-15
Rtr_594_5943 tree_594 tree_5943 0.8192
Cp_5943 tree_5943 0 2.592e-15
Rtr_594_5944 tree_594 tree_5944 0.8192
Cp_5944 tree_5944 0 2.592e-15
Rtr_594_5945 tree_594 tree_5945 0.8192
Cp_5945 tree_5945 0 2.592e-15
Rtr_594_5946 tree_594 tree_5946 0.8192
Cp_5946 tree_5946 0 2.592e-15
Rtr_594_5947 tree_594 tree_5947 0.8192
Cp_5947 tree_5947 0 2.592e-15
Rtr_594_5948 tree_594 tree_5948 0.8192
Cp_5948 tree_5948 0 2.592e-15
Rtr_594_5949 tree_594 tree_5949 0.8192
Cp_5949 tree_5949 0 2.592e-15
Rtr_594_5950 tree_594 tree_5950 0.8192
Cp_5950 tree_5950 0 2.592e-15
Rtr_595_5951 tree_595 tree_5951 0.8192
Cp_5951 tree_5951 0 2.592e-15
Rtr_595_5952 tree_595 tree_5952 0.8192
Cp_5952 tree_5952 0 2.592e-15
Rtr_595_5953 tree_595 tree_5953 0.8192
Cp_5953 tree_5953 0 2.592e-15
Rtr_595_5954 tree_595 tree_5954 0.8192
Cp_5954 tree_5954 0 2.592e-15
Rtr_595_5955 tree_595 tree_5955 0.8192
Cp_5955 tree_5955 0 2.592e-15
Rtr_595_5956 tree_595 tree_5956 0.8192
Cp_5956 tree_5956 0 2.592e-15
Rtr_595_5957 tree_595 tree_5957 0.8192
Cp_5957 tree_5957 0 2.592e-15
Rtr_595_5958 tree_595 tree_5958 0.8192
Cp_5958 tree_5958 0 2.592e-15
Rtr_595_5959 tree_595 tree_5959 0.8192
Cp_5959 tree_5959 0 2.592e-15
Rtr_595_5960 tree_595 tree_5960 0.8192
Cp_5960 tree_5960 0 2.592e-15
Rtr_596_5961 tree_596 tree_5961 0.8192
Cp_5961 tree_5961 0 2.592e-15
Rtr_596_5962 tree_596 tree_5962 0.8192
Cp_5962 tree_5962 0 2.592e-15
Rtr_596_5963 tree_596 tree_5963 0.8192
Cp_5963 tree_5963 0 2.592e-15
Rtr_596_5964 tree_596 tree_5964 0.8192
Cp_5964 tree_5964 0 2.592e-15
Rtr_596_5965 tree_596 tree_5965 0.8192
Cp_5965 tree_5965 0 2.592e-15
Rtr_596_5966 tree_596 tree_5966 0.8192
Cp_5966 tree_5966 0 2.592e-15
Rtr_596_5967 tree_596 tree_5967 0.8192
Cp_5967 tree_5967 0 2.592e-15
Rtr_596_5968 tree_596 tree_5968 0.8192
Cp_5968 tree_5968 0 2.592e-15
Rtr_596_5969 tree_596 tree_5969 0.8192
Cp_5969 tree_5969 0 2.592e-15
Rtr_596_5970 tree_596 tree_5970 0.8192
Cp_5970 tree_5970 0 2.592e-15
Rtr_597_5971 tree_597 tree_5971 0.8192
Cp_5971 tree_5971 0 2.592e-15
Rtr_597_5972 tree_597 tree_5972 0.8192
Cp_5972 tree_5972 0 2.592e-15
Rtr_597_5973 tree_597 tree_5973 0.8192
Cp_5973 tree_5973 0 2.592e-15
Rtr_597_5974 tree_597 tree_5974 0.8192
Cp_5974 tree_5974 0 2.592e-15
Rtr_597_5975 tree_597 tree_5975 0.8192
Cp_5975 tree_5975 0 2.592e-15
Rtr_597_5976 tree_597 tree_5976 0.8192
Cp_5976 tree_5976 0 2.592e-15
Rtr_597_5977 tree_597 tree_5977 0.8192
Cp_5977 tree_5977 0 2.592e-15
Rtr_597_5978 tree_597 tree_5978 0.8192
Cp_5978 tree_5978 0 2.592e-15
Rtr_597_5979 tree_597 tree_5979 0.8192
Cp_5979 tree_5979 0 2.592e-15
Rtr_597_5980 tree_597 tree_5980 0.8192
Cp_5980 tree_5980 0 2.592e-15
Rtr_598_5981 tree_598 tree_5981 0.8192
Cp_5981 tree_5981 0 2.592e-15
Rtr_598_5982 tree_598 tree_5982 0.8192
Cp_5982 tree_5982 0 2.592e-15
Rtr_598_5983 tree_598 tree_5983 0.8192
Cp_5983 tree_5983 0 2.592e-15
Rtr_598_5984 tree_598 tree_5984 0.8192
Cp_5984 tree_5984 0 2.592e-15
Rtr_598_5985 tree_598 tree_5985 0.8192
Cp_5985 tree_5985 0 2.592e-15
Rtr_598_5986 tree_598 tree_5986 0.8192
Cp_5986 tree_5986 0 2.592e-15
Rtr_598_5987 tree_598 tree_5987 0.8192
Cp_5987 tree_5987 0 2.592e-15
Rtr_598_5988 tree_598 tree_5988 0.8192
Cp_5988 tree_5988 0 2.592e-15
Rtr_598_5989 tree_598 tree_5989 0.8192
Cp_5989 tree_5989 0 2.592e-15
Rtr_598_5990 tree_598 tree_5990 0.8192
Cp_5990 tree_5990 0 2.592e-15
Rtr_599_5991 tree_599 tree_5991 0.8192
Cp_5991 tree_5991 0 2.592e-15
Rtr_599_5992 tree_599 tree_5992 0.8192
Cp_5992 tree_5992 0 2.592e-15
Rtr_599_5993 tree_599 tree_5993 0.8192
Cp_5993 tree_5993 0 2.592e-15
Rtr_599_5994 tree_599 tree_5994 0.8192
Cp_5994 tree_5994 0 2.592e-15
Rtr_599_5995 tree_599 tree_5995 0.8192
Cp_5995 tree_5995 0 2.592e-15
Rtr_599_5996 tree_599 tree_5996 0.8192
Cp_5996 tree_5996 0 2.592e-15
Rtr_599_5997 tree_599 tree_5997 0.8192
Cp_5997 tree_5997 0 2.592e-15
Rtr_599_5998 tree_599 tree_5998 0.8192
Cp_5998 tree_5998 0 2.592e-15
Rtr_599_5999 tree_599 tree_5999 0.8192
Cp_5999 tree_5999 0 2.592e-15
Rtr_599_6000 tree_599 tree_6000 0.8192
Cp_6000 tree_6000 0 2.592e-15
Rtr_600_6001 tree_600 tree_6001 0.8192
Cp_6001 tree_6001 0 2.592e-15
Rtr_600_6002 tree_600 tree_6002 0.8192
Cp_6002 tree_6002 0 2.592e-15
Rtr_600_6003 tree_600 tree_6003 0.8192
Cp_6003 tree_6003 0 2.592e-15
Rtr_600_6004 tree_600 tree_6004 0.8192
Cp_6004 tree_6004 0 2.592e-15
Rtr_600_6005 tree_600 tree_6005 0.8192
Cp_6005 tree_6005 0 2.592e-15
Rtr_600_6006 tree_600 tree_6006 0.8192
Cp_6006 tree_6006 0 2.592e-15
Rtr_600_6007 tree_600 tree_6007 0.8192
Cp_6007 tree_6007 0 2.592e-15
Rtr_600_6008 tree_600 tree_6008 0.8192
Cp_6008 tree_6008 0 2.592e-15
Rtr_600_6009 tree_600 tree_6009 0.8192
Cp_6009 tree_6009 0 2.592e-15
Rtr_600_6010 tree_600 tree_6010 0.8192
Cp_6010 tree_6010 0 2.592e-15
Rtr_601_6011 tree_601 tree_6011 0.8192
Cp_6011 tree_6011 0 2.592e-15
Rtr_601_6012 tree_601 tree_6012 0.8192
Cp_6012 tree_6012 0 2.592e-15
Rtr_601_6013 tree_601 tree_6013 0.8192
Cp_6013 tree_6013 0 2.592e-15
Rtr_601_6014 tree_601 tree_6014 0.8192
Cp_6014 tree_6014 0 2.592e-15
Rtr_601_6015 tree_601 tree_6015 0.8192
Cp_6015 tree_6015 0 2.592e-15
Rtr_601_6016 tree_601 tree_6016 0.8192
Cp_6016 tree_6016 0 2.592e-15
Rtr_601_6017 tree_601 tree_6017 0.8192
Cp_6017 tree_6017 0 2.592e-15
Rtr_601_6018 tree_601 tree_6018 0.8192
Cp_6018 tree_6018 0 2.592e-15
Rtr_601_6019 tree_601 tree_6019 0.8192
Cp_6019 tree_6019 0 2.592e-15
Rtr_601_6020 tree_601 tree_6020 0.8192
Cp_6020 tree_6020 0 2.592e-15
Rtr_602_6021 tree_602 tree_6021 0.8192
Cp_6021 tree_6021 0 2.592e-15
Rtr_602_6022 tree_602 tree_6022 0.8192
Cp_6022 tree_6022 0 2.592e-15
Rtr_602_6023 tree_602 tree_6023 0.8192
Cp_6023 tree_6023 0 2.592e-15
Rtr_602_6024 tree_602 tree_6024 0.8192
Cp_6024 tree_6024 0 2.592e-15
Rtr_602_6025 tree_602 tree_6025 0.8192
Cp_6025 tree_6025 0 2.592e-15
Rtr_602_6026 tree_602 tree_6026 0.8192
Cp_6026 tree_6026 0 2.592e-15
Rtr_602_6027 tree_602 tree_6027 0.8192
Cp_6027 tree_6027 0 2.592e-15
Rtr_602_6028 tree_602 tree_6028 0.8192
Cp_6028 tree_6028 0 2.592e-15
Rtr_602_6029 tree_602 tree_6029 0.8192
Cp_6029 tree_6029 0 2.592e-15
Rtr_602_6030 tree_602 tree_6030 0.8192
Cp_6030 tree_6030 0 2.592e-15
Rtr_603_6031 tree_603 tree_6031 0.8192
Cp_6031 tree_6031 0 2.592e-15
Rtr_603_6032 tree_603 tree_6032 0.8192
Cp_6032 tree_6032 0 2.592e-15
Rtr_603_6033 tree_603 tree_6033 0.8192
Cp_6033 tree_6033 0 2.592e-15
Rtr_603_6034 tree_603 tree_6034 0.8192
Cp_6034 tree_6034 0 2.592e-15
Rtr_603_6035 tree_603 tree_6035 0.8192
Cp_6035 tree_6035 0 2.592e-15
Rtr_603_6036 tree_603 tree_6036 0.8192
Cp_6036 tree_6036 0 2.592e-15
Rtr_603_6037 tree_603 tree_6037 0.8192
Cp_6037 tree_6037 0 2.592e-15
Rtr_603_6038 tree_603 tree_6038 0.8192
Cp_6038 tree_6038 0 2.592e-15
Rtr_603_6039 tree_603 tree_6039 0.8192
Cp_6039 tree_6039 0 2.592e-15
Rtr_603_6040 tree_603 tree_6040 0.8192
Cp_6040 tree_6040 0 2.592e-15
Rtr_604_6041 tree_604 tree_6041 0.8192
Cp_6041 tree_6041 0 2.592e-15
Rtr_604_6042 tree_604 tree_6042 0.8192
Cp_6042 tree_6042 0 2.592e-15
Rtr_604_6043 tree_604 tree_6043 0.8192
Cp_6043 tree_6043 0 2.592e-15
Rtr_604_6044 tree_604 tree_6044 0.8192
Cp_6044 tree_6044 0 2.592e-15
Rtr_604_6045 tree_604 tree_6045 0.8192
Cp_6045 tree_6045 0 2.592e-15
Rtr_604_6046 tree_604 tree_6046 0.8192
Cp_6046 tree_6046 0 2.592e-15
Rtr_604_6047 tree_604 tree_6047 0.8192
Cp_6047 tree_6047 0 2.592e-15
Rtr_604_6048 tree_604 tree_6048 0.8192
Cp_6048 tree_6048 0 2.592e-15
Rtr_604_6049 tree_604 tree_6049 0.8192
Cp_6049 tree_6049 0 2.592e-15
Rtr_604_6050 tree_604 tree_6050 0.8192
Cp_6050 tree_6050 0 2.592e-15
Rtr_605_6051 tree_605 tree_6051 0.8192
Cp_6051 tree_6051 0 2.592e-15
Rtr_605_6052 tree_605 tree_6052 0.8192
Cp_6052 tree_6052 0 2.592e-15
Rtr_605_6053 tree_605 tree_6053 0.8192
Cp_6053 tree_6053 0 2.592e-15
Rtr_605_6054 tree_605 tree_6054 0.8192
Cp_6054 tree_6054 0 2.592e-15
Rtr_605_6055 tree_605 tree_6055 0.8192
Cp_6055 tree_6055 0 2.592e-15
Rtr_605_6056 tree_605 tree_6056 0.8192
Cp_6056 tree_6056 0 2.592e-15
Rtr_605_6057 tree_605 tree_6057 0.8192
Cp_6057 tree_6057 0 2.592e-15
Rtr_605_6058 tree_605 tree_6058 0.8192
Cp_6058 tree_6058 0 2.592e-15
Rtr_605_6059 tree_605 tree_6059 0.8192
Cp_6059 tree_6059 0 2.592e-15
Rtr_605_6060 tree_605 tree_6060 0.8192
Cp_6060 tree_6060 0 2.592e-15
Rtr_606_6061 tree_606 tree_6061 0.8192
Cp_6061 tree_6061 0 2.592e-15
Rtr_606_6062 tree_606 tree_6062 0.8192
Cp_6062 tree_6062 0 2.592e-15
Rtr_606_6063 tree_606 tree_6063 0.8192
Cp_6063 tree_6063 0 2.592e-15
Rtr_606_6064 tree_606 tree_6064 0.8192
Cp_6064 tree_6064 0 2.592e-15
Rtr_606_6065 tree_606 tree_6065 0.8192
Cp_6065 tree_6065 0 2.592e-15
Rtr_606_6066 tree_606 tree_6066 0.8192
Cp_6066 tree_6066 0 2.592e-15
Rtr_606_6067 tree_606 tree_6067 0.8192
Cp_6067 tree_6067 0 2.592e-15
Rtr_606_6068 tree_606 tree_6068 0.8192
Cp_6068 tree_6068 0 2.592e-15
Rtr_606_6069 tree_606 tree_6069 0.8192
Cp_6069 tree_6069 0 2.592e-15
Rtr_606_6070 tree_606 tree_6070 0.8192
Cp_6070 tree_6070 0 2.592e-15
Rtr_607_6071 tree_607 tree_6071 0.8192
Cp_6071 tree_6071 0 2.592e-15
Rtr_607_6072 tree_607 tree_6072 0.8192
Cp_6072 tree_6072 0 2.592e-15
Rtr_607_6073 tree_607 tree_6073 0.8192
Cp_6073 tree_6073 0 2.592e-15
Rtr_607_6074 tree_607 tree_6074 0.8192
Cp_6074 tree_6074 0 2.592e-15
Rtr_607_6075 tree_607 tree_6075 0.8192
Cp_6075 tree_6075 0 2.592e-15
Rtr_607_6076 tree_607 tree_6076 0.8192
Cp_6076 tree_6076 0 2.592e-15
Rtr_607_6077 tree_607 tree_6077 0.8192
Cp_6077 tree_6077 0 2.592e-15
Rtr_607_6078 tree_607 tree_6078 0.8192
Cp_6078 tree_6078 0 2.592e-15
Rtr_607_6079 tree_607 tree_6079 0.8192
Cp_6079 tree_6079 0 2.592e-15
Rtr_607_6080 tree_607 tree_6080 0.8192
Cp_6080 tree_6080 0 2.592e-15
Rtr_608_6081 tree_608 tree_6081 0.8192
Cp_6081 tree_6081 0 2.592e-15
Rtr_608_6082 tree_608 tree_6082 0.8192
Cp_6082 tree_6082 0 2.592e-15
Rtr_608_6083 tree_608 tree_6083 0.8192
Cp_6083 tree_6083 0 2.592e-15
Rtr_608_6084 tree_608 tree_6084 0.8192
Cp_6084 tree_6084 0 2.592e-15
Rtr_608_6085 tree_608 tree_6085 0.8192
Cp_6085 tree_6085 0 2.592e-15
Rtr_608_6086 tree_608 tree_6086 0.8192
Cp_6086 tree_6086 0 2.592e-15
Rtr_608_6087 tree_608 tree_6087 0.8192
Cp_6087 tree_6087 0 2.592e-15
Rtr_608_6088 tree_608 tree_6088 0.8192
Cp_6088 tree_6088 0 2.592e-15
Rtr_608_6089 tree_608 tree_6089 0.8192
Cp_6089 tree_6089 0 2.592e-15
Rtr_608_6090 tree_608 tree_6090 0.8192
Cp_6090 tree_6090 0 2.592e-15
Rtr_609_6091 tree_609 tree_6091 0.8192
Cp_6091 tree_6091 0 2.592e-15
Rtr_609_6092 tree_609 tree_6092 0.8192
Cp_6092 tree_6092 0 2.592e-15
Rtr_609_6093 tree_609 tree_6093 0.8192
Cp_6093 tree_6093 0 2.592e-15
Rtr_609_6094 tree_609 tree_6094 0.8192
Cp_6094 tree_6094 0 2.592e-15
Rtr_609_6095 tree_609 tree_6095 0.8192
Cp_6095 tree_6095 0 2.592e-15
Rtr_609_6096 tree_609 tree_6096 0.8192
Cp_6096 tree_6096 0 2.592e-15
Rtr_609_6097 tree_609 tree_6097 0.8192
Cp_6097 tree_6097 0 2.592e-15
Rtr_609_6098 tree_609 tree_6098 0.8192
Cp_6098 tree_6098 0 2.592e-15
Rtr_609_6099 tree_609 tree_6099 0.8192
Cp_6099 tree_6099 0 2.592e-15
Rtr_609_6100 tree_609 tree_6100 0.8192
Cp_6100 tree_6100 0 2.592e-15
Rtr_610_6101 tree_610 tree_6101 0.8192
Cp_6101 tree_6101 0 2.592e-15
Rtr_610_6102 tree_610 tree_6102 0.8192
Cp_6102 tree_6102 0 2.592e-15
Rtr_610_6103 tree_610 tree_6103 0.8192
Cp_6103 tree_6103 0 2.592e-15
Rtr_610_6104 tree_610 tree_6104 0.8192
Cp_6104 tree_6104 0 2.592e-15
Rtr_610_6105 tree_610 tree_6105 0.8192
Cp_6105 tree_6105 0 2.592e-15
Rtr_610_6106 tree_610 tree_6106 0.8192
Cp_6106 tree_6106 0 2.592e-15
Rtr_610_6107 tree_610 tree_6107 0.8192
Cp_6107 tree_6107 0 2.592e-15
Rtr_610_6108 tree_610 tree_6108 0.8192
Cp_6108 tree_6108 0 2.592e-15
Rtr_610_6109 tree_610 tree_6109 0.8192
Cp_6109 tree_6109 0 2.592e-15
Rtr_610_6110 tree_610 tree_6110 0.8192
Cp_6110 tree_6110 0 2.592e-15
Rtr_611_6111 tree_611 tree_6111 0.8192
Cp_6111 tree_6111 0 2.592e-15
Rtr_611_6112 tree_611 tree_6112 0.8192
Cp_6112 tree_6112 0 2.592e-15
Rtr_611_6113 tree_611 tree_6113 0.8192
Cp_6113 tree_6113 0 2.592e-15
Rtr_611_6114 tree_611 tree_6114 0.8192
Cp_6114 tree_6114 0 2.592e-15
Rtr_611_6115 tree_611 tree_6115 0.8192
Cp_6115 tree_6115 0 2.592e-15
Rtr_611_6116 tree_611 tree_6116 0.8192
Cp_6116 tree_6116 0 2.592e-15
Rtr_611_6117 tree_611 tree_6117 0.8192
Cp_6117 tree_6117 0 2.592e-15
Rtr_611_6118 tree_611 tree_6118 0.8192
Cp_6118 tree_6118 0 2.592e-15
Rtr_611_6119 tree_611 tree_6119 0.8192
Cp_6119 tree_6119 0 2.592e-15
Rtr_611_6120 tree_611 tree_6120 0.8192
Cp_6120 tree_6120 0 2.592e-15
Rtr_612_6121 tree_612 tree_6121 0.8192
Cp_6121 tree_6121 0 2.592e-15
Rtr_612_6122 tree_612 tree_6122 0.8192
Cp_6122 tree_6122 0 2.592e-15
Rtr_612_6123 tree_612 tree_6123 0.8192
Cp_6123 tree_6123 0 2.592e-15
Rtr_612_6124 tree_612 tree_6124 0.8192
Cp_6124 tree_6124 0 2.592e-15
Rtr_612_6125 tree_612 tree_6125 0.8192
Cp_6125 tree_6125 0 2.592e-15
Rtr_612_6126 tree_612 tree_6126 0.8192
Cp_6126 tree_6126 0 2.592e-15
Rtr_612_6127 tree_612 tree_6127 0.8192
Cp_6127 tree_6127 0 2.592e-15
Rtr_612_6128 tree_612 tree_6128 0.8192
Cp_6128 tree_6128 0 2.592e-15
Rtr_612_6129 tree_612 tree_6129 0.8192
Cp_6129 tree_6129 0 2.592e-15
Rtr_612_6130 tree_612 tree_6130 0.8192
Cp_6130 tree_6130 0 2.592e-15
Rtr_613_6131 tree_613 tree_6131 0.8192
Cp_6131 tree_6131 0 2.592e-15
Rtr_613_6132 tree_613 tree_6132 0.8192
Cp_6132 tree_6132 0 2.592e-15
Rtr_613_6133 tree_613 tree_6133 0.8192
Cp_6133 tree_6133 0 2.592e-15
Rtr_613_6134 tree_613 tree_6134 0.8192
Cp_6134 tree_6134 0 2.592e-15
Rtr_613_6135 tree_613 tree_6135 0.8192
Cp_6135 tree_6135 0 2.592e-15
Rtr_613_6136 tree_613 tree_6136 0.8192
Cp_6136 tree_6136 0 2.592e-15
Rtr_613_6137 tree_613 tree_6137 0.8192
Cp_6137 tree_6137 0 2.592e-15
Rtr_613_6138 tree_613 tree_6138 0.8192
Cp_6138 tree_6138 0 2.592e-15
Rtr_613_6139 tree_613 tree_6139 0.8192
Cp_6139 tree_6139 0 2.592e-15
Rtr_613_6140 tree_613 tree_6140 0.8192
Cp_6140 tree_6140 0 2.592e-15
Rtr_614_6141 tree_614 tree_6141 0.8192
Cp_6141 tree_6141 0 2.592e-15
Rtr_614_6142 tree_614 tree_6142 0.8192
Cp_6142 tree_6142 0 2.592e-15
Rtr_614_6143 tree_614 tree_6143 0.8192
Cp_6143 tree_6143 0 2.592e-15
Rtr_614_6144 tree_614 tree_6144 0.8192
Cp_6144 tree_6144 0 2.592e-15
Rtr_614_6145 tree_614 tree_6145 0.8192
Cp_6145 tree_6145 0 2.592e-15
Rtr_614_6146 tree_614 tree_6146 0.8192
Cp_6146 tree_6146 0 2.592e-15
Rtr_614_6147 tree_614 tree_6147 0.8192
Cp_6147 tree_6147 0 2.592e-15
Rtr_614_6148 tree_614 tree_6148 0.8192
Cp_6148 tree_6148 0 2.592e-15
Rtr_614_6149 tree_614 tree_6149 0.8192
Cp_6149 tree_6149 0 2.592e-15
Rtr_614_6150 tree_614 tree_6150 0.8192
Cp_6150 tree_6150 0 2.592e-15
Rtr_615_6151 tree_615 tree_6151 0.8192
Cp_6151 tree_6151 0 2.592e-15
Rtr_615_6152 tree_615 tree_6152 0.8192
Cp_6152 tree_6152 0 2.592e-15
Rtr_615_6153 tree_615 tree_6153 0.8192
Cp_6153 tree_6153 0 2.592e-15
Rtr_615_6154 tree_615 tree_6154 0.8192
Cp_6154 tree_6154 0 2.592e-15
Rtr_615_6155 tree_615 tree_6155 0.8192
Cp_6155 tree_6155 0 2.592e-15
Rtr_615_6156 tree_615 tree_6156 0.8192
Cp_6156 tree_6156 0 2.592e-15
Rtr_615_6157 tree_615 tree_6157 0.8192
Cp_6157 tree_6157 0 2.592e-15
Rtr_615_6158 tree_615 tree_6158 0.8192
Cp_6158 tree_6158 0 2.592e-15
Rtr_615_6159 tree_615 tree_6159 0.8192
Cp_6159 tree_6159 0 2.592e-15
Rtr_615_6160 tree_615 tree_6160 0.8192
Cp_6160 tree_6160 0 2.592e-15
Rtr_616_6161 tree_616 tree_6161 0.8192
Cp_6161 tree_6161 0 2.592e-15
Rtr_616_6162 tree_616 tree_6162 0.8192
Cp_6162 tree_6162 0 2.592e-15
Rtr_616_6163 tree_616 tree_6163 0.8192
Cp_6163 tree_6163 0 2.592e-15
Rtr_616_6164 tree_616 tree_6164 0.8192
Cp_6164 tree_6164 0 2.592e-15
Rtr_616_6165 tree_616 tree_6165 0.8192
Cp_6165 tree_6165 0 2.592e-15
Rtr_616_6166 tree_616 tree_6166 0.8192
Cp_6166 tree_6166 0 2.592e-15
Rtr_616_6167 tree_616 tree_6167 0.8192
Cp_6167 tree_6167 0 2.592e-15
Rtr_616_6168 tree_616 tree_6168 0.8192
Cp_6168 tree_6168 0 2.592e-15
Rtr_616_6169 tree_616 tree_6169 0.8192
Cp_6169 tree_6169 0 2.592e-15
Rtr_616_6170 tree_616 tree_6170 0.8192
Cp_6170 tree_6170 0 2.592e-15
Rtr_617_6171 tree_617 tree_6171 0.8192
Cp_6171 tree_6171 0 2.592e-15
Rtr_617_6172 tree_617 tree_6172 0.8192
Cp_6172 tree_6172 0 2.592e-15
Rtr_617_6173 tree_617 tree_6173 0.8192
Cp_6173 tree_6173 0 2.592e-15
Rtr_617_6174 tree_617 tree_6174 0.8192
Cp_6174 tree_6174 0 2.592e-15
Rtr_617_6175 tree_617 tree_6175 0.8192
Cp_6175 tree_6175 0 2.592e-15
Rtr_617_6176 tree_617 tree_6176 0.8192
Cp_6176 tree_6176 0 2.592e-15
Rtr_617_6177 tree_617 tree_6177 0.8192
Cp_6177 tree_6177 0 2.592e-15
Rtr_617_6178 tree_617 tree_6178 0.8192
Cp_6178 tree_6178 0 2.592e-15
Rtr_617_6179 tree_617 tree_6179 0.8192
Cp_6179 tree_6179 0 2.592e-15
Rtr_617_6180 tree_617 tree_6180 0.8192
Cp_6180 tree_6180 0 2.592e-15
Rtr_618_6181 tree_618 tree_6181 0.8192
Cp_6181 tree_6181 0 2.592e-15
Rtr_618_6182 tree_618 tree_6182 0.8192
Cp_6182 tree_6182 0 2.592e-15
Rtr_618_6183 tree_618 tree_6183 0.8192
Cp_6183 tree_6183 0 2.592e-15
Rtr_618_6184 tree_618 tree_6184 0.8192
Cp_6184 tree_6184 0 2.592e-15
Rtr_618_6185 tree_618 tree_6185 0.8192
Cp_6185 tree_6185 0 2.592e-15
Rtr_618_6186 tree_618 tree_6186 0.8192
Cp_6186 tree_6186 0 2.592e-15
Rtr_618_6187 tree_618 tree_6187 0.8192
Cp_6187 tree_6187 0 2.592e-15
Rtr_618_6188 tree_618 tree_6188 0.8192
Cp_6188 tree_6188 0 2.592e-15
Rtr_618_6189 tree_618 tree_6189 0.8192
Cp_6189 tree_6189 0 2.592e-15
Rtr_618_6190 tree_618 tree_6190 0.8192
Cp_6190 tree_6190 0 2.592e-15
Rtr_619_6191 tree_619 tree_6191 0.8192
Cp_6191 tree_6191 0 2.592e-15
Rtr_619_6192 tree_619 tree_6192 0.8192
Cp_6192 tree_6192 0 2.592e-15
Rtr_619_6193 tree_619 tree_6193 0.8192
Cp_6193 tree_6193 0 2.592e-15
Rtr_619_6194 tree_619 tree_6194 0.8192
Cp_6194 tree_6194 0 2.592e-15
Rtr_619_6195 tree_619 tree_6195 0.8192
Cp_6195 tree_6195 0 2.592e-15
Rtr_619_6196 tree_619 tree_6196 0.8192
Cp_6196 tree_6196 0 2.592e-15
Rtr_619_6197 tree_619 tree_6197 0.8192
Cp_6197 tree_6197 0 2.592e-15
Rtr_619_6198 tree_619 tree_6198 0.8192
Cp_6198 tree_6198 0 2.592e-15
Rtr_619_6199 tree_619 tree_6199 0.8192
Cp_6199 tree_6199 0 2.592e-15
Rtr_619_6200 tree_619 tree_6200 0.8192
Cp_6200 tree_6200 0 2.592e-15
Rtr_620_6201 tree_620 tree_6201 0.8192
Cp_6201 tree_6201 0 2.592e-15
Rtr_620_6202 tree_620 tree_6202 0.8192
Cp_6202 tree_6202 0 2.592e-15
Rtr_620_6203 tree_620 tree_6203 0.8192
Cp_6203 tree_6203 0 2.592e-15
Rtr_620_6204 tree_620 tree_6204 0.8192
Cp_6204 tree_6204 0 2.592e-15
Rtr_620_6205 tree_620 tree_6205 0.8192
Cp_6205 tree_6205 0 2.592e-15
Rtr_620_6206 tree_620 tree_6206 0.8192
Cp_6206 tree_6206 0 2.592e-15
Rtr_620_6207 tree_620 tree_6207 0.8192
Cp_6207 tree_6207 0 2.592e-15
Rtr_620_6208 tree_620 tree_6208 0.8192
Cp_6208 tree_6208 0 2.592e-15
Rtr_620_6209 tree_620 tree_6209 0.8192
Cp_6209 tree_6209 0 2.592e-15
Rtr_620_6210 tree_620 tree_6210 0.8192
Cp_6210 tree_6210 0 2.592e-15
Rtr_621_6211 tree_621 tree_6211 0.8192
Cp_6211 tree_6211 0 2.592e-15
Rtr_621_6212 tree_621 tree_6212 0.8192
Cp_6212 tree_6212 0 2.592e-15
Rtr_621_6213 tree_621 tree_6213 0.8192
Cp_6213 tree_6213 0 2.592e-15
Rtr_621_6214 tree_621 tree_6214 0.8192
Cp_6214 tree_6214 0 2.592e-15
Rtr_621_6215 tree_621 tree_6215 0.8192
Cp_6215 tree_6215 0 2.592e-15
Rtr_621_6216 tree_621 tree_6216 0.8192
Cp_6216 tree_6216 0 2.592e-15
Rtr_621_6217 tree_621 tree_6217 0.8192
Cp_6217 tree_6217 0 2.592e-15
Rtr_621_6218 tree_621 tree_6218 0.8192
Cp_6218 tree_6218 0 2.592e-15
Rtr_621_6219 tree_621 tree_6219 0.8192
Cp_6219 tree_6219 0 2.592e-15
Rtr_621_6220 tree_621 tree_6220 0.8192
Cp_6220 tree_6220 0 2.592e-15
Rtr_622_6221 tree_622 tree_6221 0.8192
Cp_6221 tree_6221 0 2.592e-15
Rtr_622_6222 tree_622 tree_6222 0.8192
Cp_6222 tree_6222 0 2.592e-15
Rtr_622_6223 tree_622 tree_6223 0.8192
Cp_6223 tree_6223 0 2.592e-15
Rtr_622_6224 tree_622 tree_6224 0.8192
Cp_6224 tree_6224 0 2.592e-15
Rtr_622_6225 tree_622 tree_6225 0.8192
Cp_6225 tree_6225 0 2.592e-15
Rtr_622_6226 tree_622 tree_6226 0.8192
Cp_6226 tree_6226 0 2.592e-15
Rtr_622_6227 tree_622 tree_6227 0.8192
Cp_6227 tree_6227 0 2.592e-15
Rtr_622_6228 tree_622 tree_6228 0.8192
Cp_6228 tree_6228 0 2.592e-15
Rtr_622_6229 tree_622 tree_6229 0.8192
Cp_6229 tree_6229 0 2.592e-15
Rtr_622_6230 tree_622 tree_6230 0.8192
Cp_6230 tree_6230 0 2.592e-15
Rtr_623_6231 tree_623 tree_6231 0.8192
Cp_6231 tree_6231 0 2.592e-15
Rtr_623_6232 tree_623 tree_6232 0.8192
Cp_6232 tree_6232 0 2.592e-15
Rtr_623_6233 tree_623 tree_6233 0.8192
Cp_6233 tree_6233 0 2.592e-15
Rtr_623_6234 tree_623 tree_6234 0.8192
Cp_6234 tree_6234 0 2.592e-15
Rtr_623_6235 tree_623 tree_6235 0.8192
Cp_6235 tree_6235 0 2.592e-15
Rtr_623_6236 tree_623 tree_6236 0.8192
Cp_6236 tree_6236 0 2.592e-15
Rtr_623_6237 tree_623 tree_6237 0.8192
Cp_6237 tree_6237 0 2.592e-15
Rtr_623_6238 tree_623 tree_6238 0.8192
Cp_6238 tree_6238 0 2.592e-15
Rtr_623_6239 tree_623 tree_6239 0.8192
Cp_6239 tree_6239 0 2.592e-15
Rtr_623_6240 tree_623 tree_6240 0.8192
Cp_6240 tree_6240 0 2.592e-15
Rtr_624_6241 tree_624 tree_6241 0.8192
Cp_6241 tree_6241 0 2.592e-15
Rtr_624_6242 tree_624 tree_6242 0.8192
Cp_6242 tree_6242 0 2.592e-15
Rtr_624_6243 tree_624 tree_6243 0.8192
Cp_6243 tree_6243 0 2.592e-15
Rtr_624_6244 tree_624 tree_6244 0.8192
Cp_6244 tree_6244 0 2.592e-15
Rtr_624_6245 tree_624 tree_6245 0.8192
Cp_6245 tree_6245 0 2.592e-15
Rtr_624_6246 tree_624 tree_6246 0.8192
Cp_6246 tree_6246 0 2.592e-15
Rtr_624_6247 tree_624 tree_6247 0.8192
Cp_6247 tree_6247 0 2.592e-15
Rtr_624_6248 tree_624 tree_6248 0.8192
Cp_6248 tree_6248 0 2.592e-15
Rtr_624_6249 tree_624 tree_6249 0.8192
Cp_6249 tree_6249 0 2.592e-15
Rtr_624_6250 tree_624 tree_6250 0.8192
Cp_6250 tree_6250 0 2.592e-15
Rtr_625_6251 tree_625 tree_6251 0.8192
Cp_6251 tree_6251 0 2.592e-15
Rtr_625_6252 tree_625 tree_6252 0.8192
Cp_6252 tree_6252 0 2.592e-15
Rtr_625_6253 tree_625 tree_6253 0.8192
Cp_6253 tree_6253 0 2.592e-15
Rtr_625_6254 tree_625 tree_6254 0.8192
Cp_6254 tree_6254 0 2.592e-15
Rtr_625_6255 tree_625 tree_6255 0.8192
Cp_6255 tree_6255 0 2.592e-15
Rtr_625_6256 tree_625 tree_6256 0.8192
Cp_6256 tree_6256 0 2.592e-15
Rtr_625_6257 tree_625 tree_6257 0.8192
Cp_6257 tree_6257 0 2.592e-15
Rtr_625_6258 tree_625 tree_6258 0.8192
Cp_6258 tree_6258 0 2.592e-15
Rtr_625_6259 tree_625 tree_6259 0.8192
Cp_6259 tree_6259 0 2.592e-15
Rtr_625_6260 tree_625 tree_6260 0.8192
Cp_6260 tree_6260 0 2.592e-15
Rtr_626_6261 tree_626 tree_6261 0.8192
Cp_6261 tree_6261 0 2.592e-15
Rtr_626_6262 tree_626 tree_6262 0.8192
Cp_6262 tree_6262 0 2.592e-15
Rtr_626_6263 tree_626 tree_6263 0.8192
Cp_6263 tree_6263 0 2.592e-15
Rtr_626_6264 tree_626 tree_6264 0.8192
Cp_6264 tree_6264 0 2.592e-15
Rtr_626_6265 tree_626 tree_6265 0.8192
Cp_6265 tree_6265 0 2.592e-15
Rtr_626_6266 tree_626 tree_6266 0.8192
Cp_6266 tree_6266 0 2.592e-15
Rtr_626_6267 tree_626 tree_6267 0.8192
Cp_6267 tree_6267 0 2.592e-15
Rtr_626_6268 tree_626 tree_6268 0.8192
Cp_6268 tree_6268 0 2.592e-15
Rtr_626_6269 tree_626 tree_6269 0.8192
Cp_6269 tree_6269 0 2.592e-15
Rtr_626_6270 tree_626 tree_6270 0.8192
Cp_6270 tree_6270 0 2.592e-15
Rtr_627_6271 tree_627 tree_6271 0.8192
Cp_6271 tree_6271 0 2.592e-15
Rtr_627_6272 tree_627 tree_6272 0.8192
Cp_6272 tree_6272 0 2.592e-15
Rtr_627_6273 tree_627 tree_6273 0.8192
Cp_6273 tree_6273 0 2.592e-15
Rtr_627_6274 tree_627 tree_6274 0.8192
Cp_6274 tree_6274 0 2.592e-15
Rtr_627_6275 tree_627 tree_6275 0.8192
Cp_6275 tree_6275 0 2.592e-15
Rtr_627_6276 tree_627 tree_6276 0.8192
Cp_6276 tree_6276 0 2.592e-15
Rtr_627_6277 tree_627 tree_6277 0.8192
Cp_6277 tree_6277 0 2.592e-15
Rtr_627_6278 tree_627 tree_6278 0.8192
Cp_6278 tree_6278 0 2.592e-15
Rtr_627_6279 tree_627 tree_6279 0.8192
Cp_6279 tree_6279 0 2.592e-15
Rtr_627_6280 tree_627 tree_6280 0.8192
Cp_6280 tree_6280 0 2.592e-15
Rtr_628_6281 tree_628 tree_6281 0.8192
Cp_6281 tree_6281 0 2.592e-15
Rtr_628_6282 tree_628 tree_6282 0.8192
Cp_6282 tree_6282 0 2.592e-15
Rtr_628_6283 tree_628 tree_6283 0.8192
Cp_6283 tree_6283 0 2.592e-15
Rtr_628_6284 tree_628 tree_6284 0.8192
Cp_6284 tree_6284 0 2.592e-15
Rtr_628_6285 tree_628 tree_6285 0.8192
Cp_6285 tree_6285 0 2.592e-15
Rtr_628_6286 tree_628 tree_6286 0.8192
Cp_6286 tree_6286 0 2.592e-15
Rtr_628_6287 tree_628 tree_6287 0.8192
Cp_6287 tree_6287 0 2.592e-15
Rtr_628_6288 tree_628 tree_6288 0.8192
Cp_6288 tree_6288 0 2.592e-15
Rtr_628_6289 tree_628 tree_6289 0.8192
Cp_6289 tree_6289 0 2.592e-15
Rtr_628_6290 tree_628 tree_6290 0.8192
Cp_6290 tree_6290 0 2.592e-15
Rtr_629_6291 tree_629 tree_6291 0.8192
Cp_6291 tree_6291 0 2.592e-15
Rtr_629_6292 tree_629 tree_6292 0.8192
Cp_6292 tree_6292 0 2.592e-15
Rtr_629_6293 tree_629 tree_6293 0.8192
Cp_6293 tree_6293 0 2.592e-15
Rtr_629_6294 tree_629 tree_6294 0.8192
Cp_6294 tree_6294 0 2.592e-15
Rtr_629_6295 tree_629 tree_6295 0.8192
Cp_6295 tree_6295 0 2.592e-15
Rtr_629_6296 tree_629 tree_6296 0.8192
Cp_6296 tree_6296 0 2.592e-15
Rtr_629_6297 tree_629 tree_6297 0.8192
Cp_6297 tree_6297 0 2.592e-15
Rtr_629_6298 tree_629 tree_6298 0.8192
Cp_6298 tree_6298 0 2.592e-15
Rtr_629_6299 tree_629 tree_6299 0.8192
Cp_6299 tree_6299 0 2.592e-15
Rtr_629_6300 tree_629 tree_6300 0.8192
Cp_6300 tree_6300 0 2.592e-15
Rtr_630_6301 tree_630 tree_6301 0.8192
Cp_6301 tree_6301 0 2.592e-15
Rtr_630_6302 tree_630 tree_6302 0.8192
Cp_6302 tree_6302 0 2.592e-15
Rtr_630_6303 tree_630 tree_6303 0.8192
Cp_6303 tree_6303 0 2.592e-15
Rtr_630_6304 tree_630 tree_6304 0.8192
Cp_6304 tree_6304 0 2.592e-15
Rtr_630_6305 tree_630 tree_6305 0.8192
Cp_6305 tree_6305 0 2.592e-15
Rtr_630_6306 tree_630 tree_6306 0.8192
Cp_6306 tree_6306 0 2.592e-15
Rtr_630_6307 tree_630 tree_6307 0.8192
Cp_6307 tree_6307 0 2.592e-15
Rtr_630_6308 tree_630 tree_6308 0.8192
Cp_6308 tree_6308 0 2.592e-15
Rtr_630_6309 tree_630 tree_6309 0.8192
Cp_6309 tree_6309 0 2.592e-15
Rtr_630_6310 tree_630 tree_6310 0.8192
Cp_6310 tree_6310 0 2.592e-15
Rtr_631_6311 tree_631 tree_6311 0.8192
Cp_6311 tree_6311 0 2.592e-15
Rtr_631_6312 tree_631 tree_6312 0.8192
Cp_6312 tree_6312 0 2.592e-15
Rtr_631_6313 tree_631 tree_6313 0.8192
Cp_6313 tree_6313 0 2.592e-15
Rtr_631_6314 tree_631 tree_6314 0.8192
Cp_6314 tree_6314 0 2.592e-15
Rtr_631_6315 tree_631 tree_6315 0.8192
Cp_6315 tree_6315 0 2.592e-15
Rtr_631_6316 tree_631 tree_6316 0.8192
Cp_6316 tree_6316 0 2.592e-15
Rtr_631_6317 tree_631 tree_6317 0.8192
Cp_6317 tree_6317 0 2.592e-15
Rtr_631_6318 tree_631 tree_6318 0.8192
Cp_6318 tree_6318 0 2.592e-15
Rtr_631_6319 tree_631 tree_6319 0.8192
Cp_6319 tree_6319 0 2.592e-15
Rtr_631_6320 tree_631 tree_6320 0.8192
Cp_6320 tree_6320 0 2.592e-15
Rtr_632_6321 tree_632 tree_6321 0.8192
Cp_6321 tree_6321 0 2.592e-15
Rtr_632_6322 tree_632 tree_6322 0.8192
Cp_6322 tree_6322 0 2.592e-15
Rtr_632_6323 tree_632 tree_6323 0.8192
Cp_6323 tree_6323 0 2.592e-15
Rtr_632_6324 tree_632 tree_6324 0.8192
Cp_6324 tree_6324 0 2.592e-15
Rtr_632_6325 tree_632 tree_6325 0.8192
Cp_6325 tree_6325 0 2.592e-15
Rtr_632_6326 tree_632 tree_6326 0.8192
Cp_6326 tree_6326 0 2.592e-15
Rtr_632_6327 tree_632 tree_6327 0.8192
Cp_6327 tree_6327 0 2.592e-15
Rtr_632_6328 tree_632 tree_6328 0.8192
Cp_6328 tree_6328 0 2.592e-15
Rtr_632_6329 tree_632 tree_6329 0.8192
Cp_6329 tree_6329 0 2.592e-15
Rtr_632_6330 tree_632 tree_6330 0.8192
Cp_6330 tree_6330 0 2.592e-15
Rtr_633_6331 tree_633 tree_6331 0.8192
Cp_6331 tree_6331 0 2.592e-15
Rtr_633_6332 tree_633 tree_6332 0.8192
Cp_6332 tree_6332 0 2.592e-15
Rtr_633_6333 tree_633 tree_6333 0.8192
Cp_6333 tree_6333 0 2.592e-15
Rtr_633_6334 tree_633 tree_6334 0.8192
Cp_6334 tree_6334 0 2.592e-15
Rtr_633_6335 tree_633 tree_6335 0.8192
Cp_6335 tree_6335 0 2.592e-15
Rtr_633_6336 tree_633 tree_6336 0.8192
Cp_6336 tree_6336 0 2.592e-15
Rtr_633_6337 tree_633 tree_6337 0.8192
Cp_6337 tree_6337 0 2.592e-15
Rtr_633_6338 tree_633 tree_6338 0.8192
Cp_6338 tree_6338 0 2.592e-15
Rtr_633_6339 tree_633 tree_6339 0.8192
Cp_6339 tree_6339 0 2.592e-15
Rtr_633_6340 tree_633 tree_6340 0.8192
Cp_6340 tree_6340 0 2.592e-15
Rtr_634_6341 tree_634 tree_6341 0.8192
Cp_6341 tree_6341 0 2.592e-15
Rtr_634_6342 tree_634 tree_6342 0.8192
Cp_6342 tree_6342 0 2.592e-15
Rtr_634_6343 tree_634 tree_6343 0.8192
Cp_6343 tree_6343 0 2.592e-15
Rtr_634_6344 tree_634 tree_6344 0.8192
Cp_6344 tree_6344 0 2.592e-15
Rtr_634_6345 tree_634 tree_6345 0.8192
Cp_6345 tree_6345 0 2.592e-15
Rtr_634_6346 tree_634 tree_6346 0.8192
Cp_6346 tree_6346 0 2.592e-15
Rtr_634_6347 tree_634 tree_6347 0.8192
Cp_6347 tree_6347 0 2.592e-15
Rtr_634_6348 tree_634 tree_6348 0.8192
Cp_6348 tree_6348 0 2.592e-15
Rtr_634_6349 tree_634 tree_6349 0.8192
Cp_6349 tree_6349 0 2.592e-15
Rtr_634_6350 tree_634 tree_6350 0.8192
Cp_6350 tree_6350 0 2.592e-15
Rtr_635_6351 tree_635 tree_6351 0.8192
Cp_6351 tree_6351 0 2.592e-15
Rtr_635_6352 tree_635 tree_6352 0.8192
Cp_6352 tree_6352 0 2.592e-15
Rtr_635_6353 tree_635 tree_6353 0.8192
Cp_6353 tree_6353 0 2.592e-15
Rtr_635_6354 tree_635 tree_6354 0.8192
Cp_6354 tree_6354 0 2.592e-15
Rtr_635_6355 tree_635 tree_6355 0.8192
Cp_6355 tree_6355 0 2.592e-15
Rtr_635_6356 tree_635 tree_6356 0.8192
Cp_6356 tree_6356 0 2.592e-15
Rtr_635_6357 tree_635 tree_6357 0.8192
Cp_6357 tree_6357 0 2.592e-15
Rtr_635_6358 tree_635 tree_6358 0.8192
Cp_6358 tree_6358 0 2.592e-15
Rtr_635_6359 tree_635 tree_6359 0.8192
Cp_6359 tree_6359 0 2.592e-15
Rtr_635_6360 tree_635 tree_6360 0.8192
Cp_6360 tree_6360 0 2.592e-15
Rtr_636_6361 tree_636 tree_6361 0.8192
Cp_6361 tree_6361 0 2.592e-15
Rtr_636_6362 tree_636 tree_6362 0.8192
Cp_6362 tree_6362 0 2.592e-15
Rtr_636_6363 tree_636 tree_6363 0.8192
Cp_6363 tree_6363 0 2.592e-15
Rtr_636_6364 tree_636 tree_6364 0.8192
Cp_6364 tree_6364 0 2.592e-15
Rtr_636_6365 tree_636 tree_6365 0.8192
Cp_6365 tree_6365 0 2.592e-15
Rtr_636_6366 tree_636 tree_6366 0.8192
Cp_6366 tree_6366 0 2.592e-15
Rtr_636_6367 tree_636 tree_6367 0.8192
Cp_6367 tree_6367 0 2.592e-15
Rtr_636_6368 tree_636 tree_6368 0.8192
Cp_6368 tree_6368 0 2.592e-15
Rtr_636_6369 tree_636 tree_6369 0.8192
Cp_6369 tree_6369 0 2.592e-15
Rtr_636_6370 tree_636 tree_6370 0.8192
Cp_6370 tree_6370 0 2.592e-15
Rtr_637_6371 tree_637 tree_6371 0.8192
Cp_6371 tree_6371 0 2.592e-15
Rtr_637_6372 tree_637 tree_6372 0.8192
Cp_6372 tree_6372 0 2.592e-15
Rtr_637_6373 tree_637 tree_6373 0.8192
Cp_6373 tree_6373 0 2.592e-15
Rtr_637_6374 tree_637 tree_6374 0.8192
Cp_6374 tree_6374 0 2.592e-15
Rtr_637_6375 tree_637 tree_6375 0.8192
Cp_6375 tree_6375 0 2.592e-15
Rtr_637_6376 tree_637 tree_6376 0.8192
Cp_6376 tree_6376 0 2.592e-15
Rtr_637_6377 tree_637 tree_6377 0.8192
Cp_6377 tree_6377 0 2.592e-15
Rtr_637_6378 tree_637 tree_6378 0.8192
Cp_6378 tree_6378 0 2.592e-15
Rtr_637_6379 tree_637 tree_6379 0.8192
Cp_6379 tree_6379 0 2.592e-15
Rtr_637_6380 tree_637 tree_6380 0.8192
Cp_6380 tree_6380 0 2.592e-15
Rtr_638_6381 tree_638 tree_6381 0.8192
Cp_6381 tree_6381 0 2.592e-15
Rtr_638_6382 tree_638 tree_6382 0.8192
Cp_6382 tree_6382 0 2.592e-15
Rtr_638_6383 tree_638 tree_6383 0.8192
Cp_6383 tree_6383 0 2.592e-15
Rtr_638_6384 tree_638 tree_6384 0.8192
Cp_6384 tree_6384 0 2.592e-15
Rtr_638_6385 tree_638 tree_6385 0.8192
Cp_6385 tree_6385 0 2.592e-15
Rtr_638_6386 tree_638 tree_6386 0.8192
Cp_6386 tree_6386 0 2.592e-15
Rtr_638_6387 tree_638 tree_6387 0.8192
Cp_6387 tree_6387 0 2.592e-15
Rtr_638_6388 tree_638 tree_6388 0.8192
Cp_6388 tree_6388 0 2.592e-15
Rtr_638_6389 tree_638 tree_6389 0.8192
Cp_6389 tree_6389 0 2.592e-15
Rtr_638_6390 tree_638 tree_6390 0.8192
Cp_6390 tree_6390 0 2.592e-15
Rtr_639_6391 tree_639 tree_6391 0.8192
Cp_6391 tree_6391 0 2.592e-15
Rtr_639_6392 tree_639 tree_6392 0.8192
Cp_6392 tree_6392 0 2.592e-15
Rtr_639_6393 tree_639 tree_6393 0.8192
Cp_6393 tree_6393 0 2.592e-15
Rtr_639_6394 tree_639 tree_6394 0.8192
Cp_6394 tree_6394 0 2.592e-15
Rtr_639_6395 tree_639 tree_6395 0.8192
Cp_6395 tree_6395 0 2.592e-15
Rtr_639_6396 tree_639 tree_6396 0.8192
Cp_6396 tree_6396 0 2.592e-15
Rtr_639_6397 tree_639 tree_6397 0.8192
Cp_6397 tree_6397 0 2.592e-15
Rtr_639_6398 tree_639 tree_6398 0.8192
Cp_6398 tree_6398 0 2.592e-15
Rtr_639_6399 tree_639 tree_6399 0.8192
Cp_6399 tree_6399 0 2.592e-15
Rtr_639_6400 tree_639 tree_6400 0.8192
Cp_6400 tree_6400 0 2.592e-15
Rtr_640_6401 tree_640 tree_6401 0.8192
Cp_6401 tree_6401 0 2.592e-15
Rtr_640_6402 tree_640 tree_6402 0.8192
Cp_6402 tree_6402 0 2.592e-15
Rtr_640_6403 tree_640 tree_6403 0.8192
Cp_6403 tree_6403 0 2.592e-15
Rtr_640_6404 tree_640 tree_6404 0.8192
Cp_6404 tree_6404 0 2.592e-15
Rtr_640_6405 tree_640 tree_6405 0.8192
Cp_6405 tree_6405 0 2.592e-15
Rtr_640_6406 tree_640 tree_6406 0.8192
Cp_6406 tree_6406 0 2.592e-15
Rtr_640_6407 tree_640 tree_6407 0.8192
Cp_6407 tree_6407 0 2.592e-15
Rtr_640_6408 tree_640 tree_6408 0.8192
Cp_6408 tree_6408 0 2.592e-15
Rtr_640_6409 tree_640 tree_6409 0.8192
Cp_6409 tree_6409 0 2.592e-15
Rtr_640_6410 tree_640 tree_6410 0.8192
Cp_6410 tree_6410 0 2.592e-15
Rtr_641_6411 tree_641 tree_6411 0.8192
Cp_6411 tree_6411 0 2.592e-15
Rtr_641_6412 tree_641 tree_6412 0.8192
Cp_6412 tree_6412 0 2.592e-15
Rtr_641_6413 tree_641 tree_6413 0.8192
Cp_6413 tree_6413 0 2.592e-15
Rtr_641_6414 tree_641 tree_6414 0.8192
Cp_6414 tree_6414 0 2.592e-15
Rtr_641_6415 tree_641 tree_6415 0.8192
Cp_6415 tree_6415 0 2.592e-15
Rtr_641_6416 tree_641 tree_6416 0.8192
Cp_6416 tree_6416 0 2.592e-15
Rtr_641_6417 tree_641 tree_6417 0.8192
Cp_6417 tree_6417 0 2.592e-15
Rtr_641_6418 tree_641 tree_6418 0.8192
Cp_6418 tree_6418 0 2.592e-15
Rtr_641_6419 tree_641 tree_6419 0.8192
Cp_6419 tree_6419 0 2.592e-15
Rtr_641_6420 tree_641 tree_6420 0.8192
Cp_6420 tree_6420 0 2.592e-15
Rtr_642_6421 tree_642 tree_6421 0.8192
Cp_6421 tree_6421 0 2.592e-15
Rtr_642_6422 tree_642 tree_6422 0.8192
Cp_6422 tree_6422 0 2.592e-15
Rtr_642_6423 tree_642 tree_6423 0.8192
Cp_6423 tree_6423 0 2.592e-15
Rtr_642_6424 tree_642 tree_6424 0.8192
Cp_6424 tree_6424 0 2.592e-15
Rtr_642_6425 tree_642 tree_6425 0.8192
Cp_6425 tree_6425 0 2.592e-15
Rtr_642_6426 tree_642 tree_6426 0.8192
Cp_6426 tree_6426 0 2.592e-15
Rtr_642_6427 tree_642 tree_6427 0.8192
Cp_6427 tree_6427 0 2.592e-15
Rtr_642_6428 tree_642 tree_6428 0.8192
Cp_6428 tree_6428 0 2.592e-15
Rtr_642_6429 tree_642 tree_6429 0.8192
Cp_6429 tree_6429 0 2.592e-15
Rtr_642_6430 tree_642 tree_6430 0.8192
Cp_6430 tree_6430 0 2.592e-15
Rtr_643_6431 tree_643 tree_6431 0.8192
Cp_6431 tree_6431 0 2.592e-15
Rtr_643_6432 tree_643 tree_6432 0.8192
Cp_6432 tree_6432 0 2.592e-15
Rtr_643_6433 tree_643 tree_6433 0.8192
Cp_6433 tree_6433 0 2.592e-15
Rtr_643_6434 tree_643 tree_6434 0.8192
Cp_6434 tree_6434 0 2.592e-15
Rtr_643_6435 tree_643 tree_6435 0.8192
Cp_6435 tree_6435 0 2.592e-15
Rtr_643_6436 tree_643 tree_6436 0.8192
Cp_6436 tree_6436 0 2.592e-15
Rtr_643_6437 tree_643 tree_6437 0.8192
Cp_6437 tree_6437 0 2.592e-15
Rtr_643_6438 tree_643 tree_6438 0.8192
Cp_6438 tree_6438 0 2.592e-15
Rtr_643_6439 tree_643 tree_6439 0.8192
Cp_6439 tree_6439 0 2.592e-15
Rtr_643_6440 tree_643 tree_6440 0.8192
Cp_6440 tree_6440 0 2.592e-15
Rtr_644_6441 tree_644 tree_6441 0.8192
Cp_6441 tree_6441 0 2.592e-15
Rtr_644_6442 tree_644 tree_6442 0.8192
Cp_6442 tree_6442 0 2.592e-15
Rtr_644_6443 tree_644 tree_6443 0.8192
Cp_6443 tree_6443 0 2.592e-15
Rtr_644_6444 tree_644 tree_6444 0.8192
Cp_6444 tree_6444 0 2.592e-15
Rtr_644_6445 tree_644 tree_6445 0.8192
Cp_6445 tree_6445 0 2.592e-15
Rtr_644_6446 tree_644 tree_6446 0.8192
Cp_6446 tree_6446 0 2.592e-15
Rtr_644_6447 tree_644 tree_6447 0.8192
Cp_6447 tree_6447 0 2.592e-15
Rtr_644_6448 tree_644 tree_6448 0.8192
Cp_6448 tree_6448 0 2.592e-15
Rtr_644_6449 tree_644 tree_6449 0.8192
Cp_6449 tree_6449 0 2.592e-15
Rtr_644_6450 tree_644 tree_6450 0.8192
Cp_6450 tree_6450 0 2.592e-15
Rtr_645_6451 tree_645 tree_6451 0.8192
Cp_6451 tree_6451 0 2.592e-15
Rtr_645_6452 tree_645 tree_6452 0.8192
Cp_6452 tree_6452 0 2.592e-15
Rtr_645_6453 tree_645 tree_6453 0.8192
Cp_6453 tree_6453 0 2.592e-15
Rtr_645_6454 tree_645 tree_6454 0.8192
Cp_6454 tree_6454 0 2.592e-15
Rtr_645_6455 tree_645 tree_6455 0.8192
Cp_6455 tree_6455 0 2.592e-15
Rtr_645_6456 tree_645 tree_6456 0.8192
Cp_6456 tree_6456 0 2.592e-15
Rtr_645_6457 tree_645 tree_6457 0.8192
Cp_6457 tree_6457 0 2.592e-15
Rtr_645_6458 tree_645 tree_6458 0.8192
Cp_6458 tree_6458 0 2.592e-15
Rtr_645_6459 tree_645 tree_6459 0.8192
Cp_6459 tree_6459 0 2.592e-15
Rtr_645_6460 tree_645 tree_6460 0.8192
Cp_6460 tree_6460 0 2.592e-15
Rtr_646_6461 tree_646 tree_6461 0.8192
Cp_6461 tree_6461 0 2.592e-15
Rtr_646_6462 tree_646 tree_6462 0.8192
Cp_6462 tree_6462 0 2.592e-15
Rtr_646_6463 tree_646 tree_6463 0.8192
Cp_6463 tree_6463 0 2.592e-15
Rtr_646_6464 tree_646 tree_6464 0.8192
Cp_6464 tree_6464 0 2.592e-15
Rtr_646_6465 tree_646 tree_6465 0.8192
Cp_6465 tree_6465 0 2.592e-15
Rtr_646_6466 tree_646 tree_6466 0.8192
Cp_6466 tree_6466 0 2.592e-15
Rtr_646_6467 tree_646 tree_6467 0.8192
Cp_6467 tree_6467 0 2.592e-15
Rtr_646_6468 tree_646 tree_6468 0.8192
Cp_6468 tree_6468 0 2.592e-15
Rtr_646_6469 tree_646 tree_6469 0.8192
Cp_6469 tree_6469 0 2.592e-15
Rtr_646_6470 tree_646 tree_6470 0.8192
Cp_6470 tree_6470 0 2.592e-15
Rtr_647_6471 tree_647 tree_6471 0.8192
Cp_6471 tree_6471 0 2.592e-15
Rtr_647_6472 tree_647 tree_6472 0.8192
Cp_6472 tree_6472 0 2.592e-15
Rtr_647_6473 tree_647 tree_6473 0.8192
Cp_6473 tree_6473 0 2.592e-15
Rtr_647_6474 tree_647 tree_6474 0.8192
Cp_6474 tree_6474 0 2.592e-15
Rtr_647_6475 tree_647 tree_6475 0.8192
Cp_6475 tree_6475 0 2.592e-15
Rtr_647_6476 tree_647 tree_6476 0.8192
Cp_6476 tree_6476 0 2.592e-15
Rtr_647_6477 tree_647 tree_6477 0.8192
Cp_6477 tree_6477 0 2.592e-15
Rtr_647_6478 tree_647 tree_6478 0.8192
Cp_6478 tree_6478 0 2.592e-15
Rtr_647_6479 tree_647 tree_6479 0.8192
Cp_6479 tree_6479 0 2.592e-15
Rtr_647_6480 tree_647 tree_6480 0.8192
Cp_6480 tree_6480 0 2.592e-15
Rtr_648_6481 tree_648 tree_6481 0.8192
Cp_6481 tree_6481 0 2.592e-15
Rtr_648_6482 tree_648 tree_6482 0.8192
Cp_6482 tree_6482 0 2.592e-15
Rtr_648_6483 tree_648 tree_6483 0.8192
Cp_6483 tree_6483 0 2.592e-15
Rtr_648_6484 tree_648 tree_6484 0.8192
Cp_6484 tree_6484 0 2.592e-15
Rtr_648_6485 tree_648 tree_6485 0.8192
Cp_6485 tree_6485 0 2.592e-15
Rtr_648_6486 tree_648 tree_6486 0.8192
Cp_6486 tree_6486 0 2.592e-15
Rtr_648_6487 tree_648 tree_6487 0.8192
Cp_6487 tree_6487 0 2.592e-15
Rtr_648_6488 tree_648 tree_6488 0.8192
Cp_6488 tree_6488 0 2.592e-15
Rtr_648_6489 tree_648 tree_6489 0.8192
Cp_6489 tree_6489 0 2.592e-15
Rtr_648_6490 tree_648 tree_6490 0.8192
Cp_6490 tree_6490 0 2.592e-15
Rtr_649_6491 tree_649 tree_6491 0.8192
Cp_6491 tree_6491 0 2.592e-15
Rtr_649_6492 tree_649 tree_6492 0.8192
Cp_6492 tree_6492 0 2.592e-15
Rtr_649_6493 tree_649 tree_6493 0.8192
Cp_6493 tree_6493 0 2.592e-15
Rtr_649_6494 tree_649 tree_6494 0.8192
Cp_6494 tree_6494 0 2.592e-15
Rtr_649_6495 tree_649 tree_6495 0.8192
Cp_6495 tree_6495 0 2.592e-15
Rtr_649_6496 tree_649 tree_6496 0.8192
Cp_6496 tree_6496 0 2.592e-15
Rtr_649_6497 tree_649 tree_6497 0.8192
Cp_6497 tree_6497 0 2.592e-15
Rtr_649_6498 tree_649 tree_6498 0.8192
Cp_6498 tree_6498 0 2.592e-15
Rtr_649_6499 tree_649 tree_6499 0.8192
Cp_6499 tree_6499 0 2.592e-15
Rtr_649_6500 tree_649 tree_6500 0.8192
Cp_6500 tree_6500 0 2.592e-15
Rtr_650_6501 tree_650 tree_6501 0.8192
Cp_6501 tree_6501 0 2.592e-15
Rtr_650_6502 tree_650 tree_6502 0.8192
Cp_6502 tree_6502 0 2.592e-15
Rtr_650_6503 tree_650 tree_6503 0.8192
Cp_6503 tree_6503 0 2.592e-15
Rtr_650_6504 tree_650 tree_6504 0.8192
Cp_6504 tree_6504 0 2.592e-15
Rtr_650_6505 tree_650 tree_6505 0.8192
Cp_6505 tree_6505 0 2.592e-15
Rtr_650_6506 tree_650 tree_6506 0.8192
Cp_6506 tree_6506 0 2.592e-15
Rtr_650_6507 tree_650 tree_6507 0.8192
Cp_6507 tree_6507 0 2.592e-15
Rtr_650_6508 tree_650 tree_6508 0.8192
Cp_6508 tree_6508 0 2.592e-15
Rtr_650_6509 tree_650 tree_6509 0.8192
Cp_6509 tree_6509 0 2.592e-15
Rtr_650_6510 tree_650 tree_6510 0.8192
Cp_6510 tree_6510 0 2.592e-15
Rtr_651_6511 tree_651 tree_6511 0.8192
Cp_6511 tree_6511 0 2.592e-15
Rtr_651_6512 tree_651 tree_6512 0.8192
Cp_6512 tree_6512 0 2.592e-15
Rtr_651_6513 tree_651 tree_6513 0.8192
Cp_6513 tree_6513 0 2.592e-15
Rtr_651_6514 tree_651 tree_6514 0.8192
Cp_6514 tree_6514 0 2.592e-15
Rtr_651_6515 tree_651 tree_6515 0.8192
Cp_6515 tree_6515 0 2.592e-15
Rtr_651_6516 tree_651 tree_6516 0.8192
Cp_6516 tree_6516 0 2.592e-15
Rtr_651_6517 tree_651 tree_6517 0.8192
Cp_6517 tree_6517 0 2.592e-15
Rtr_651_6518 tree_651 tree_6518 0.8192
Cp_6518 tree_6518 0 2.592e-15
Rtr_651_6519 tree_651 tree_6519 0.8192
Cp_6519 tree_6519 0 2.592e-15
Rtr_651_6520 tree_651 tree_6520 0.8192
Cp_6520 tree_6520 0 2.592e-15
Rtr_652_6521 tree_652 tree_6521 0.8192
Cp_6521 tree_6521 0 2.592e-15
Rtr_652_6522 tree_652 tree_6522 0.8192
Cp_6522 tree_6522 0 2.592e-15
Rtr_652_6523 tree_652 tree_6523 0.8192
Cp_6523 tree_6523 0 2.592e-15
Rtr_652_6524 tree_652 tree_6524 0.8192
Cp_6524 tree_6524 0 2.592e-15
Rtr_652_6525 tree_652 tree_6525 0.8192
Cp_6525 tree_6525 0 2.592e-15
Rtr_652_6526 tree_652 tree_6526 0.8192
Cp_6526 tree_6526 0 2.592e-15
Rtr_652_6527 tree_652 tree_6527 0.8192
Cp_6527 tree_6527 0 2.592e-15
Rtr_652_6528 tree_652 tree_6528 0.8192
Cp_6528 tree_6528 0 2.592e-15
Rtr_652_6529 tree_652 tree_6529 0.8192
Cp_6529 tree_6529 0 2.592e-15
Rtr_652_6530 tree_652 tree_6530 0.8192
Cp_6530 tree_6530 0 2.592e-15
Rtr_653_6531 tree_653 tree_6531 0.8192
Cp_6531 tree_6531 0 2.592e-15
Rtr_653_6532 tree_653 tree_6532 0.8192
Cp_6532 tree_6532 0 2.592e-15
Rtr_653_6533 tree_653 tree_6533 0.8192
Cp_6533 tree_6533 0 2.592e-15
Rtr_653_6534 tree_653 tree_6534 0.8192
Cp_6534 tree_6534 0 2.592e-15
Rtr_653_6535 tree_653 tree_6535 0.8192
Cp_6535 tree_6535 0 2.592e-15
Rtr_653_6536 tree_653 tree_6536 0.8192
Cp_6536 tree_6536 0 2.592e-15
Rtr_653_6537 tree_653 tree_6537 0.8192
Cp_6537 tree_6537 0 2.592e-15
Rtr_653_6538 tree_653 tree_6538 0.8192
Cp_6538 tree_6538 0 2.592e-15
Rtr_653_6539 tree_653 tree_6539 0.8192
Cp_6539 tree_6539 0 2.592e-15
Rtr_653_6540 tree_653 tree_6540 0.8192
Cp_6540 tree_6540 0 2.592e-15
Rtr_654_6541 tree_654 tree_6541 0.8192
Cp_6541 tree_6541 0 2.592e-15
Rtr_654_6542 tree_654 tree_6542 0.8192
Cp_6542 tree_6542 0 2.592e-15
Rtr_654_6543 tree_654 tree_6543 0.8192
Cp_6543 tree_6543 0 2.592e-15
Rtr_654_6544 tree_654 tree_6544 0.8192
Cp_6544 tree_6544 0 2.592e-15
Rtr_654_6545 tree_654 tree_6545 0.8192
Cp_6545 tree_6545 0 2.592e-15
Rtr_654_6546 tree_654 tree_6546 0.8192
Cp_6546 tree_6546 0 2.592e-15
Rtr_654_6547 tree_654 tree_6547 0.8192
Cp_6547 tree_6547 0 2.592e-15
Rtr_654_6548 tree_654 tree_6548 0.8192
Cp_6548 tree_6548 0 2.592e-15
Rtr_654_6549 tree_654 tree_6549 0.8192
Cp_6549 tree_6549 0 2.592e-15
Rtr_654_6550 tree_654 tree_6550 0.8192
Cp_6550 tree_6550 0 2.592e-15
Rtr_655_6551 tree_655 tree_6551 0.8192
Cp_6551 tree_6551 0 2.592e-15
Rtr_655_6552 tree_655 tree_6552 0.8192
Cp_6552 tree_6552 0 2.592e-15
Rtr_655_6553 tree_655 tree_6553 0.8192
Cp_6553 tree_6553 0 2.592e-15
Rtr_655_6554 tree_655 tree_6554 0.8192
Cp_6554 tree_6554 0 2.592e-15
Rtr_655_6555 tree_655 tree_6555 0.8192
Cp_6555 tree_6555 0 2.592e-15
Rtr_655_6556 tree_655 tree_6556 0.8192
Cp_6556 tree_6556 0 2.592e-15
Rtr_655_6557 tree_655 tree_6557 0.8192
Cp_6557 tree_6557 0 2.592e-15
Rtr_655_6558 tree_655 tree_6558 0.8192
Cp_6558 tree_6558 0 2.592e-15
Rtr_655_6559 tree_655 tree_6559 0.8192
Cp_6559 tree_6559 0 2.592e-15
Rtr_655_6560 tree_655 tree_6560 0.8192
Cp_6560 tree_6560 0 2.592e-15
Rtr_656_6561 tree_656 tree_6561 0.8192
Cp_6561 tree_6561 0 2.592e-15
Rtr_656_6562 tree_656 tree_6562 0.8192
Cp_6562 tree_6562 0 2.592e-15
Rtr_656_6563 tree_656 tree_6563 0.8192
Cp_6563 tree_6563 0 2.592e-15
Rtr_656_6564 tree_656 tree_6564 0.8192
Cp_6564 tree_6564 0 2.592e-15
Rtr_656_6565 tree_656 tree_6565 0.8192
Cp_6565 tree_6565 0 2.592e-15
Rtr_656_6566 tree_656 tree_6566 0.8192
Cp_6566 tree_6566 0 2.592e-15
Rtr_656_6567 tree_656 tree_6567 0.8192
Cp_6567 tree_6567 0 2.592e-15
Rtr_656_6568 tree_656 tree_6568 0.8192
Cp_6568 tree_6568 0 2.592e-15
Rtr_656_6569 tree_656 tree_6569 0.8192
Cp_6569 tree_6569 0 2.592e-15
Rtr_656_6570 tree_656 tree_6570 0.8192
Cp_6570 tree_6570 0 2.592e-15
Rtr_657_6571 tree_657 tree_6571 0.8192
Cp_6571 tree_6571 0 2.592e-15
Rtr_657_6572 tree_657 tree_6572 0.8192
Cp_6572 tree_6572 0 2.592e-15
Rtr_657_6573 tree_657 tree_6573 0.8192
Cp_6573 tree_6573 0 2.592e-15
Rtr_657_6574 tree_657 tree_6574 0.8192
Cp_6574 tree_6574 0 2.592e-15
Rtr_657_6575 tree_657 tree_6575 0.8192
Cp_6575 tree_6575 0 2.592e-15
Rtr_657_6576 tree_657 tree_6576 0.8192
Cp_6576 tree_6576 0 2.592e-15
Rtr_657_6577 tree_657 tree_6577 0.8192
Cp_6577 tree_6577 0 2.592e-15
Rtr_657_6578 tree_657 tree_6578 0.8192
Cp_6578 tree_6578 0 2.592e-15
Rtr_657_6579 tree_657 tree_6579 0.8192
Cp_6579 tree_6579 0 2.592e-15
Rtr_657_6580 tree_657 tree_6580 0.8192
Cp_6580 tree_6580 0 2.592e-15
Rtr_658_6581 tree_658 tree_6581 0.8192
Cp_6581 tree_6581 0 2.592e-15
Rtr_658_6582 tree_658 tree_6582 0.8192
Cp_6582 tree_6582 0 2.592e-15
Rtr_658_6583 tree_658 tree_6583 0.8192
Cp_6583 tree_6583 0 2.592e-15
Rtr_658_6584 tree_658 tree_6584 0.8192
Cp_6584 tree_6584 0 2.592e-15
Rtr_658_6585 tree_658 tree_6585 0.8192
Cp_6585 tree_6585 0 2.592e-15
Rtr_658_6586 tree_658 tree_6586 0.8192
Cp_6586 tree_6586 0 2.592e-15
Rtr_658_6587 tree_658 tree_6587 0.8192
Cp_6587 tree_6587 0 2.592e-15
Rtr_658_6588 tree_658 tree_6588 0.8192
Cp_6588 tree_6588 0 2.592e-15
Rtr_658_6589 tree_658 tree_6589 0.8192
Cp_6589 tree_6589 0 2.592e-15
Rtr_658_6590 tree_658 tree_6590 0.8192
Cp_6590 tree_6590 0 2.592e-15
Rtr_659_6591 tree_659 tree_6591 0.8192
Cp_6591 tree_6591 0 2.592e-15
Rtr_659_6592 tree_659 tree_6592 0.8192
Cp_6592 tree_6592 0 2.592e-15
Rtr_659_6593 tree_659 tree_6593 0.8192
Cp_6593 tree_6593 0 2.592e-15
Rtr_659_6594 tree_659 tree_6594 0.8192
Cp_6594 tree_6594 0 2.592e-15
Rtr_659_6595 tree_659 tree_6595 0.8192
Cp_6595 tree_6595 0 2.592e-15
Rtr_659_6596 tree_659 tree_6596 0.8192
Cp_6596 tree_6596 0 2.592e-15
Rtr_659_6597 tree_659 tree_6597 0.8192
Cp_6597 tree_6597 0 2.592e-15
Rtr_659_6598 tree_659 tree_6598 0.8192
Cp_6598 tree_6598 0 2.592e-15
Rtr_659_6599 tree_659 tree_6599 0.8192
Cp_6599 tree_6599 0 2.592e-15
Rtr_659_6600 tree_659 tree_6600 0.8192
Cp_6600 tree_6600 0 2.592e-15
Rtr_660_6601 tree_660 tree_6601 0.8192
Cp_6601 tree_6601 0 2.592e-15
Rtr_660_6602 tree_660 tree_6602 0.8192
Cp_6602 tree_6602 0 2.592e-15
Rtr_660_6603 tree_660 tree_6603 0.8192
Cp_6603 tree_6603 0 2.592e-15
Rtr_660_6604 tree_660 tree_6604 0.8192
Cp_6604 tree_6604 0 2.592e-15
Rtr_660_6605 tree_660 tree_6605 0.8192
Cp_6605 tree_6605 0 2.592e-15
Rtr_660_6606 tree_660 tree_6606 0.8192
Cp_6606 tree_6606 0 2.592e-15
Rtr_660_6607 tree_660 tree_6607 0.8192
Cp_6607 tree_6607 0 2.592e-15
Rtr_660_6608 tree_660 tree_6608 0.8192
Cp_6608 tree_6608 0 2.592e-15
Rtr_660_6609 tree_660 tree_6609 0.8192
Cp_6609 tree_6609 0 2.592e-15
Rtr_660_6610 tree_660 tree_6610 0.8192
Cp_6610 tree_6610 0 2.592e-15
Rtr_661_6611 tree_661 tree_6611 0.8192
Cp_6611 tree_6611 0 2.592e-15
Rtr_661_6612 tree_661 tree_6612 0.8192
Cp_6612 tree_6612 0 2.592e-15
Rtr_661_6613 tree_661 tree_6613 0.8192
Cp_6613 tree_6613 0 2.592e-15
Rtr_661_6614 tree_661 tree_6614 0.8192
Cp_6614 tree_6614 0 2.592e-15
Rtr_661_6615 tree_661 tree_6615 0.8192
Cp_6615 tree_6615 0 2.592e-15
Rtr_661_6616 tree_661 tree_6616 0.8192
Cp_6616 tree_6616 0 2.592e-15
Rtr_661_6617 tree_661 tree_6617 0.8192
Cp_6617 tree_6617 0 2.592e-15
Rtr_661_6618 tree_661 tree_6618 0.8192
Cp_6618 tree_6618 0 2.592e-15
Rtr_661_6619 tree_661 tree_6619 0.8192
Cp_6619 tree_6619 0 2.592e-15
Rtr_661_6620 tree_661 tree_6620 0.8192
Cp_6620 tree_6620 0 2.592e-15
Rtr_662_6621 tree_662 tree_6621 0.8192
Cp_6621 tree_6621 0 2.592e-15
Rtr_662_6622 tree_662 tree_6622 0.8192
Cp_6622 tree_6622 0 2.592e-15
Rtr_662_6623 tree_662 tree_6623 0.8192
Cp_6623 tree_6623 0 2.592e-15
Rtr_662_6624 tree_662 tree_6624 0.8192
Cp_6624 tree_6624 0 2.592e-15
Rtr_662_6625 tree_662 tree_6625 0.8192
Cp_6625 tree_6625 0 2.592e-15
Rtr_662_6626 tree_662 tree_6626 0.8192
Cp_6626 tree_6626 0 2.592e-15
Rtr_662_6627 tree_662 tree_6627 0.8192
Cp_6627 tree_6627 0 2.592e-15
Rtr_662_6628 tree_662 tree_6628 0.8192
Cp_6628 tree_6628 0 2.592e-15
Rtr_662_6629 tree_662 tree_6629 0.8192
Cp_6629 tree_6629 0 2.592e-15
Rtr_662_6630 tree_662 tree_6630 0.8192
Cp_6630 tree_6630 0 2.592e-15
Rtr_663_6631 tree_663 tree_6631 0.8192
Cp_6631 tree_6631 0 2.592e-15
Rtr_663_6632 tree_663 tree_6632 0.8192
Cp_6632 tree_6632 0 2.592e-15
Rtr_663_6633 tree_663 tree_6633 0.8192
Cp_6633 tree_6633 0 2.592e-15
Rtr_663_6634 tree_663 tree_6634 0.8192
Cp_6634 tree_6634 0 2.592e-15
Rtr_663_6635 tree_663 tree_6635 0.8192
Cp_6635 tree_6635 0 2.592e-15
Rtr_663_6636 tree_663 tree_6636 0.8192
Cp_6636 tree_6636 0 2.592e-15
Rtr_663_6637 tree_663 tree_6637 0.8192
Cp_6637 tree_6637 0 2.592e-15
Rtr_663_6638 tree_663 tree_6638 0.8192
Cp_6638 tree_6638 0 2.592e-15
Rtr_663_6639 tree_663 tree_6639 0.8192
Cp_6639 tree_6639 0 2.592e-15
Rtr_663_6640 tree_663 tree_6640 0.8192
Cp_6640 tree_6640 0 2.592e-15
Rtr_664_6641 tree_664 tree_6641 0.8192
Cp_6641 tree_6641 0 2.592e-15
Rtr_664_6642 tree_664 tree_6642 0.8192
Cp_6642 tree_6642 0 2.592e-15
Rtr_664_6643 tree_664 tree_6643 0.8192
Cp_6643 tree_6643 0 2.592e-15
Rtr_664_6644 tree_664 tree_6644 0.8192
Cp_6644 tree_6644 0 2.592e-15
Rtr_664_6645 tree_664 tree_6645 0.8192
Cp_6645 tree_6645 0 2.592e-15
Rtr_664_6646 tree_664 tree_6646 0.8192
Cp_6646 tree_6646 0 2.592e-15
Rtr_664_6647 tree_664 tree_6647 0.8192
Cp_6647 tree_6647 0 2.592e-15
Rtr_664_6648 tree_664 tree_6648 0.8192
Cp_6648 tree_6648 0 2.592e-15
Rtr_664_6649 tree_664 tree_6649 0.8192
Cp_6649 tree_6649 0 2.592e-15
Rtr_664_6650 tree_664 tree_6650 0.8192
Cp_6650 tree_6650 0 2.592e-15
Rtr_665_6651 tree_665 tree_6651 0.8192
Cp_6651 tree_6651 0 2.592e-15
Rtr_665_6652 tree_665 tree_6652 0.8192
Cp_6652 tree_6652 0 2.592e-15
Rtr_665_6653 tree_665 tree_6653 0.8192
Cp_6653 tree_6653 0 2.592e-15
Rtr_665_6654 tree_665 tree_6654 0.8192
Cp_6654 tree_6654 0 2.592e-15
Rtr_665_6655 tree_665 tree_6655 0.8192
Cp_6655 tree_6655 0 2.592e-15
Rtr_665_6656 tree_665 tree_6656 0.8192
Cp_6656 tree_6656 0 2.592e-15
Rtr_665_6657 tree_665 tree_6657 0.8192
Cp_6657 tree_6657 0 2.592e-15
Rtr_665_6658 tree_665 tree_6658 0.8192
Cp_6658 tree_6658 0 2.592e-15
Rtr_665_6659 tree_665 tree_6659 0.8192
Cp_6659 tree_6659 0 2.592e-15
Rtr_665_6660 tree_665 tree_6660 0.8192
Cp_6660 tree_6660 0 2.592e-15
Rtr_666_6661 tree_666 tree_6661 0.8192
Cp_6661 tree_6661 0 2.592e-15
Rtr_666_6662 tree_666 tree_6662 0.8192
Cp_6662 tree_6662 0 2.592e-15
Rtr_666_6663 tree_666 tree_6663 0.8192
Cp_6663 tree_6663 0 2.592e-15
Rtr_666_6664 tree_666 tree_6664 0.8192
Cp_6664 tree_6664 0 2.592e-15
Rtr_666_6665 tree_666 tree_6665 0.8192
Cp_6665 tree_6665 0 2.592e-15
Rtr_666_6666 tree_666 tree_6666 0.8192
Cp_6666 tree_6666 0 2.592e-15
Rtr_666_6667 tree_666 tree_6667 0.8192
Cp_6667 tree_6667 0 2.592e-15
Rtr_666_6668 tree_666 tree_6668 0.8192
Cp_6668 tree_6668 0 2.592e-15
Rtr_666_6669 tree_666 tree_6669 0.8192
Cp_6669 tree_6669 0 2.592e-15
Rtr_666_6670 tree_666 tree_6670 0.8192
Cp_6670 tree_6670 0 2.592e-15
Rtr_667_6671 tree_667 tree_6671 0.8192
Cp_6671 tree_6671 0 2.592e-15
Rtr_667_6672 tree_667 tree_6672 0.8192
Cp_6672 tree_6672 0 2.592e-15
Rtr_667_6673 tree_667 tree_6673 0.8192
Cp_6673 tree_6673 0 2.592e-15
Rtr_667_6674 tree_667 tree_6674 0.8192
Cp_6674 tree_6674 0 2.592e-15
Rtr_667_6675 tree_667 tree_6675 0.8192
Cp_6675 tree_6675 0 2.592e-15
Rtr_667_6676 tree_667 tree_6676 0.8192
Cp_6676 tree_6676 0 2.592e-15
Rtr_667_6677 tree_667 tree_6677 0.8192
Cp_6677 tree_6677 0 2.592e-15
Rtr_667_6678 tree_667 tree_6678 0.8192
Cp_6678 tree_6678 0 2.592e-15
Rtr_667_6679 tree_667 tree_6679 0.8192
Cp_6679 tree_6679 0 2.592e-15
Rtr_667_6680 tree_667 tree_6680 0.8192
Cp_6680 tree_6680 0 2.592e-15
Rtr_668_6681 tree_668 tree_6681 0.8192
Cp_6681 tree_6681 0 2.592e-15
Rtr_668_6682 tree_668 tree_6682 0.8192
Cp_6682 tree_6682 0 2.592e-15
Rtr_668_6683 tree_668 tree_6683 0.8192
Cp_6683 tree_6683 0 2.592e-15
Rtr_668_6684 tree_668 tree_6684 0.8192
Cp_6684 tree_6684 0 2.592e-15
Rtr_668_6685 tree_668 tree_6685 0.8192
Cp_6685 tree_6685 0 2.592e-15
Rtr_668_6686 tree_668 tree_6686 0.8192
Cp_6686 tree_6686 0 2.592e-15
Rtr_668_6687 tree_668 tree_6687 0.8192
Cp_6687 tree_6687 0 2.592e-15
Rtr_668_6688 tree_668 tree_6688 0.8192
Cp_6688 tree_6688 0 2.592e-15
Rtr_668_6689 tree_668 tree_6689 0.8192
Cp_6689 tree_6689 0 2.592e-15
Rtr_668_6690 tree_668 tree_6690 0.8192
Cp_6690 tree_6690 0 2.592e-15
Rtr_669_6691 tree_669 tree_6691 0.8192
Cp_6691 tree_6691 0 2.592e-15
Rtr_669_6692 tree_669 tree_6692 0.8192
Cp_6692 tree_6692 0 2.592e-15
Rtr_669_6693 tree_669 tree_6693 0.8192
Cp_6693 tree_6693 0 2.592e-15
Rtr_669_6694 tree_669 tree_6694 0.8192
Cp_6694 tree_6694 0 2.592e-15
Rtr_669_6695 tree_669 tree_6695 0.8192
Cp_6695 tree_6695 0 2.592e-15
Rtr_669_6696 tree_669 tree_6696 0.8192
Cp_6696 tree_6696 0 2.592e-15
Rtr_669_6697 tree_669 tree_6697 0.8192
Cp_6697 tree_6697 0 2.592e-15
Rtr_669_6698 tree_669 tree_6698 0.8192
Cp_6698 tree_6698 0 2.592e-15
Rtr_669_6699 tree_669 tree_6699 0.8192
Cp_6699 tree_6699 0 2.592e-15
Rtr_669_6700 tree_669 tree_6700 0.8192
Cp_6700 tree_6700 0 2.592e-15
Rtr_670_6701 tree_670 tree_6701 0.8192
Cp_6701 tree_6701 0 2.592e-15
Rtr_670_6702 tree_670 tree_6702 0.8192
Cp_6702 tree_6702 0 2.592e-15
Rtr_670_6703 tree_670 tree_6703 0.8192
Cp_6703 tree_6703 0 2.592e-15
Rtr_670_6704 tree_670 tree_6704 0.8192
Cp_6704 tree_6704 0 2.592e-15
Rtr_670_6705 tree_670 tree_6705 0.8192
Cp_6705 tree_6705 0 2.592e-15
Rtr_670_6706 tree_670 tree_6706 0.8192
Cp_6706 tree_6706 0 2.592e-15
Rtr_670_6707 tree_670 tree_6707 0.8192
Cp_6707 tree_6707 0 2.592e-15
Rtr_670_6708 tree_670 tree_6708 0.8192
Cp_6708 tree_6708 0 2.592e-15
Rtr_670_6709 tree_670 tree_6709 0.8192
Cp_6709 tree_6709 0 2.592e-15
Rtr_670_6710 tree_670 tree_6710 0.8192
Cp_6710 tree_6710 0 2.592e-15
Rtr_671_6711 tree_671 tree_6711 0.8192
Cp_6711 tree_6711 0 2.592e-15
Rtr_671_6712 tree_671 tree_6712 0.8192
Cp_6712 tree_6712 0 2.592e-15
Rtr_671_6713 tree_671 tree_6713 0.8192
Cp_6713 tree_6713 0 2.592e-15
Rtr_671_6714 tree_671 tree_6714 0.8192
Cp_6714 tree_6714 0 2.592e-15
Rtr_671_6715 tree_671 tree_6715 0.8192
Cp_6715 tree_6715 0 2.592e-15
Rtr_671_6716 tree_671 tree_6716 0.8192
Cp_6716 tree_6716 0 2.592e-15
Rtr_671_6717 tree_671 tree_6717 0.8192
Cp_6717 tree_6717 0 2.592e-15
Rtr_671_6718 tree_671 tree_6718 0.8192
Cp_6718 tree_6718 0 2.592e-15
Rtr_671_6719 tree_671 tree_6719 0.8192
Cp_6719 tree_6719 0 2.592e-15
Rtr_671_6720 tree_671 tree_6720 0.8192
Cp_6720 tree_6720 0 2.592e-15
Rtr_672_6721 tree_672 tree_6721 0.8192
Cp_6721 tree_6721 0 2.592e-15
Rtr_672_6722 tree_672 tree_6722 0.8192
Cp_6722 tree_6722 0 2.592e-15
Rtr_672_6723 tree_672 tree_6723 0.8192
Cp_6723 tree_6723 0 2.592e-15
Rtr_672_6724 tree_672 tree_6724 0.8192
Cp_6724 tree_6724 0 2.592e-15
Rtr_672_6725 tree_672 tree_6725 0.8192
Cp_6725 tree_6725 0 2.592e-15
Rtr_672_6726 tree_672 tree_6726 0.8192
Cp_6726 tree_6726 0 2.592e-15
Rtr_672_6727 tree_672 tree_6727 0.8192
Cp_6727 tree_6727 0 2.592e-15
Rtr_672_6728 tree_672 tree_6728 0.8192
Cp_6728 tree_6728 0 2.592e-15
Rtr_672_6729 tree_672 tree_6729 0.8192
Cp_6729 tree_6729 0 2.592e-15
Rtr_672_6730 tree_672 tree_6730 0.8192
Cp_6730 tree_6730 0 2.592e-15
Rtr_673_6731 tree_673 tree_6731 0.8192
Cp_6731 tree_6731 0 2.592e-15
Rtr_673_6732 tree_673 tree_6732 0.8192
Cp_6732 tree_6732 0 2.592e-15
Rtr_673_6733 tree_673 tree_6733 0.8192
Cp_6733 tree_6733 0 2.592e-15
Rtr_673_6734 tree_673 tree_6734 0.8192
Cp_6734 tree_6734 0 2.592e-15
Rtr_673_6735 tree_673 tree_6735 0.8192
Cp_6735 tree_6735 0 2.592e-15
Rtr_673_6736 tree_673 tree_6736 0.8192
Cp_6736 tree_6736 0 2.592e-15
Rtr_673_6737 tree_673 tree_6737 0.8192
Cp_6737 tree_6737 0 2.592e-15
Rtr_673_6738 tree_673 tree_6738 0.8192
Cp_6738 tree_6738 0 2.592e-15
Rtr_673_6739 tree_673 tree_6739 0.8192
Cp_6739 tree_6739 0 2.592e-15
Rtr_673_6740 tree_673 tree_6740 0.8192
Cp_6740 tree_6740 0 2.592e-15
Rtr_674_6741 tree_674 tree_6741 0.8192
Cp_6741 tree_6741 0 2.592e-15
Rtr_674_6742 tree_674 tree_6742 0.8192
Cp_6742 tree_6742 0 2.592e-15
Rtr_674_6743 tree_674 tree_6743 0.8192
Cp_6743 tree_6743 0 2.592e-15
Rtr_674_6744 tree_674 tree_6744 0.8192
Cp_6744 tree_6744 0 2.592e-15
Rtr_674_6745 tree_674 tree_6745 0.8192
Cp_6745 tree_6745 0 2.592e-15
Rtr_674_6746 tree_674 tree_6746 0.8192
Cp_6746 tree_6746 0 2.592e-15
Rtr_674_6747 tree_674 tree_6747 0.8192
Cp_6747 tree_6747 0 2.592e-15
Rtr_674_6748 tree_674 tree_6748 0.8192
Cp_6748 tree_6748 0 2.592e-15
Rtr_674_6749 tree_674 tree_6749 0.8192
Cp_6749 tree_6749 0 2.592e-15
Rtr_674_6750 tree_674 tree_6750 0.8192
Cp_6750 tree_6750 0 2.592e-15
Rtr_675_6751 tree_675 tree_6751 0.8192
Cp_6751 tree_6751 0 2.592e-15
Rtr_675_6752 tree_675 tree_6752 0.8192
Cp_6752 tree_6752 0 2.592e-15
Rtr_675_6753 tree_675 tree_6753 0.8192
Cp_6753 tree_6753 0 2.592e-15
Rtr_675_6754 tree_675 tree_6754 0.8192
Cp_6754 tree_6754 0 2.592e-15
Rtr_675_6755 tree_675 tree_6755 0.8192
Cp_6755 tree_6755 0 2.592e-15
Rtr_675_6756 tree_675 tree_6756 0.8192
Cp_6756 tree_6756 0 2.592e-15
Rtr_675_6757 tree_675 tree_6757 0.8192
Cp_6757 tree_6757 0 2.592e-15
Rtr_675_6758 tree_675 tree_6758 0.8192
Cp_6758 tree_6758 0 2.592e-15
Rtr_675_6759 tree_675 tree_6759 0.8192
Cp_6759 tree_6759 0 2.592e-15
Rtr_675_6760 tree_675 tree_6760 0.8192
Cp_6760 tree_6760 0 2.592e-15
Rtr_676_6761 tree_676 tree_6761 0.8192
Cp_6761 tree_6761 0 2.592e-15
Rtr_676_6762 tree_676 tree_6762 0.8192
Cp_6762 tree_6762 0 2.592e-15
Rtr_676_6763 tree_676 tree_6763 0.8192
Cp_6763 tree_6763 0 2.592e-15
Rtr_676_6764 tree_676 tree_6764 0.8192
Cp_6764 tree_6764 0 2.592e-15
Rtr_676_6765 tree_676 tree_6765 0.8192
Cp_6765 tree_6765 0 2.592e-15
Rtr_676_6766 tree_676 tree_6766 0.8192
Cp_6766 tree_6766 0 2.592e-15
Rtr_676_6767 tree_676 tree_6767 0.8192
Cp_6767 tree_6767 0 2.592e-15
Rtr_676_6768 tree_676 tree_6768 0.8192
Cp_6768 tree_6768 0 2.592e-15
Rtr_676_6769 tree_676 tree_6769 0.8192
Cp_6769 tree_6769 0 2.592e-15
Rtr_676_6770 tree_676 tree_6770 0.8192
Cp_6770 tree_6770 0 2.592e-15
Rtr_677_6771 tree_677 tree_6771 0.8192
Cp_6771 tree_6771 0 2.592e-15
Rtr_677_6772 tree_677 tree_6772 0.8192
Cp_6772 tree_6772 0 2.592e-15
Rtr_677_6773 tree_677 tree_6773 0.8192
Cp_6773 tree_6773 0 2.592e-15
Rtr_677_6774 tree_677 tree_6774 0.8192
Cp_6774 tree_6774 0 2.592e-15
Rtr_677_6775 tree_677 tree_6775 0.8192
Cp_6775 tree_6775 0 2.592e-15
Rtr_677_6776 tree_677 tree_6776 0.8192
Cp_6776 tree_6776 0 2.592e-15
Rtr_677_6777 tree_677 tree_6777 0.8192
Cp_6777 tree_6777 0 2.592e-15
Rtr_677_6778 tree_677 tree_6778 0.8192
Cp_6778 tree_6778 0 2.592e-15
Rtr_677_6779 tree_677 tree_6779 0.8192
Cp_6779 tree_6779 0 2.592e-15
Rtr_677_6780 tree_677 tree_6780 0.8192
Cp_6780 tree_6780 0 2.592e-15
Rtr_678_6781 tree_678 tree_6781 0.8192
Cp_6781 tree_6781 0 2.592e-15
Rtr_678_6782 tree_678 tree_6782 0.8192
Cp_6782 tree_6782 0 2.592e-15
Rtr_678_6783 tree_678 tree_6783 0.8192
Cp_6783 tree_6783 0 2.592e-15
Rtr_678_6784 tree_678 tree_6784 0.8192
Cp_6784 tree_6784 0 2.592e-15
Rtr_678_6785 tree_678 tree_6785 0.8192
Cp_6785 tree_6785 0 2.592e-15
Rtr_678_6786 tree_678 tree_6786 0.8192
Cp_6786 tree_6786 0 2.592e-15
Rtr_678_6787 tree_678 tree_6787 0.8192
Cp_6787 tree_6787 0 2.592e-15
Rtr_678_6788 tree_678 tree_6788 0.8192
Cp_6788 tree_6788 0 2.592e-15
Rtr_678_6789 tree_678 tree_6789 0.8192
Cp_6789 tree_6789 0 2.592e-15
Rtr_678_6790 tree_678 tree_6790 0.8192
Cp_6790 tree_6790 0 2.592e-15
Rtr_679_6791 tree_679 tree_6791 0.8192
Cp_6791 tree_6791 0 2.592e-15
Rtr_679_6792 tree_679 tree_6792 0.8192
Cp_6792 tree_6792 0 2.592e-15
Rtr_679_6793 tree_679 tree_6793 0.8192
Cp_6793 tree_6793 0 2.592e-15
Rtr_679_6794 tree_679 tree_6794 0.8192
Cp_6794 tree_6794 0 2.592e-15
Rtr_679_6795 tree_679 tree_6795 0.8192
Cp_6795 tree_6795 0 2.592e-15
Rtr_679_6796 tree_679 tree_6796 0.8192
Cp_6796 tree_6796 0 2.592e-15
Rtr_679_6797 tree_679 tree_6797 0.8192
Cp_6797 tree_6797 0 2.592e-15
Rtr_679_6798 tree_679 tree_6798 0.8192
Cp_6798 tree_6798 0 2.592e-15
Rtr_679_6799 tree_679 tree_6799 0.8192
Cp_6799 tree_6799 0 2.592e-15
Rtr_679_6800 tree_679 tree_6800 0.8192
Cp_6800 tree_6800 0 2.592e-15
Rtr_680_6801 tree_680 tree_6801 0.8192
Cp_6801 tree_6801 0 2.592e-15
Rtr_680_6802 tree_680 tree_6802 0.8192
Cp_6802 tree_6802 0 2.592e-15
Rtr_680_6803 tree_680 tree_6803 0.8192
Cp_6803 tree_6803 0 2.592e-15
Rtr_680_6804 tree_680 tree_6804 0.8192
Cp_6804 tree_6804 0 2.592e-15
Rtr_680_6805 tree_680 tree_6805 0.8192
Cp_6805 tree_6805 0 2.592e-15
Rtr_680_6806 tree_680 tree_6806 0.8192
Cp_6806 tree_6806 0 2.592e-15
Rtr_680_6807 tree_680 tree_6807 0.8192
Cp_6807 tree_6807 0 2.592e-15
Rtr_680_6808 tree_680 tree_6808 0.8192
Cp_6808 tree_6808 0 2.592e-15
Rtr_680_6809 tree_680 tree_6809 0.8192
Cp_6809 tree_6809 0 2.592e-15
Rtr_680_6810 tree_680 tree_6810 0.8192
Cp_6810 tree_6810 0 2.592e-15
Rtr_681_6811 tree_681 tree_6811 0.8192
Cp_6811 tree_6811 0 2.592e-15
Rtr_681_6812 tree_681 tree_6812 0.8192
Cp_6812 tree_6812 0 2.592e-15
Rtr_681_6813 tree_681 tree_6813 0.8192
Cp_6813 tree_6813 0 2.592e-15
Rtr_681_6814 tree_681 tree_6814 0.8192
Cp_6814 tree_6814 0 2.592e-15
Rtr_681_6815 tree_681 tree_6815 0.8192
Cp_6815 tree_6815 0 2.592e-15
Rtr_681_6816 tree_681 tree_6816 0.8192
Cp_6816 tree_6816 0 2.592e-15
Rtr_681_6817 tree_681 tree_6817 0.8192
Cp_6817 tree_6817 0 2.592e-15
Rtr_681_6818 tree_681 tree_6818 0.8192
Cp_6818 tree_6818 0 2.592e-15
Rtr_681_6819 tree_681 tree_6819 0.8192
Cp_6819 tree_6819 0 2.592e-15
Rtr_681_6820 tree_681 tree_6820 0.8192
Cp_6820 tree_6820 0 2.592e-15
Rtr_682_6821 tree_682 tree_6821 0.8192
Cp_6821 tree_6821 0 2.592e-15
Rtr_682_6822 tree_682 tree_6822 0.8192
Cp_6822 tree_6822 0 2.592e-15
Rtr_682_6823 tree_682 tree_6823 0.8192
Cp_6823 tree_6823 0 2.592e-15
Rtr_682_6824 tree_682 tree_6824 0.8192
Cp_6824 tree_6824 0 2.592e-15
Rtr_682_6825 tree_682 tree_6825 0.8192
Cp_6825 tree_6825 0 2.592e-15
Rtr_682_6826 tree_682 tree_6826 0.8192
Cp_6826 tree_6826 0 2.592e-15
Rtr_682_6827 tree_682 tree_6827 0.8192
Cp_6827 tree_6827 0 2.592e-15
Rtr_682_6828 tree_682 tree_6828 0.8192
Cp_6828 tree_6828 0 2.592e-15
Rtr_682_6829 tree_682 tree_6829 0.8192
Cp_6829 tree_6829 0 2.592e-15
Rtr_682_6830 tree_682 tree_6830 0.8192
Cp_6830 tree_6830 0 2.592e-15
Rtr_683_6831 tree_683 tree_6831 0.8192
Cp_6831 tree_6831 0 2.592e-15
Rtr_683_6832 tree_683 tree_6832 0.8192
Cp_6832 tree_6832 0 2.592e-15
Rtr_683_6833 tree_683 tree_6833 0.8192
Cp_6833 tree_6833 0 2.592e-15
Rtr_683_6834 tree_683 tree_6834 0.8192
Cp_6834 tree_6834 0 2.592e-15
Rtr_683_6835 tree_683 tree_6835 0.8192
Cp_6835 tree_6835 0 2.592e-15
Rtr_683_6836 tree_683 tree_6836 0.8192
Cp_6836 tree_6836 0 2.592e-15
Rtr_683_6837 tree_683 tree_6837 0.8192
Cp_6837 tree_6837 0 2.592e-15
Rtr_683_6838 tree_683 tree_6838 0.8192
Cp_6838 tree_6838 0 2.592e-15
Rtr_683_6839 tree_683 tree_6839 0.8192
Cp_6839 tree_6839 0 2.592e-15
Rtr_683_6840 tree_683 tree_6840 0.8192
Cp_6840 tree_6840 0 2.592e-15
Rtr_684_6841 tree_684 tree_6841 0.8192
Cp_6841 tree_6841 0 2.592e-15
Rtr_684_6842 tree_684 tree_6842 0.8192
Cp_6842 tree_6842 0 2.592e-15
Rtr_684_6843 tree_684 tree_6843 0.8192
Cp_6843 tree_6843 0 2.592e-15
Rtr_684_6844 tree_684 tree_6844 0.8192
Cp_6844 tree_6844 0 2.592e-15
Rtr_684_6845 tree_684 tree_6845 0.8192
Cp_6845 tree_6845 0 2.592e-15
Rtr_684_6846 tree_684 tree_6846 0.8192
Cp_6846 tree_6846 0 2.592e-15
Rtr_684_6847 tree_684 tree_6847 0.8192
Cp_6847 tree_6847 0 2.592e-15
Rtr_684_6848 tree_684 tree_6848 0.8192
Cp_6848 tree_6848 0 2.592e-15
Rtr_684_6849 tree_684 tree_6849 0.8192
Cp_6849 tree_6849 0 2.592e-15
Rtr_684_6850 tree_684 tree_6850 0.8192
Cp_6850 tree_6850 0 2.592e-15
Rtr_685_6851 tree_685 tree_6851 0.8192
Cp_6851 tree_6851 0 2.592e-15
Rtr_685_6852 tree_685 tree_6852 0.8192
Cp_6852 tree_6852 0 2.592e-15
Rtr_685_6853 tree_685 tree_6853 0.8192
Cp_6853 tree_6853 0 2.592e-15
Rtr_685_6854 tree_685 tree_6854 0.8192
Cp_6854 tree_6854 0 2.592e-15
Rtr_685_6855 tree_685 tree_6855 0.8192
Cp_6855 tree_6855 0 2.592e-15
Rtr_685_6856 tree_685 tree_6856 0.8192
Cp_6856 tree_6856 0 2.592e-15
Rtr_685_6857 tree_685 tree_6857 0.8192
Cp_6857 tree_6857 0 2.592e-15
Rtr_685_6858 tree_685 tree_6858 0.8192
Cp_6858 tree_6858 0 2.592e-15
Rtr_685_6859 tree_685 tree_6859 0.8192
Cp_6859 tree_6859 0 2.592e-15
Rtr_685_6860 tree_685 tree_6860 0.8192
Cp_6860 tree_6860 0 2.592e-15
Rtr_686_6861 tree_686 tree_6861 0.8192
Cp_6861 tree_6861 0 2.592e-15
Rtr_686_6862 tree_686 tree_6862 0.8192
Cp_6862 tree_6862 0 2.592e-15
Rtr_686_6863 tree_686 tree_6863 0.8192
Cp_6863 tree_6863 0 2.592e-15
Rtr_686_6864 tree_686 tree_6864 0.8192
Cp_6864 tree_6864 0 2.592e-15
Rtr_686_6865 tree_686 tree_6865 0.8192
Cp_6865 tree_6865 0 2.592e-15
Rtr_686_6866 tree_686 tree_6866 0.8192
Cp_6866 tree_6866 0 2.592e-15
Rtr_686_6867 tree_686 tree_6867 0.8192
Cp_6867 tree_6867 0 2.592e-15
Rtr_686_6868 tree_686 tree_6868 0.8192
Cp_6868 tree_6868 0 2.592e-15
Rtr_686_6869 tree_686 tree_6869 0.8192
Cp_6869 tree_6869 0 2.592e-15
Rtr_686_6870 tree_686 tree_6870 0.8192
Cp_6870 tree_6870 0 2.592e-15
Rtr_687_6871 tree_687 tree_6871 0.8192
Cp_6871 tree_6871 0 2.592e-15
Rtr_687_6872 tree_687 tree_6872 0.8192
Cp_6872 tree_6872 0 2.592e-15
Rtr_687_6873 tree_687 tree_6873 0.8192
Cp_6873 tree_6873 0 2.592e-15
Rtr_687_6874 tree_687 tree_6874 0.8192
Cp_6874 tree_6874 0 2.592e-15
Rtr_687_6875 tree_687 tree_6875 0.8192
Cp_6875 tree_6875 0 2.592e-15
Rtr_687_6876 tree_687 tree_6876 0.8192
Cp_6876 tree_6876 0 2.592e-15
Rtr_687_6877 tree_687 tree_6877 0.8192
Cp_6877 tree_6877 0 2.592e-15
Rtr_687_6878 tree_687 tree_6878 0.8192
Cp_6878 tree_6878 0 2.592e-15
Rtr_687_6879 tree_687 tree_6879 0.8192
Cp_6879 tree_6879 0 2.592e-15
Rtr_687_6880 tree_687 tree_6880 0.8192
Cp_6880 tree_6880 0 2.592e-15
Rtr_688_6881 tree_688 tree_6881 0.8192
Cp_6881 tree_6881 0 2.592e-15
Rtr_688_6882 tree_688 tree_6882 0.8192
Cp_6882 tree_6882 0 2.592e-15
Rtr_688_6883 tree_688 tree_6883 0.8192
Cp_6883 tree_6883 0 2.592e-15
Rtr_688_6884 tree_688 tree_6884 0.8192
Cp_6884 tree_6884 0 2.592e-15
Rtr_688_6885 tree_688 tree_6885 0.8192
Cp_6885 tree_6885 0 2.592e-15
Rtr_688_6886 tree_688 tree_6886 0.8192
Cp_6886 tree_6886 0 2.592e-15
Rtr_688_6887 tree_688 tree_6887 0.8192
Cp_6887 tree_6887 0 2.592e-15
Rtr_688_6888 tree_688 tree_6888 0.8192
Cp_6888 tree_6888 0 2.592e-15
Rtr_688_6889 tree_688 tree_6889 0.8192
Cp_6889 tree_6889 0 2.592e-15
Rtr_688_6890 tree_688 tree_6890 0.8192
Cp_6890 tree_6890 0 2.592e-15
Rtr_689_6891 tree_689 tree_6891 0.8192
Cp_6891 tree_6891 0 2.592e-15
Rtr_689_6892 tree_689 tree_6892 0.8192
Cp_6892 tree_6892 0 2.592e-15
Rtr_689_6893 tree_689 tree_6893 0.8192
Cp_6893 tree_6893 0 2.592e-15
Rtr_689_6894 tree_689 tree_6894 0.8192
Cp_6894 tree_6894 0 2.592e-15
Rtr_689_6895 tree_689 tree_6895 0.8192
Cp_6895 tree_6895 0 2.592e-15
Rtr_689_6896 tree_689 tree_6896 0.8192
Cp_6896 tree_6896 0 2.592e-15
Rtr_689_6897 tree_689 tree_6897 0.8192
Cp_6897 tree_6897 0 2.592e-15
Rtr_689_6898 tree_689 tree_6898 0.8192
Cp_6898 tree_6898 0 2.592e-15
Rtr_689_6899 tree_689 tree_6899 0.8192
Cp_6899 tree_6899 0 2.592e-15
Rtr_689_6900 tree_689 tree_6900 0.8192
Cp_6900 tree_6900 0 2.592e-15
Rtr_690_6901 tree_690 tree_6901 0.8192
Cp_6901 tree_6901 0 2.592e-15
Rtr_690_6902 tree_690 tree_6902 0.8192
Cp_6902 tree_6902 0 2.592e-15
Rtr_690_6903 tree_690 tree_6903 0.8192
Cp_6903 tree_6903 0 2.592e-15
Rtr_690_6904 tree_690 tree_6904 0.8192
Cp_6904 tree_6904 0 2.592e-15
Rtr_690_6905 tree_690 tree_6905 0.8192
Cp_6905 tree_6905 0 2.592e-15
Rtr_690_6906 tree_690 tree_6906 0.8192
Cp_6906 tree_6906 0 2.592e-15
Rtr_690_6907 tree_690 tree_6907 0.8192
Cp_6907 tree_6907 0 2.592e-15
Rtr_690_6908 tree_690 tree_6908 0.8192
Cp_6908 tree_6908 0 2.592e-15
Rtr_690_6909 tree_690 tree_6909 0.8192
Cp_6909 tree_6909 0 2.592e-15
Rtr_690_6910 tree_690 tree_6910 0.8192
Cp_6910 tree_6910 0 2.592e-15
Rtr_691_6911 tree_691 tree_6911 0.8192
Cp_6911 tree_6911 0 2.592e-15
Rtr_691_6912 tree_691 tree_6912 0.8192
Cp_6912 tree_6912 0 2.592e-15
Rtr_691_6913 tree_691 tree_6913 0.8192
Cp_6913 tree_6913 0 2.592e-15
Rtr_691_6914 tree_691 tree_6914 0.8192
Cp_6914 tree_6914 0 2.592e-15
Rtr_691_6915 tree_691 tree_6915 0.8192
Cp_6915 tree_6915 0 2.592e-15
Rtr_691_6916 tree_691 tree_6916 0.8192
Cp_6916 tree_6916 0 2.592e-15
Rtr_691_6917 tree_691 tree_6917 0.8192
Cp_6917 tree_6917 0 2.592e-15
Rtr_691_6918 tree_691 tree_6918 0.8192
Cp_6918 tree_6918 0 2.592e-15
Rtr_691_6919 tree_691 tree_6919 0.8192
Cp_6919 tree_6919 0 2.592e-15
Rtr_691_6920 tree_691 tree_6920 0.8192
Cp_6920 tree_6920 0 2.592e-15
Rtr_692_6921 tree_692 tree_6921 0.8192
Cp_6921 tree_6921 0 2.592e-15
Rtr_692_6922 tree_692 tree_6922 0.8192
Cp_6922 tree_6922 0 2.592e-15
Rtr_692_6923 tree_692 tree_6923 0.8192
Cp_6923 tree_6923 0 2.592e-15
Rtr_692_6924 tree_692 tree_6924 0.8192
Cp_6924 tree_6924 0 2.592e-15
Rtr_692_6925 tree_692 tree_6925 0.8192
Cp_6925 tree_6925 0 2.592e-15
Rtr_692_6926 tree_692 tree_6926 0.8192
Cp_6926 tree_6926 0 2.592e-15
Rtr_692_6927 tree_692 tree_6927 0.8192
Cp_6927 tree_6927 0 2.592e-15
Rtr_692_6928 tree_692 tree_6928 0.8192
Cp_6928 tree_6928 0 2.592e-15
Rtr_692_6929 tree_692 tree_6929 0.8192
Cp_6929 tree_6929 0 2.592e-15
Rtr_692_6930 tree_692 tree_6930 0.8192
Cp_6930 tree_6930 0 2.592e-15
Rtr_693_6931 tree_693 tree_6931 0.8192
Cp_6931 tree_6931 0 2.592e-15
Rtr_693_6932 tree_693 tree_6932 0.8192
Cp_6932 tree_6932 0 2.592e-15
Rtr_693_6933 tree_693 tree_6933 0.8192
Cp_6933 tree_6933 0 2.592e-15
Rtr_693_6934 tree_693 tree_6934 0.8192
Cp_6934 tree_6934 0 2.592e-15
Rtr_693_6935 tree_693 tree_6935 0.8192
Cp_6935 tree_6935 0 2.592e-15
Rtr_693_6936 tree_693 tree_6936 0.8192
Cp_6936 tree_6936 0 2.592e-15
Rtr_693_6937 tree_693 tree_6937 0.8192
Cp_6937 tree_6937 0 2.592e-15
Rtr_693_6938 tree_693 tree_6938 0.8192
Cp_6938 tree_6938 0 2.592e-15
Rtr_693_6939 tree_693 tree_6939 0.8192
Cp_6939 tree_6939 0 2.592e-15
Rtr_693_6940 tree_693 tree_6940 0.8192
Cp_6940 tree_6940 0 2.592e-15
Rtr_694_6941 tree_694 tree_6941 0.8192
Cp_6941 tree_6941 0 2.592e-15
Rtr_694_6942 tree_694 tree_6942 0.8192
Cp_6942 tree_6942 0 2.592e-15
Rtr_694_6943 tree_694 tree_6943 0.8192
Cp_6943 tree_6943 0 2.592e-15
Rtr_694_6944 tree_694 tree_6944 0.8192
Cp_6944 tree_6944 0 2.592e-15
Rtr_694_6945 tree_694 tree_6945 0.8192
Cp_6945 tree_6945 0 2.592e-15
Rtr_694_6946 tree_694 tree_6946 0.8192
Cp_6946 tree_6946 0 2.592e-15
Rtr_694_6947 tree_694 tree_6947 0.8192
Cp_6947 tree_6947 0 2.592e-15
Rtr_694_6948 tree_694 tree_6948 0.8192
Cp_6948 tree_6948 0 2.592e-15
Rtr_694_6949 tree_694 tree_6949 0.8192
Cp_6949 tree_6949 0 2.592e-15
Rtr_694_6950 tree_694 tree_6950 0.8192
Cp_6950 tree_6950 0 2.592e-15
Rtr_695_6951 tree_695 tree_6951 0.8192
Cp_6951 tree_6951 0 2.592e-15
Rtr_695_6952 tree_695 tree_6952 0.8192
Cp_6952 tree_6952 0 2.592e-15
Rtr_695_6953 tree_695 tree_6953 0.8192
Cp_6953 tree_6953 0 2.592e-15
Rtr_695_6954 tree_695 tree_6954 0.8192
Cp_6954 tree_6954 0 2.592e-15
Rtr_695_6955 tree_695 tree_6955 0.8192
Cp_6955 tree_6955 0 2.592e-15
Rtr_695_6956 tree_695 tree_6956 0.8192
Cp_6956 tree_6956 0 2.592e-15
Rtr_695_6957 tree_695 tree_6957 0.8192
Cp_6957 tree_6957 0 2.592e-15
Rtr_695_6958 tree_695 tree_6958 0.8192
Cp_6958 tree_6958 0 2.592e-15
Rtr_695_6959 tree_695 tree_6959 0.8192
Cp_6959 tree_6959 0 2.592e-15
Rtr_695_6960 tree_695 tree_6960 0.8192
Cp_6960 tree_6960 0 2.592e-15
Rtr_696_6961 tree_696 tree_6961 0.8192
Cp_6961 tree_6961 0 2.592e-15
Rtr_696_6962 tree_696 tree_6962 0.8192
Cp_6962 tree_6962 0 2.592e-15
Rtr_696_6963 tree_696 tree_6963 0.8192
Cp_6963 tree_6963 0 2.592e-15
Rtr_696_6964 tree_696 tree_6964 0.8192
Cp_6964 tree_6964 0 2.592e-15
Rtr_696_6965 tree_696 tree_6965 0.8192
Cp_6965 tree_6965 0 2.592e-15
Rtr_696_6966 tree_696 tree_6966 0.8192
Cp_6966 tree_6966 0 2.592e-15
Rtr_696_6967 tree_696 tree_6967 0.8192
Cp_6967 tree_6967 0 2.592e-15
Rtr_696_6968 tree_696 tree_6968 0.8192
Cp_6968 tree_6968 0 2.592e-15
Rtr_696_6969 tree_696 tree_6969 0.8192
Cp_6969 tree_6969 0 2.592e-15
Rtr_696_6970 tree_696 tree_6970 0.8192
Cp_6970 tree_6970 0 2.592e-15
Rtr_697_6971 tree_697 tree_6971 0.8192
Cp_6971 tree_6971 0 2.592e-15
Rtr_697_6972 tree_697 tree_6972 0.8192
Cp_6972 tree_6972 0 2.592e-15
Rtr_697_6973 tree_697 tree_6973 0.8192
Cp_6973 tree_6973 0 2.592e-15
Rtr_697_6974 tree_697 tree_6974 0.8192
Cp_6974 tree_6974 0 2.592e-15
Rtr_697_6975 tree_697 tree_6975 0.8192
Cp_6975 tree_6975 0 2.592e-15
Rtr_697_6976 tree_697 tree_6976 0.8192
Cp_6976 tree_6976 0 2.592e-15
Rtr_697_6977 tree_697 tree_6977 0.8192
Cp_6977 tree_6977 0 2.592e-15
Rtr_697_6978 tree_697 tree_6978 0.8192
Cp_6978 tree_6978 0 2.592e-15
Rtr_697_6979 tree_697 tree_6979 0.8192
Cp_6979 tree_6979 0 2.592e-15
Rtr_697_6980 tree_697 tree_6980 0.8192
Cp_6980 tree_6980 0 2.592e-15
Rtr_698_6981 tree_698 tree_6981 0.8192
Cp_6981 tree_6981 0 2.592e-15
Rtr_698_6982 tree_698 tree_6982 0.8192
Cp_6982 tree_6982 0 2.592e-15
Rtr_698_6983 tree_698 tree_6983 0.8192
Cp_6983 tree_6983 0 2.592e-15
Rtr_698_6984 tree_698 tree_6984 0.8192
Cp_6984 tree_6984 0 2.592e-15
Rtr_698_6985 tree_698 tree_6985 0.8192
Cp_6985 tree_6985 0 2.592e-15
Rtr_698_6986 tree_698 tree_6986 0.8192
Cp_6986 tree_6986 0 2.592e-15
Rtr_698_6987 tree_698 tree_6987 0.8192
Cp_6987 tree_6987 0 2.592e-15
Rtr_698_6988 tree_698 tree_6988 0.8192
Cp_6988 tree_6988 0 2.592e-15
Rtr_698_6989 tree_698 tree_6989 0.8192
Cp_6989 tree_6989 0 2.592e-15
Rtr_698_6990 tree_698 tree_6990 0.8192
Cp_6990 tree_6990 0 2.592e-15
Rtr_699_6991 tree_699 tree_6991 0.8192
Cp_6991 tree_6991 0 2.592e-15
Rtr_699_6992 tree_699 tree_6992 0.8192
Cp_6992 tree_6992 0 2.592e-15
Rtr_699_6993 tree_699 tree_6993 0.8192
Cp_6993 tree_6993 0 2.592e-15
Rtr_699_6994 tree_699 tree_6994 0.8192
Cp_6994 tree_6994 0 2.592e-15
Rtr_699_6995 tree_699 tree_6995 0.8192
Cp_6995 tree_6995 0 2.592e-15
Rtr_699_6996 tree_699 tree_6996 0.8192
Cp_6996 tree_6996 0 2.592e-15
Rtr_699_6997 tree_699 tree_6997 0.8192
Cp_6997 tree_6997 0 2.592e-15
Rtr_699_6998 tree_699 tree_6998 0.8192
Cp_6998 tree_6998 0 2.592e-15
Rtr_699_6999 tree_699 tree_6999 0.8192
Cp_6999 tree_6999 0 2.592e-15
Rtr_699_7000 tree_699 tree_7000 0.8192
Cp_7000 tree_7000 0 2.592e-15
Rtr_700_7001 tree_700 tree_7001 0.8192
Cp_7001 tree_7001 0 2.592e-15
Rtr_700_7002 tree_700 tree_7002 0.8192
Cp_7002 tree_7002 0 2.592e-15
Rtr_700_7003 tree_700 tree_7003 0.8192
Cp_7003 tree_7003 0 2.592e-15
Rtr_700_7004 tree_700 tree_7004 0.8192
Cp_7004 tree_7004 0 2.592e-15
Rtr_700_7005 tree_700 tree_7005 0.8192
Cp_7005 tree_7005 0 2.592e-15
Rtr_700_7006 tree_700 tree_7006 0.8192
Cp_7006 tree_7006 0 2.592e-15
Rtr_700_7007 tree_700 tree_7007 0.8192
Cp_7007 tree_7007 0 2.592e-15
Rtr_700_7008 tree_700 tree_7008 0.8192
Cp_7008 tree_7008 0 2.592e-15
Rtr_700_7009 tree_700 tree_7009 0.8192
Cp_7009 tree_7009 0 2.592e-15
Rtr_700_7010 tree_700 tree_7010 0.8192
Cp_7010 tree_7010 0 2.592e-15
Rtr_701_7011 tree_701 tree_7011 0.8192
Cp_7011 tree_7011 0 2.592e-15
Rtr_701_7012 tree_701 tree_7012 0.8192
Cp_7012 tree_7012 0 2.592e-15
Rtr_701_7013 tree_701 tree_7013 0.8192
Cp_7013 tree_7013 0 2.592e-15
Rtr_701_7014 tree_701 tree_7014 0.8192
Cp_7014 tree_7014 0 2.592e-15
Rtr_701_7015 tree_701 tree_7015 0.8192
Cp_7015 tree_7015 0 2.592e-15
Rtr_701_7016 tree_701 tree_7016 0.8192
Cp_7016 tree_7016 0 2.592e-15
Rtr_701_7017 tree_701 tree_7017 0.8192
Cp_7017 tree_7017 0 2.592e-15
Rtr_701_7018 tree_701 tree_7018 0.8192
Cp_7018 tree_7018 0 2.592e-15
Rtr_701_7019 tree_701 tree_7019 0.8192
Cp_7019 tree_7019 0 2.592e-15
Rtr_701_7020 tree_701 tree_7020 0.8192
Cp_7020 tree_7020 0 2.592e-15
Rtr_702_7021 tree_702 tree_7021 0.8192
Cp_7021 tree_7021 0 2.592e-15
Rtr_702_7022 tree_702 tree_7022 0.8192
Cp_7022 tree_7022 0 2.592e-15
Rtr_702_7023 tree_702 tree_7023 0.8192
Cp_7023 tree_7023 0 2.592e-15
Rtr_702_7024 tree_702 tree_7024 0.8192
Cp_7024 tree_7024 0 2.592e-15
Rtr_702_7025 tree_702 tree_7025 0.8192
Cp_7025 tree_7025 0 2.592e-15
Rtr_702_7026 tree_702 tree_7026 0.8192
Cp_7026 tree_7026 0 2.592e-15
Rtr_702_7027 tree_702 tree_7027 0.8192
Cp_7027 tree_7027 0 2.592e-15
Rtr_702_7028 tree_702 tree_7028 0.8192
Cp_7028 tree_7028 0 2.592e-15
Rtr_702_7029 tree_702 tree_7029 0.8192
Cp_7029 tree_7029 0 2.592e-15
Rtr_702_7030 tree_702 tree_7030 0.8192
Cp_7030 tree_7030 0 2.592e-15
Rtr_703_7031 tree_703 tree_7031 0.8192
Cp_7031 tree_7031 0 2.592e-15
Rtr_703_7032 tree_703 tree_7032 0.8192
Cp_7032 tree_7032 0 2.592e-15
Rtr_703_7033 tree_703 tree_7033 0.8192
Cp_7033 tree_7033 0 2.592e-15
Rtr_703_7034 tree_703 tree_7034 0.8192
Cp_7034 tree_7034 0 2.592e-15
Rtr_703_7035 tree_703 tree_7035 0.8192
Cp_7035 tree_7035 0 2.592e-15
Rtr_703_7036 tree_703 tree_7036 0.8192
Cp_7036 tree_7036 0 2.592e-15
Rtr_703_7037 tree_703 tree_7037 0.8192
Cp_7037 tree_7037 0 2.592e-15
Rtr_703_7038 tree_703 tree_7038 0.8192
Cp_7038 tree_7038 0 2.592e-15
Rtr_703_7039 tree_703 tree_7039 0.8192
Cp_7039 tree_7039 0 2.592e-15
Rtr_703_7040 tree_703 tree_7040 0.8192
Cp_7040 tree_7040 0 2.592e-15
Rtr_704_7041 tree_704 tree_7041 0.8192
Cp_7041 tree_7041 0 2.592e-15
Rtr_704_7042 tree_704 tree_7042 0.8192
Cp_7042 tree_7042 0 2.592e-15
Rtr_704_7043 tree_704 tree_7043 0.8192
Cp_7043 tree_7043 0 2.592e-15
Rtr_704_7044 tree_704 tree_7044 0.8192
Cp_7044 tree_7044 0 2.592e-15
Rtr_704_7045 tree_704 tree_7045 0.8192
Cp_7045 tree_7045 0 2.592e-15
Rtr_704_7046 tree_704 tree_7046 0.8192
Cp_7046 tree_7046 0 2.592e-15
Rtr_704_7047 tree_704 tree_7047 0.8192
Cp_7047 tree_7047 0 2.592e-15
Rtr_704_7048 tree_704 tree_7048 0.8192
Cp_7048 tree_7048 0 2.592e-15
Rtr_704_7049 tree_704 tree_7049 0.8192
Cp_7049 tree_7049 0 2.592e-15
Rtr_704_7050 tree_704 tree_7050 0.8192
Cp_7050 tree_7050 0 2.592e-15
Rtr_705_7051 tree_705 tree_7051 0.8192
Cp_7051 tree_7051 0 2.592e-15
Rtr_705_7052 tree_705 tree_7052 0.8192
Cp_7052 tree_7052 0 2.592e-15
Rtr_705_7053 tree_705 tree_7053 0.8192
Cp_7053 tree_7053 0 2.592e-15
Rtr_705_7054 tree_705 tree_7054 0.8192
Cp_7054 tree_7054 0 2.592e-15
Rtr_705_7055 tree_705 tree_7055 0.8192
Cp_7055 tree_7055 0 2.592e-15
Rtr_705_7056 tree_705 tree_7056 0.8192
Cp_7056 tree_7056 0 2.592e-15
Rtr_705_7057 tree_705 tree_7057 0.8192
Cp_7057 tree_7057 0 2.592e-15
Rtr_705_7058 tree_705 tree_7058 0.8192
Cp_7058 tree_7058 0 2.592e-15
Rtr_705_7059 tree_705 tree_7059 0.8192
Cp_7059 tree_7059 0 2.592e-15
Rtr_705_7060 tree_705 tree_7060 0.8192
Cp_7060 tree_7060 0 2.592e-15
Rtr_706_7061 tree_706 tree_7061 0.8192
Cp_7061 tree_7061 0 2.592e-15
Rtr_706_7062 tree_706 tree_7062 0.8192
Cp_7062 tree_7062 0 2.592e-15
Rtr_706_7063 tree_706 tree_7063 0.8192
Cp_7063 tree_7063 0 2.592e-15
Rtr_706_7064 tree_706 tree_7064 0.8192
Cp_7064 tree_7064 0 2.592e-15
Rtr_706_7065 tree_706 tree_7065 0.8192
Cp_7065 tree_7065 0 2.592e-15
Rtr_706_7066 tree_706 tree_7066 0.8192
Cp_7066 tree_7066 0 2.592e-15
Rtr_706_7067 tree_706 tree_7067 0.8192
Cp_7067 tree_7067 0 2.592e-15
Rtr_706_7068 tree_706 tree_7068 0.8192
Cp_7068 tree_7068 0 2.592e-15
Rtr_706_7069 tree_706 tree_7069 0.8192
Cp_7069 tree_7069 0 2.592e-15
Rtr_706_7070 tree_706 tree_7070 0.8192
Cp_7070 tree_7070 0 2.592e-15
Rtr_707_7071 tree_707 tree_7071 0.8192
Cp_7071 tree_7071 0 2.592e-15
Rtr_707_7072 tree_707 tree_7072 0.8192
Cp_7072 tree_7072 0 2.592e-15
Rtr_707_7073 tree_707 tree_7073 0.8192
Cp_7073 tree_7073 0 2.592e-15
Rtr_707_7074 tree_707 tree_7074 0.8192
Cp_7074 tree_7074 0 2.592e-15
Rtr_707_7075 tree_707 tree_7075 0.8192
Cp_7075 tree_7075 0 2.592e-15
Rtr_707_7076 tree_707 tree_7076 0.8192
Cp_7076 tree_7076 0 2.592e-15
Rtr_707_7077 tree_707 tree_7077 0.8192
Cp_7077 tree_7077 0 2.592e-15
Rtr_707_7078 tree_707 tree_7078 0.8192
Cp_7078 tree_7078 0 2.592e-15
Rtr_707_7079 tree_707 tree_7079 0.8192
Cp_7079 tree_7079 0 2.592e-15
Rtr_707_7080 tree_707 tree_7080 0.8192
Cp_7080 tree_7080 0 2.592e-15
Rtr_708_7081 tree_708 tree_7081 0.8192
Cp_7081 tree_7081 0 2.592e-15
Rtr_708_7082 tree_708 tree_7082 0.8192
Cp_7082 tree_7082 0 2.592e-15
Rtr_708_7083 tree_708 tree_7083 0.8192
Cp_7083 tree_7083 0 2.592e-15
Rtr_708_7084 tree_708 tree_7084 0.8192
Cp_7084 tree_7084 0 2.592e-15
Rtr_708_7085 tree_708 tree_7085 0.8192
Cp_7085 tree_7085 0 2.592e-15
Rtr_708_7086 tree_708 tree_7086 0.8192
Cp_7086 tree_7086 0 2.592e-15
Rtr_708_7087 tree_708 tree_7087 0.8192
Cp_7087 tree_7087 0 2.592e-15
Rtr_708_7088 tree_708 tree_7088 0.8192
Cp_7088 tree_7088 0 2.592e-15
Rtr_708_7089 tree_708 tree_7089 0.8192
Cp_7089 tree_7089 0 2.592e-15
Rtr_708_7090 tree_708 tree_7090 0.8192
Cp_7090 tree_7090 0 2.592e-15
Rtr_709_7091 tree_709 tree_7091 0.8192
Cp_7091 tree_7091 0 2.592e-15
Rtr_709_7092 tree_709 tree_7092 0.8192
Cp_7092 tree_7092 0 2.592e-15
Rtr_709_7093 tree_709 tree_7093 0.8192
Cp_7093 tree_7093 0 2.592e-15
Rtr_709_7094 tree_709 tree_7094 0.8192
Cp_7094 tree_7094 0 2.592e-15
Rtr_709_7095 tree_709 tree_7095 0.8192
Cp_7095 tree_7095 0 2.592e-15
Rtr_709_7096 tree_709 tree_7096 0.8192
Cp_7096 tree_7096 0 2.592e-15
Rtr_709_7097 tree_709 tree_7097 0.8192
Cp_7097 tree_7097 0 2.592e-15
Rtr_709_7098 tree_709 tree_7098 0.8192
Cp_7098 tree_7098 0 2.592e-15
Rtr_709_7099 tree_709 tree_7099 0.8192
Cp_7099 tree_7099 0 2.592e-15
Rtr_709_7100 tree_709 tree_7100 0.8192
Cp_7100 tree_7100 0 2.592e-15
Rtr_710_7101 tree_710 tree_7101 0.8192
Cp_7101 tree_7101 0 2.592e-15
Rtr_710_7102 tree_710 tree_7102 0.8192
Cp_7102 tree_7102 0 2.592e-15
Rtr_710_7103 tree_710 tree_7103 0.8192
Cp_7103 tree_7103 0 2.592e-15
Rtr_710_7104 tree_710 tree_7104 0.8192
Cp_7104 tree_7104 0 2.592e-15
Rtr_710_7105 tree_710 tree_7105 0.8192
Cp_7105 tree_7105 0 2.592e-15
Rtr_710_7106 tree_710 tree_7106 0.8192
Cp_7106 tree_7106 0 2.592e-15
Rtr_710_7107 tree_710 tree_7107 0.8192
Cp_7107 tree_7107 0 2.592e-15
Rtr_710_7108 tree_710 tree_7108 0.8192
Cp_7108 tree_7108 0 2.592e-15
Rtr_710_7109 tree_710 tree_7109 0.8192
Cp_7109 tree_7109 0 2.592e-15
Rtr_710_7110 tree_710 tree_7110 0.8192
Cp_7110 tree_7110 0 2.592e-15
Rtr_711_7111 tree_711 tree_7111 0.8192
Cp_7111 tree_7111 0 2.592e-15
Rtr_711_7112 tree_711 tree_7112 0.8192
Cp_7112 tree_7112 0 2.592e-15
Rtr_711_7113 tree_711 tree_7113 0.8192
Cp_7113 tree_7113 0 2.592e-15
Rtr_711_7114 tree_711 tree_7114 0.8192
Cp_7114 tree_7114 0 2.592e-15
Rtr_711_7115 tree_711 tree_7115 0.8192
Cp_7115 tree_7115 0 2.592e-15
Rtr_711_7116 tree_711 tree_7116 0.8192
Cp_7116 tree_7116 0 2.592e-15
Rtr_711_7117 tree_711 tree_7117 0.8192
Cp_7117 tree_7117 0 2.592e-15
Rtr_711_7118 tree_711 tree_7118 0.8192
Cp_7118 tree_7118 0 2.592e-15
Rtr_711_7119 tree_711 tree_7119 0.8192
Cp_7119 tree_7119 0 2.592e-15
Rtr_711_7120 tree_711 tree_7120 0.8192
Cp_7120 tree_7120 0 2.592e-15
Rtr_712_7121 tree_712 tree_7121 0.8192
Cp_7121 tree_7121 0 2.592e-15
Rtr_712_7122 tree_712 tree_7122 0.8192
Cp_7122 tree_7122 0 2.592e-15
Rtr_712_7123 tree_712 tree_7123 0.8192
Cp_7123 tree_7123 0 2.592e-15
Rtr_712_7124 tree_712 tree_7124 0.8192
Cp_7124 tree_7124 0 2.592e-15
Rtr_712_7125 tree_712 tree_7125 0.8192
Cp_7125 tree_7125 0 2.592e-15
Rtr_712_7126 tree_712 tree_7126 0.8192
Cp_7126 tree_7126 0 2.592e-15
Rtr_712_7127 tree_712 tree_7127 0.8192
Cp_7127 tree_7127 0 2.592e-15
Rtr_712_7128 tree_712 tree_7128 0.8192
Cp_7128 tree_7128 0 2.592e-15
Rtr_712_7129 tree_712 tree_7129 0.8192
Cp_7129 tree_7129 0 2.592e-15
Rtr_712_7130 tree_712 tree_7130 0.8192
Cp_7130 tree_7130 0 2.592e-15
Rtr_713_7131 tree_713 tree_7131 0.8192
Cp_7131 tree_7131 0 2.592e-15
Rtr_713_7132 tree_713 tree_7132 0.8192
Cp_7132 tree_7132 0 2.592e-15
Rtr_713_7133 tree_713 tree_7133 0.8192
Cp_7133 tree_7133 0 2.592e-15
Rtr_713_7134 tree_713 tree_7134 0.8192
Cp_7134 tree_7134 0 2.592e-15
Rtr_713_7135 tree_713 tree_7135 0.8192
Cp_7135 tree_7135 0 2.592e-15
Rtr_713_7136 tree_713 tree_7136 0.8192
Cp_7136 tree_7136 0 2.592e-15
Rtr_713_7137 tree_713 tree_7137 0.8192
Cp_7137 tree_7137 0 2.592e-15
Rtr_713_7138 tree_713 tree_7138 0.8192
Cp_7138 tree_7138 0 2.592e-15
Rtr_713_7139 tree_713 tree_7139 0.8192
Cp_7139 tree_7139 0 2.592e-15
Rtr_713_7140 tree_713 tree_7140 0.8192
Cp_7140 tree_7140 0 2.592e-15
Rtr_714_7141 tree_714 tree_7141 0.8192
Cp_7141 tree_7141 0 2.592e-15
Rtr_714_7142 tree_714 tree_7142 0.8192
Cp_7142 tree_7142 0 2.592e-15
Rtr_714_7143 tree_714 tree_7143 0.8192
Cp_7143 tree_7143 0 2.592e-15
Rtr_714_7144 tree_714 tree_7144 0.8192
Cp_7144 tree_7144 0 2.592e-15
Rtr_714_7145 tree_714 tree_7145 0.8192
Cp_7145 tree_7145 0 2.592e-15
Rtr_714_7146 tree_714 tree_7146 0.8192
Cp_7146 tree_7146 0 2.592e-15
Rtr_714_7147 tree_714 tree_7147 0.8192
Cp_7147 tree_7147 0 2.592e-15
Rtr_714_7148 tree_714 tree_7148 0.8192
Cp_7148 tree_7148 0 2.592e-15
Rtr_714_7149 tree_714 tree_7149 0.8192
Cp_7149 tree_7149 0 2.592e-15
Rtr_714_7150 tree_714 tree_7150 0.8192
Cp_7150 tree_7150 0 2.592e-15
Rtr_715_7151 tree_715 tree_7151 0.8192
Cp_7151 tree_7151 0 2.592e-15
Rtr_715_7152 tree_715 tree_7152 0.8192
Cp_7152 tree_7152 0 2.592e-15
Rtr_715_7153 tree_715 tree_7153 0.8192
Cp_7153 tree_7153 0 2.592e-15
Rtr_715_7154 tree_715 tree_7154 0.8192
Cp_7154 tree_7154 0 2.592e-15
Rtr_715_7155 tree_715 tree_7155 0.8192
Cp_7155 tree_7155 0 2.592e-15
Rtr_715_7156 tree_715 tree_7156 0.8192
Cp_7156 tree_7156 0 2.592e-15
Rtr_715_7157 tree_715 tree_7157 0.8192
Cp_7157 tree_7157 0 2.592e-15
Rtr_715_7158 tree_715 tree_7158 0.8192
Cp_7158 tree_7158 0 2.592e-15
Rtr_715_7159 tree_715 tree_7159 0.8192
Cp_7159 tree_7159 0 2.592e-15
Rtr_715_7160 tree_715 tree_7160 0.8192
Cp_7160 tree_7160 0 2.592e-15
Rtr_716_7161 tree_716 tree_7161 0.8192
Cp_7161 tree_7161 0 2.592e-15
Rtr_716_7162 tree_716 tree_7162 0.8192
Cp_7162 tree_7162 0 2.592e-15
Rtr_716_7163 tree_716 tree_7163 0.8192
Cp_7163 tree_7163 0 2.592e-15
Rtr_716_7164 tree_716 tree_7164 0.8192
Cp_7164 tree_7164 0 2.592e-15
Rtr_716_7165 tree_716 tree_7165 0.8192
Cp_7165 tree_7165 0 2.592e-15
Rtr_716_7166 tree_716 tree_7166 0.8192
Cp_7166 tree_7166 0 2.592e-15
Rtr_716_7167 tree_716 tree_7167 0.8192
Cp_7167 tree_7167 0 2.592e-15
Rtr_716_7168 tree_716 tree_7168 0.8192
Cp_7168 tree_7168 0 2.592e-15
Rtr_716_7169 tree_716 tree_7169 0.8192
Cp_7169 tree_7169 0 2.592e-15
Rtr_716_7170 tree_716 tree_7170 0.8192
Cp_7170 tree_7170 0 2.592e-15
Rtr_717_7171 tree_717 tree_7171 0.8192
Cp_7171 tree_7171 0 2.592e-15
Rtr_717_7172 tree_717 tree_7172 0.8192
Cp_7172 tree_7172 0 2.592e-15
Rtr_717_7173 tree_717 tree_7173 0.8192
Cp_7173 tree_7173 0 2.592e-15
Rtr_717_7174 tree_717 tree_7174 0.8192
Cp_7174 tree_7174 0 2.592e-15
Rtr_717_7175 tree_717 tree_7175 0.8192
Cp_7175 tree_7175 0 2.592e-15
Rtr_717_7176 tree_717 tree_7176 0.8192
Cp_7176 tree_7176 0 2.592e-15
Rtr_717_7177 tree_717 tree_7177 0.8192
Cp_7177 tree_7177 0 2.592e-15
Rtr_717_7178 tree_717 tree_7178 0.8192
Cp_7178 tree_7178 0 2.592e-15
Rtr_717_7179 tree_717 tree_7179 0.8192
Cp_7179 tree_7179 0 2.592e-15
Rtr_717_7180 tree_717 tree_7180 0.8192
Cp_7180 tree_7180 0 2.592e-15
Rtr_718_7181 tree_718 tree_7181 0.8192
Cp_7181 tree_7181 0 2.592e-15
Rtr_718_7182 tree_718 tree_7182 0.8192
Cp_7182 tree_7182 0 2.592e-15
Rtr_718_7183 tree_718 tree_7183 0.8192
Cp_7183 tree_7183 0 2.592e-15
Rtr_718_7184 tree_718 tree_7184 0.8192
Cp_7184 tree_7184 0 2.592e-15
Rtr_718_7185 tree_718 tree_7185 0.8192
Cp_7185 tree_7185 0 2.592e-15
Rtr_718_7186 tree_718 tree_7186 0.8192
Cp_7186 tree_7186 0 2.592e-15
Rtr_718_7187 tree_718 tree_7187 0.8192
Cp_7187 tree_7187 0 2.592e-15
Rtr_718_7188 tree_718 tree_7188 0.8192
Cp_7188 tree_7188 0 2.592e-15
Rtr_718_7189 tree_718 tree_7189 0.8192
Cp_7189 tree_7189 0 2.592e-15
Rtr_718_7190 tree_718 tree_7190 0.8192
Cp_7190 tree_7190 0 2.592e-15
Rtr_719_7191 tree_719 tree_7191 0.8192
Cp_7191 tree_7191 0 2.592e-15
Rtr_719_7192 tree_719 tree_7192 0.8192
Cp_7192 tree_7192 0 2.592e-15
Rtr_719_7193 tree_719 tree_7193 0.8192
Cp_7193 tree_7193 0 2.592e-15
Rtr_719_7194 tree_719 tree_7194 0.8192
Cp_7194 tree_7194 0 2.592e-15
Rtr_719_7195 tree_719 tree_7195 0.8192
Cp_7195 tree_7195 0 2.592e-15
Rtr_719_7196 tree_719 tree_7196 0.8192
Cp_7196 tree_7196 0 2.592e-15
Rtr_719_7197 tree_719 tree_7197 0.8192
Cp_7197 tree_7197 0 2.592e-15
Rtr_719_7198 tree_719 tree_7198 0.8192
Cp_7198 tree_7198 0 2.592e-15
Rtr_719_7199 tree_719 tree_7199 0.8192
Cp_7199 tree_7199 0 2.592e-15
Rtr_719_7200 tree_719 tree_7200 0.8192
Cp_7200 tree_7200 0 2.592e-15
Rtr_720_7201 tree_720 tree_7201 0.8192
Cp_7201 tree_7201 0 2.592e-15
Rtr_720_7202 tree_720 tree_7202 0.8192
Cp_7202 tree_7202 0 2.592e-15
Rtr_720_7203 tree_720 tree_7203 0.8192
Cp_7203 tree_7203 0 2.592e-15
Rtr_720_7204 tree_720 tree_7204 0.8192
Cp_7204 tree_7204 0 2.592e-15
Rtr_720_7205 tree_720 tree_7205 0.8192
Cp_7205 tree_7205 0 2.592e-15
Rtr_720_7206 tree_720 tree_7206 0.8192
Cp_7206 tree_7206 0 2.592e-15
Rtr_720_7207 tree_720 tree_7207 0.8192
Cp_7207 tree_7207 0 2.592e-15
Rtr_720_7208 tree_720 tree_7208 0.8192
Cp_7208 tree_7208 0 2.592e-15
Rtr_720_7209 tree_720 tree_7209 0.8192
Cp_7209 tree_7209 0 2.592e-15
Rtr_720_7210 tree_720 tree_7210 0.8192
Cp_7210 tree_7210 0 2.592e-15
Rtr_721_7211 tree_721 tree_7211 0.8192
Cp_7211 tree_7211 0 2.592e-15
Rtr_721_7212 tree_721 tree_7212 0.8192
Cp_7212 tree_7212 0 2.592e-15
Rtr_721_7213 tree_721 tree_7213 0.8192
Cp_7213 tree_7213 0 2.592e-15
Rtr_721_7214 tree_721 tree_7214 0.8192
Cp_7214 tree_7214 0 2.592e-15
Rtr_721_7215 tree_721 tree_7215 0.8192
Cp_7215 tree_7215 0 2.592e-15
Rtr_721_7216 tree_721 tree_7216 0.8192
Cp_7216 tree_7216 0 2.592e-15
Rtr_721_7217 tree_721 tree_7217 0.8192
Cp_7217 tree_7217 0 2.592e-15
Rtr_721_7218 tree_721 tree_7218 0.8192
Cp_7218 tree_7218 0 2.592e-15
Rtr_721_7219 tree_721 tree_7219 0.8192
Cp_7219 tree_7219 0 2.592e-15
Rtr_721_7220 tree_721 tree_7220 0.8192
Cp_7220 tree_7220 0 2.592e-15
Rtr_722_7221 tree_722 tree_7221 0.8192
Cp_7221 tree_7221 0 2.592e-15
Rtr_722_7222 tree_722 tree_7222 0.8192
Cp_7222 tree_7222 0 2.592e-15
Rtr_722_7223 tree_722 tree_7223 0.8192
Cp_7223 tree_7223 0 2.592e-15
Rtr_722_7224 tree_722 tree_7224 0.8192
Cp_7224 tree_7224 0 2.592e-15
Rtr_722_7225 tree_722 tree_7225 0.8192
Cp_7225 tree_7225 0 2.592e-15
Rtr_722_7226 tree_722 tree_7226 0.8192
Cp_7226 tree_7226 0 2.592e-15
Rtr_722_7227 tree_722 tree_7227 0.8192
Cp_7227 tree_7227 0 2.592e-15
Rtr_722_7228 tree_722 tree_7228 0.8192
Cp_7228 tree_7228 0 2.592e-15
Rtr_722_7229 tree_722 tree_7229 0.8192
Cp_7229 tree_7229 0 2.592e-15
Rtr_722_7230 tree_722 tree_7230 0.8192
Cp_7230 tree_7230 0 2.592e-15
Rtr_723_7231 tree_723 tree_7231 0.8192
Cp_7231 tree_7231 0 2.592e-15
Rtr_723_7232 tree_723 tree_7232 0.8192
Cp_7232 tree_7232 0 2.592e-15
Rtr_723_7233 tree_723 tree_7233 0.8192
Cp_7233 tree_7233 0 2.592e-15
Rtr_723_7234 tree_723 tree_7234 0.8192
Cp_7234 tree_7234 0 2.592e-15
Rtr_723_7235 tree_723 tree_7235 0.8192
Cp_7235 tree_7235 0 2.592e-15
Rtr_723_7236 tree_723 tree_7236 0.8192
Cp_7236 tree_7236 0 2.592e-15
Rtr_723_7237 tree_723 tree_7237 0.8192
Cp_7237 tree_7237 0 2.592e-15
Rtr_723_7238 tree_723 tree_7238 0.8192
Cp_7238 tree_7238 0 2.592e-15
Rtr_723_7239 tree_723 tree_7239 0.8192
Cp_7239 tree_7239 0 2.592e-15
Rtr_723_7240 tree_723 tree_7240 0.8192
Cp_7240 tree_7240 0 2.592e-15
Rtr_724_7241 tree_724 tree_7241 0.8192
Cp_7241 tree_7241 0 2.592e-15
Rtr_724_7242 tree_724 tree_7242 0.8192
Cp_7242 tree_7242 0 2.592e-15
Rtr_724_7243 tree_724 tree_7243 0.8192
Cp_7243 tree_7243 0 2.592e-15
Rtr_724_7244 tree_724 tree_7244 0.8192
Cp_7244 tree_7244 0 2.592e-15
Rtr_724_7245 tree_724 tree_7245 0.8192
Cp_7245 tree_7245 0 2.592e-15
Rtr_724_7246 tree_724 tree_7246 0.8192
Cp_7246 tree_7246 0 2.592e-15
Rtr_724_7247 tree_724 tree_7247 0.8192
Cp_7247 tree_7247 0 2.592e-15
Rtr_724_7248 tree_724 tree_7248 0.8192
Cp_7248 tree_7248 0 2.592e-15
Rtr_724_7249 tree_724 tree_7249 0.8192
Cp_7249 tree_7249 0 2.592e-15
Rtr_724_7250 tree_724 tree_7250 0.8192
Cp_7250 tree_7250 0 2.592e-15
Rtr_725_7251 tree_725 tree_7251 0.8192
Cp_7251 tree_7251 0 2.592e-15
Rtr_725_7252 tree_725 tree_7252 0.8192
Cp_7252 tree_7252 0 2.592e-15
Rtr_725_7253 tree_725 tree_7253 0.8192
Cp_7253 tree_7253 0 2.592e-15
Rtr_725_7254 tree_725 tree_7254 0.8192
Cp_7254 tree_7254 0 2.592e-15
Rtr_725_7255 tree_725 tree_7255 0.8192
Cp_7255 tree_7255 0 2.592e-15
Rtr_725_7256 tree_725 tree_7256 0.8192
Cp_7256 tree_7256 0 2.592e-15
Rtr_725_7257 tree_725 tree_7257 0.8192
Cp_7257 tree_7257 0 2.592e-15
Rtr_725_7258 tree_725 tree_7258 0.8192
Cp_7258 tree_7258 0 2.592e-15
Rtr_725_7259 tree_725 tree_7259 0.8192
Cp_7259 tree_7259 0 2.592e-15
Rtr_725_7260 tree_725 tree_7260 0.8192
Cp_7260 tree_7260 0 2.592e-15
Rtr_726_7261 tree_726 tree_7261 0.8192
Cp_7261 tree_7261 0 2.592e-15
Rtr_726_7262 tree_726 tree_7262 0.8192
Cp_7262 tree_7262 0 2.592e-15
Rtr_726_7263 tree_726 tree_7263 0.8192
Cp_7263 tree_7263 0 2.592e-15
Rtr_726_7264 tree_726 tree_7264 0.8192
Cp_7264 tree_7264 0 2.592e-15
Rtr_726_7265 tree_726 tree_7265 0.8192
Cp_7265 tree_7265 0 2.592e-15
Rtr_726_7266 tree_726 tree_7266 0.8192
Cp_7266 tree_7266 0 2.592e-15
Rtr_726_7267 tree_726 tree_7267 0.8192
Cp_7267 tree_7267 0 2.592e-15
Rtr_726_7268 tree_726 tree_7268 0.8192
Cp_7268 tree_7268 0 2.592e-15
Rtr_726_7269 tree_726 tree_7269 0.8192
Cp_7269 tree_7269 0 2.592e-15
Rtr_726_7270 tree_726 tree_7270 0.8192
Cp_7270 tree_7270 0 2.592e-15
Rtr_727_7271 tree_727 tree_7271 0.8192
Cp_7271 tree_7271 0 2.592e-15
Rtr_727_7272 tree_727 tree_7272 0.8192
Cp_7272 tree_7272 0 2.592e-15
Rtr_727_7273 tree_727 tree_7273 0.8192
Cp_7273 tree_7273 0 2.592e-15
Rtr_727_7274 tree_727 tree_7274 0.8192
Cp_7274 tree_7274 0 2.592e-15
Rtr_727_7275 tree_727 tree_7275 0.8192
Cp_7275 tree_7275 0 2.592e-15
Rtr_727_7276 tree_727 tree_7276 0.8192
Cp_7276 tree_7276 0 2.592e-15
Rtr_727_7277 tree_727 tree_7277 0.8192
Cp_7277 tree_7277 0 2.592e-15
Rtr_727_7278 tree_727 tree_7278 0.8192
Cp_7278 tree_7278 0 2.592e-15
Rtr_727_7279 tree_727 tree_7279 0.8192
Cp_7279 tree_7279 0 2.592e-15
Rtr_727_7280 tree_727 tree_7280 0.8192
Cp_7280 tree_7280 0 2.592e-15
Rtr_728_7281 tree_728 tree_7281 0.8192
Cp_7281 tree_7281 0 2.592e-15
Rtr_728_7282 tree_728 tree_7282 0.8192
Cp_7282 tree_7282 0 2.592e-15
Rtr_728_7283 tree_728 tree_7283 0.8192
Cp_7283 tree_7283 0 2.592e-15
Rtr_728_7284 tree_728 tree_7284 0.8192
Cp_7284 tree_7284 0 2.592e-15
Rtr_728_7285 tree_728 tree_7285 0.8192
Cp_7285 tree_7285 0 2.592e-15
Rtr_728_7286 tree_728 tree_7286 0.8192
Cp_7286 tree_7286 0 2.592e-15
Rtr_728_7287 tree_728 tree_7287 0.8192
Cp_7287 tree_7287 0 2.592e-15
Rtr_728_7288 tree_728 tree_7288 0.8192
Cp_7288 tree_7288 0 2.592e-15
Rtr_728_7289 tree_728 tree_7289 0.8192
Cp_7289 tree_7289 0 2.592e-15
Rtr_728_7290 tree_728 tree_7290 0.8192
Cp_7290 tree_7290 0 2.592e-15
Rtr_729_7291 tree_729 tree_7291 0.8192
Cp_7291 tree_7291 0 2.592e-15
Rtr_729_7292 tree_729 tree_7292 0.8192
Cp_7292 tree_7292 0 2.592e-15
Rtr_729_7293 tree_729 tree_7293 0.8192
Cp_7293 tree_7293 0 2.592e-15
Rtr_729_7294 tree_729 tree_7294 0.8192
Cp_7294 tree_7294 0 2.592e-15
Rtr_729_7295 tree_729 tree_7295 0.8192
Cp_7295 tree_7295 0 2.592e-15
Rtr_729_7296 tree_729 tree_7296 0.8192
Cp_7296 tree_7296 0 2.592e-15
Rtr_729_7297 tree_729 tree_7297 0.8192
Cp_7297 tree_7297 0 2.592e-15
Rtr_729_7298 tree_729 tree_7298 0.8192
Cp_7298 tree_7298 0 2.592e-15
Rtr_729_7299 tree_729 tree_7299 0.8192
Cp_7299 tree_7299 0 2.592e-15
Rtr_729_7300 tree_729 tree_7300 0.8192
Cp_7300 tree_7300 0 2.592e-15
Rtr_730_7301 tree_730 tree_7301 0.8192
Cp_7301 tree_7301 0 2.592e-15
Rtr_730_7302 tree_730 tree_7302 0.8192
Cp_7302 tree_7302 0 2.592e-15
Rtr_730_7303 tree_730 tree_7303 0.8192
Cp_7303 tree_7303 0 2.592e-15
Rtr_730_7304 tree_730 tree_7304 0.8192
Cp_7304 tree_7304 0 2.592e-15
Rtr_730_7305 tree_730 tree_7305 0.8192
Cp_7305 tree_7305 0 2.592e-15
Rtr_730_7306 tree_730 tree_7306 0.8192
Cp_7306 tree_7306 0 2.592e-15
Rtr_730_7307 tree_730 tree_7307 0.8192
Cp_7307 tree_7307 0 2.592e-15
Rtr_730_7308 tree_730 tree_7308 0.8192
Cp_7308 tree_7308 0 2.592e-15
Rtr_730_7309 tree_730 tree_7309 0.8192
Cp_7309 tree_7309 0 2.592e-15
Rtr_730_7310 tree_730 tree_7310 0.8192
Cp_7310 tree_7310 0 2.592e-15
Rtr_731_7311 tree_731 tree_7311 0.8192
Cp_7311 tree_7311 0 2.592e-15
Rtr_731_7312 tree_731 tree_7312 0.8192
Cp_7312 tree_7312 0 2.592e-15
Rtr_731_7313 tree_731 tree_7313 0.8192
Cp_7313 tree_7313 0 2.592e-15
Rtr_731_7314 tree_731 tree_7314 0.8192
Cp_7314 tree_7314 0 2.592e-15
Rtr_731_7315 tree_731 tree_7315 0.8192
Cp_7315 tree_7315 0 2.592e-15
Rtr_731_7316 tree_731 tree_7316 0.8192
Cp_7316 tree_7316 0 2.592e-15
Rtr_731_7317 tree_731 tree_7317 0.8192
Cp_7317 tree_7317 0 2.592e-15
Rtr_731_7318 tree_731 tree_7318 0.8192
Cp_7318 tree_7318 0 2.592e-15
Rtr_731_7319 tree_731 tree_7319 0.8192
Cp_7319 tree_7319 0 2.592e-15
Rtr_731_7320 tree_731 tree_7320 0.8192
Cp_7320 tree_7320 0 2.592e-15
Rtr_732_7321 tree_732 tree_7321 0.8192
Cp_7321 tree_7321 0 2.592e-15
Rtr_732_7322 tree_732 tree_7322 0.8192
Cp_7322 tree_7322 0 2.592e-15
Rtr_732_7323 tree_732 tree_7323 0.8192
Cp_7323 tree_7323 0 2.592e-15
Rtr_732_7324 tree_732 tree_7324 0.8192
Cp_7324 tree_7324 0 2.592e-15
Rtr_732_7325 tree_732 tree_7325 0.8192
Cp_7325 tree_7325 0 2.592e-15
Rtr_732_7326 tree_732 tree_7326 0.8192
Cp_7326 tree_7326 0 2.592e-15
Rtr_732_7327 tree_732 tree_7327 0.8192
Cp_7327 tree_7327 0 2.592e-15
Rtr_732_7328 tree_732 tree_7328 0.8192
Cp_7328 tree_7328 0 2.592e-15
Rtr_732_7329 tree_732 tree_7329 0.8192
Cp_7329 tree_7329 0 2.592e-15
Rtr_732_7330 tree_732 tree_7330 0.8192
Cp_7330 tree_7330 0 2.592e-15
Rtr_733_7331 tree_733 tree_7331 0.8192
Cp_7331 tree_7331 0 2.592e-15
Rtr_733_7332 tree_733 tree_7332 0.8192
Cp_7332 tree_7332 0 2.592e-15
Rtr_733_7333 tree_733 tree_7333 0.8192
Cp_7333 tree_7333 0 2.592e-15
Rtr_733_7334 tree_733 tree_7334 0.8192
Cp_7334 tree_7334 0 2.592e-15
Rtr_733_7335 tree_733 tree_7335 0.8192
Cp_7335 tree_7335 0 2.592e-15
Rtr_733_7336 tree_733 tree_7336 0.8192
Cp_7336 tree_7336 0 2.592e-15
Rtr_733_7337 tree_733 tree_7337 0.8192
Cp_7337 tree_7337 0 2.592e-15
Rtr_733_7338 tree_733 tree_7338 0.8192
Cp_7338 tree_7338 0 2.592e-15
Rtr_733_7339 tree_733 tree_7339 0.8192
Cp_7339 tree_7339 0 2.592e-15
Rtr_733_7340 tree_733 tree_7340 0.8192
Cp_7340 tree_7340 0 2.592e-15
Rtr_734_7341 tree_734 tree_7341 0.8192
Cp_7341 tree_7341 0 2.592e-15
Rtr_734_7342 tree_734 tree_7342 0.8192
Cp_7342 tree_7342 0 2.592e-15
Rtr_734_7343 tree_734 tree_7343 0.8192
Cp_7343 tree_7343 0 2.592e-15
Rtr_734_7344 tree_734 tree_7344 0.8192
Cp_7344 tree_7344 0 2.592e-15
Rtr_734_7345 tree_734 tree_7345 0.8192
Cp_7345 tree_7345 0 2.592e-15
Rtr_734_7346 tree_734 tree_7346 0.8192
Cp_7346 tree_7346 0 2.592e-15
Rtr_734_7347 tree_734 tree_7347 0.8192
Cp_7347 tree_7347 0 2.592e-15
Rtr_734_7348 tree_734 tree_7348 0.8192
Cp_7348 tree_7348 0 2.592e-15
Rtr_734_7349 tree_734 tree_7349 0.8192
Cp_7349 tree_7349 0 2.592e-15
Rtr_734_7350 tree_734 tree_7350 0.8192
Cp_7350 tree_7350 0 2.592e-15
Rtr_735_7351 tree_735 tree_7351 0.8192
Cp_7351 tree_7351 0 2.592e-15
Rtr_735_7352 tree_735 tree_7352 0.8192
Cp_7352 tree_7352 0 2.592e-15
Rtr_735_7353 tree_735 tree_7353 0.8192
Cp_7353 tree_7353 0 2.592e-15
Rtr_735_7354 tree_735 tree_7354 0.8192
Cp_7354 tree_7354 0 2.592e-15
Rtr_735_7355 tree_735 tree_7355 0.8192
Cp_7355 tree_7355 0 2.592e-15
Rtr_735_7356 tree_735 tree_7356 0.8192
Cp_7356 tree_7356 0 2.592e-15
Rtr_735_7357 tree_735 tree_7357 0.8192
Cp_7357 tree_7357 0 2.592e-15
Rtr_735_7358 tree_735 tree_7358 0.8192
Cp_7358 tree_7358 0 2.592e-15
Rtr_735_7359 tree_735 tree_7359 0.8192
Cp_7359 tree_7359 0 2.592e-15
Rtr_735_7360 tree_735 tree_7360 0.8192
Cp_7360 tree_7360 0 2.592e-15
Rtr_736_7361 tree_736 tree_7361 0.8192
Cp_7361 tree_7361 0 2.592e-15
Rtr_736_7362 tree_736 tree_7362 0.8192
Cp_7362 tree_7362 0 2.592e-15
Rtr_736_7363 tree_736 tree_7363 0.8192
Cp_7363 tree_7363 0 2.592e-15
Rtr_736_7364 tree_736 tree_7364 0.8192
Cp_7364 tree_7364 0 2.592e-15
Rtr_736_7365 tree_736 tree_7365 0.8192
Cp_7365 tree_7365 0 2.592e-15
Rtr_736_7366 tree_736 tree_7366 0.8192
Cp_7366 tree_7366 0 2.592e-15
Rtr_736_7367 tree_736 tree_7367 0.8192
Cp_7367 tree_7367 0 2.592e-15
Rtr_736_7368 tree_736 tree_7368 0.8192
Cp_7368 tree_7368 0 2.592e-15
Rtr_736_7369 tree_736 tree_7369 0.8192
Cp_7369 tree_7369 0 2.592e-15
Rtr_736_7370 tree_736 tree_7370 0.8192
Cp_7370 tree_7370 0 2.592e-15
Rtr_737_7371 tree_737 tree_7371 0.8192
Cp_7371 tree_7371 0 2.592e-15
Rtr_737_7372 tree_737 tree_7372 0.8192
Cp_7372 tree_7372 0 2.592e-15
Rtr_737_7373 tree_737 tree_7373 0.8192
Cp_7373 tree_7373 0 2.592e-15
Rtr_737_7374 tree_737 tree_7374 0.8192
Cp_7374 tree_7374 0 2.592e-15
Rtr_737_7375 tree_737 tree_7375 0.8192
Cp_7375 tree_7375 0 2.592e-15
Rtr_737_7376 tree_737 tree_7376 0.8192
Cp_7376 tree_7376 0 2.592e-15
Rtr_737_7377 tree_737 tree_7377 0.8192
Cp_7377 tree_7377 0 2.592e-15
Rtr_737_7378 tree_737 tree_7378 0.8192
Cp_7378 tree_7378 0 2.592e-15
Rtr_737_7379 tree_737 tree_7379 0.8192
Cp_7379 tree_7379 0 2.592e-15
Rtr_737_7380 tree_737 tree_7380 0.8192
Cp_7380 tree_7380 0 2.592e-15
Rtr_738_7381 tree_738 tree_7381 0.8192
Cp_7381 tree_7381 0 2.592e-15
Rtr_738_7382 tree_738 tree_7382 0.8192
Cp_7382 tree_7382 0 2.592e-15
Rtr_738_7383 tree_738 tree_7383 0.8192
Cp_7383 tree_7383 0 2.592e-15
Rtr_738_7384 tree_738 tree_7384 0.8192
Cp_7384 tree_7384 0 2.592e-15
Rtr_738_7385 tree_738 tree_7385 0.8192
Cp_7385 tree_7385 0 2.592e-15
Rtr_738_7386 tree_738 tree_7386 0.8192
Cp_7386 tree_7386 0 2.592e-15
Rtr_738_7387 tree_738 tree_7387 0.8192
Cp_7387 tree_7387 0 2.592e-15
Rtr_738_7388 tree_738 tree_7388 0.8192
Cp_7388 tree_7388 0 2.592e-15
Rtr_738_7389 tree_738 tree_7389 0.8192
Cp_7389 tree_7389 0 2.592e-15
Rtr_738_7390 tree_738 tree_7390 0.8192
Cp_7390 tree_7390 0 2.592e-15
Rtr_739_7391 tree_739 tree_7391 0.8192
Cp_7391 tree_7391 0 2.592e-15
Rtr_739_7392 tree_739 tree_7392 0.8192
Cp_7392 tree_7392 0 2.592e-15
Rtr_739_7393 tree_739 tree_7393 0.8192
Cp_7393 tree_7393 0 2.592e-15
Rtr_739_7394 tree_739 tree_7394 0.8192
Cp_7394 tree_7394 0 2.592e-15
Rtr_739_7395 tree_739 tree_7395 0.8192
Cp_7395 tree_7395 0 2.592e-15
Rtr_739_7396 tree_739 tree_7396 0.8192
Cp_7396 tree_7396 0 2.592e-15
Rtr_739_7397 tree_739 tree_7397 0.8192
Cp_7397 tree_7397 0 2.592e-15
Rtr_739_7398 tree_739 tree_7398 0.8192
Cp_7398 tree_7398 0 2.592e-15
Rtr_739_7399 tree_739 tree_7399 0.8192
Cp_7399 tree_7399 0 2.592e-15
Rtr_739_7400 tree_739 tree_7400 0.8192
Cp_7400 tree_7400 0 2.592e-15
Rtr_740_7401 tree_740 tree_7401 0.8192
Cp_7401 tree_7401 0 2.592e-15
Rtr_740_7402 tree_740 tree_7402 0.8192
Cp_7402 tree_7402 0 2.592e-15
Rtr_740_7403 tree_740 tree_7403 0.8192
Cp_7403 tree_7403 0 2.592e-15
Rtr_740_7404 tree_740 tree_7404 0.8192
Cp_7404 tree_7404 0 2.592e-15
Rtr_740_7405 tree_740 tree_7405 0.8192
Cp_7405 tree_7405 0 2.592e-15
Rtr_740_7406 tree_740 tree_7406 0.8192
Cp_7406 tree_7406 0 2.592e-15
Rtr_740_7407 tree_740 tree_7407 0.8192
Cp_7407 tree_7407 0 2.592e-15
Rtr_740_7408 tree_740 tree_7408 0.8192
Cp_7408 tree_7408 0 2.592e-15
Rtr_740_7409 tree_740 tree_7409 0.8192
Cp_7409 tree_7409 0 2.592e-15
Rtr_740_7410 tree_740 tree_7410 0.8192
Cp_7410 tree_7410 0 2.592e-15
Rtr_741_7411 tree_741 tree_7411 0.8192
Cp_7411 tree_7411 0 2.592e-15
Rtr_741_7412 tree_741 tree_7412 0.8192
Cp_7412 tree_7412 0 2.592e-15
Rtr_741_7413 tree_741 tree_7413 0.8192
Cp_7413 tree_7413 0 2.592e-15
Rtr_741_7414 tree_741 tree_7414 0.8192
Cp_7414 tree_7414 0 2.592e-15
Rtr_741_7415 tree_741 tree_7415 0.8192
Cp_7415 tree_7415 0 2.592e-15
Rtr_741_7416 tree_741 tree_7416 0.8192
Cp_7416 tree_7416 0 2.592e-15
Rtr_741_7417 tree_741 tree_7417 0.8192
Cp_7417 tree_7417 0 2.592e-15
Rtr_741_7418 tree_741 tree_7418 0.8192
Cp_7418 tree_7418 0 2.592e-15
Rtr_741_7419 tree_741 tree_7419 0.8192
Cp_7419 tree_7419 0 2.592e-15
Rtr_741_7420 tree_741 tree_7420 0.8192
Cp_7420 tree_7420 0 2.592e-15
Rtr_742_7421 tree_742 tree_7421 0.8192
Cp_7421 tree_7421 0 2.592e-15
Rtr_742_7422 tree_742 tree_7422 0.8192
Cp_7422 tree_7422 0 2.592e-15
Rtr_742_7423 tree_742 tree_7423 0.8192
Cp_7423 tree_7423 0 2.592e-15
Rtr_742_7424 tree_742 tree_7424 0.8192
Cp_7424 tree_7424 0 2.592e-15
Rtr_742_7425 tree_742 tree_7425 0.8192
Cp_7425 tree_7425 0 2.592e-15
Rtr_742_7426 tree_742 tree_7426 0.8192
Cp_7426 tree_7426 0 2.592e-15
Rtr_742_7427 tree_742 tree_7427 0.8192
Cp_7427 tree_7427 0 2.592e-15
Rtr_742_7428 tree_742 tree_7428 0.8192
Cp_7428 tree_7428 0 2.592e-15
Rtr_742_7429 tree_742 tree_7429 0.8192
Cp_7429 tree_7429 0 2.592e-15
Rtr_742_7430 tree_742 tree_7430 0.8192
Cp_7430 tree_7430 0 2.592e-15
Rtr_743_7431 tree_743 tree_7431 0.8192
Cp_7431 tree_7431 0 2.592e-15
Rtr_743_7432 tree_743 tree_7432 0.8192
Cp_7432 tree_7432 0 2.592e-15
Rtr_743_7433 tree_743 tree_7433 0.8192
Cp_7433 tree_7433 0 2.592e-15
Rtr_743_7434 tree_743 tree_7434 0.8192
Cp_7434 tree_7434 0 2.592e-15
Rtr_743_7435 tree_743 tree_7435 0.8192
Cp_7435 tree_7435 0 2.592e-15
Rtr_743_7436 tree_743 tree_7436 0.8192
Cp_7436 tree_7436 0 2.592e-15
Rtr_743_7437 tree_743 tree_7437 0.8192
Cp_7437 tree_7437 0 2.592e-15
Rtr_743_7438 tree_743 tree_7438 0.8192
Cp_7438 tree_7438 0 2.592e-15
Rtr_743_7439 tree_743 tree_7439 0.8192
Cp_7439 tree_7439 0 2.592e-15
Rtr_743_7440 tree_743 tree_7440 0.8192
Cp_7440 tree_7440 0 2.592e-15
Rtr_744_7441 tree_744 tree_7441 0.8192
Cp_7441 tree_7441 0 2.592e-15
Rtr_744_7442 tree_744 tree_7442 0.8192
Cp_7442 tree_7442 0 2.592e-15
Rtr_744_7443 tree_744 tree_7443 0.8192
Cp_7443 tree_7443 0 2.592e-15
Rtr_744_7444 tree_744 tree_7444 0.8192
Cp_7444 tree_7444 0 2.592e-15
Rtr_744_7445 tree_744 tree_7445 0.8192
Cp_7445 tree_7445 0 2.592e-15
Rtr_744_7446 tree_744 tree_7446 0.8192
Cp_7446 tree_7446 0 2.592e-15
Rtr_744_7447 tree_744 tree_7447 0.8192
Cp_7447 tree_7447 0 2.592e-15
Rtr_744_7448 tree_744 tree_7448 0.8192
Cp_7448 tree_7448 0 2.592e-15
Rtr_744_7449 tree_744 tree_7449 0.8192
Cp_7449 tree_7449 0 2.592e-15
Rtr_744_7450 tree_744 tree_7450 0.8192
Cp_7450 tree_7450 0 2.592e-15
Rtr_745_7451 tree_745 tree_7451 0.8192
Cp_7451 tree_7451 0 2.592e-15
Rtr_745_7452 tree_745 tree_7452 0.8192
Cp_7452 tree_7452 0 2.592e-15
Rtr_745_7453 tree_745 tree_7453 0.8192
Cp_7453 tree_7453 0 2.592e-15
Rtr_745_7454 tree_745 tree_7454 0.8192
Cp_7454 tree_7454 0 2.592e-15
Rtr_745_7455 tree_745 tree_7455 0.8192
Cp_7455 tree_7455 0 2.592e-15
Rtr_745_7456 tree_745 tree_7456 0.8192
Cp_7456 tree_7456 0 2.592e-15
Rtr_745_7457 tree_745 tree_7457 0.8192
Cp_7457 tree_7457 0 2.592e-15
Rtr_745_7458 tree_745 tree_7458 0.8192
Cp_7458 tree_7458 0 2.592e-15
Rtr_745_7459 tree_745 tree_7459 0.8192
Cp_7459 tree_7459 0 2.592e-15
Rtr_745_7460 tree_745 tree_7460 0.8192
Cp_7460 tree_7460 0 2.592e-15
Rtr_746_7461 tree_746 tree_7461 0.8192
Cp_7461 tree_7461 0 2.592e-15
Rtr_746_7462 tree_746 tree_7462 0.8192
Cp_7462 tree_7462 0 2.592e-15
Rtr_746_7463 tree_746 tree_7463 0.8192
Cp_7463 tree_7463 0 2.592e-15
Rtr_746_7464 tree_746 tree_7464 0.8192
Cp_7464 tree_7464 0 2.592e-15
Rtr_746_7465 tree_746 tree_7465 0.8192
Cp_7465 tree_7465 0 2.592e-15
Rtr_746_7466 tree_746 tree_7466 0.8192
Cp_7466 tree_7466 0 2.592e-15
Rtr_746_7467 tree_746 tree_7467 0.8192
Cp_7467 tree_7467 0 2.592e-15
Rtr_746_7468 tree_746 tree_7468 0.8192
Cp_7468 tree_7468 0 2.592e-15
Rtr_746_7469 tree_746 tree_7469 0.8192
Cp_7469 tree_7469 0 2.592e-15
Rtr_746_7470 tree_746 tree_7470 0.8192
Cp_7470 tree_7470 0 2.592e-15
Rtr_747_7471 tree_747 tree_7471 0.8192
Cp_7471 tree_7471 0 2.592e-15
Rtr_747_7472 tree_747 tree_7472 0.8192
Cp_7472 tree_7472 0 2.592e-15
Rtr_747_7473 tree_747 tree_7473 0.8192
Cp_7473 tree_7473 0 2.592e-15
Rtr_747_7474 tree_747 tree_7474 0.8192
Cp_7474 tree_7474 0 2.592e-15
Rtr_747_7475 tree_747 tree_7475 0.8192
Cp_7475 tree_7475 0 2.592e-15
Rtr_747_7476 tree_747 tree_7476 0.8192
Cp_7476 tree_7476 0 2.592e-15
Rtr_747_7477 tree_747 tree_7477 0.8192
Cp_7477 tree_7477 0 2.592e-15
Rtr_747_7478 tree_747 tree_7478 0.8192
Cp_7478 tree_7478 0 2.592e-15
Rtr_747_7479 tree_747 tree_7479 0.8192
Cp_7479 tree_7479 0 2.592e-15
Rtr_747_7480 tree_747 tree_7480 0.8192
Cp_7480 tree_7480 0 2.592e-15
Rtr_748_7481 tree_748 tree_7481 0.8192
Cp_7481 tree_7481 0 2.592e-15
Rtr_748_7482 tree_748 tree_7482 0.8192
Cp_7482 tree_7482 0 2.592e-15
Rtr_748_7483 tree_748 tree_7483 0.8192
Cp_7483 tree_7483 0 2.592e-15
Rtr_748_7484 tree_748 tree_7484 0.8192
Cp_7484 tree_7484 0 2.592e-15
Rtr_748_7485 tree_748 tree_7485 0.8192
Cp_7485 tree_7485 0 2.592e-15
Rtr_748_7486 tree_748 tree_7486 0.8192
Cp_7486 tree_7486 0 2.592e-15
Rtr_748_7487 tree_748 tree_7487 0.8192
Cp_7487 tree_7487 0 2.592e-15
Rtr_748_7488 tree_748 tree_7488 0.8192
Cp_7488 tree_7488 0 2.592e-15
Rtr_748_7489 tree_748 tree_7489 0.8192
Cp_7489 tree_7489 0 2.592e-15
Rtr_748_7490 tree_748 tree_7490 0.8192
Cp_7490 tree_7490 0 2.592e-15
Rtr_749_7491 tree_749 tree_7491 0.8192
Cp_7491 tree_7491 0 2.592e-15
Rtr_749_7492 tree_749 tree_7492 0.8192
Cp_7492 tree_7492 0 2.592e-15
Rtr_749_7493 tree_749 tree_7493 0.8192
Cp_7493 tree_7493 0 2.592e-15
Rtr_749_7494 tree_749 tree_7494 0.8192
Cp_7494 tree_7494 0 2.592e-15
Rtr_749_7495 tree_749 tree_7495 0.8192
Cp_7495 tree_7495 0 2.592e-15
Rtr_749_7496 tree_749 tree_7496 0.8192
Cp_7496 tree_7496 0 2.592e-15
Rtr_749_7497 tree_749 tree_7497 0.8192
Cp_7497 tree_7497 0 2.592e-15
Rtr_749_7498 tree_749 tree_7498 0.8192
Cp_7498 tree_7498 0 2.592e-15
Rtr_749_7499 tree_749 tree_7499 0.8192
Cp_7499 tree_7499 0 2.592e-15
Rtr_749_7500 tree_749 tree_7500 0.8192
Cp_7500 tree_7500 0 2.592e-15
Rtr_750_7501 tree_750 tree_7501 0.8192
Cp_7501 tree_7501 0 2.592e-15
Rtr_750_7502 tree_750 tree_7502 0.8192
Cp_7502 tree_7502 0 2.592e-15
Rtr_750_7503 tree_750 tree_7503 0.8192
Cp_7503 tree_7503 0 2.592e-15
Rtr_750_7504 tree_750 tree_7504 0.8192
Cp_7504 tree_7504 0 2.592e-15
Rtr_750_7505 tree_750 tree_7505 0.8192
Cp_7505 tree_7505 0 2.592e-15
Rtr_750_7506 tree_750 tree_7506 0.8192
Cp_7506 tree_7506 0 2.592e-15
Rtr_750_7507 tree_750 tree_7507 0.8192
Cp_7507 tree_7507 0 2.592e-15
Rtr_750_7508 tree_750 tree_7508 0.8192
Cp_7508 tree_7508 0 2.592e-15
Rtr_750_7509 tree_750 tree_7509 0.8192
Cp_7509 tree_7509 0 2.592e-15
Rtr_750_7510 tree_750 tree_7510 0.8192
Cp_7510 tree_7510 0 2.592e-15
Rtr_751_7511 tree_751 tree_7511 0.8192
Cp_7511 tree_7511 0 2.592e-15
Rtr_751_7512 tree_751 tree_7512 0.8192
Cp_7512 tree_7512 0 2.592e-15
Rtr_751_7513 tree_751 tree_7513 0.8192
Cp_7513 tree_7513 0 2.592e-15
Rtr_751_7514 tree_751 tree_7514 0.8192
Cp_7514 tree_7514 0 2.592e-15
Rtr_751_7515 tree_751 tree_7515 0.8192
Cp_7515 tree_7515 0 2.592e-15
Rtr_751_7516 tree_751 tree_7516 0.8192
Cp_7516 tree_7516 0 2.592e-15
Rtr_751_7517 tree_751 tree_7517 0.8192
Cp_7517 tree_7517 0 2.592e-15
Rtr_751_7518 tree_751 tree_7518 0.8192
Cp_7518 tree_7518 0 2.592e-15
Rtr_751_7519 tree_751 tree_7519 0.8192
Cp_7519 tree_7519 0 2.592e-15
Rtr_751_7520 tree_751 tree_7520 0.8192
Cp_7520 tree_7520 0 2.592e-15
Rtr_752_7521 tree_752 tree_7521 0.8192
Cp_7521 tree_7521 0 2.592e-15
Rtr_752_7522 tree_752 tree_7522 0.8192
Cp_7522 tree_7522 0 2.592e-15
Rtr_752_7523 tree_752 tree_7523 0.8192
Cp_7523 tree_7523 0 2.592e-15
Rtr_752_7524 tree_752 tree_7524 0.8192
Cp_7524 tree_7524 0 2.592e-15
Rtr_752_7525 tree_752 tree_7525 0.8192
Cp_7525 tree_7525 0 2.592e-15
Rtr_752_7526 tree_752 tree_7526 0.8192
Cp_7526 tree_7526 0 2.592e-15
Rtr_752_7527 tree_752 tree_7527 0.8192
Cp_7527 tree_7527 0 2.592e-15
Rtr_752_7528 tree_752 tree_7528 0.8192
Cp_7528 tree_7528 0 2.592e-15
Rtr_752_7529 tree_752 tree_7529 0.8192
Cp_7529 tree_7529 0 2.592e-15
Rtr_752_7530 tree_752 tree_7530 0.8192
Cp_7530 tree_7530 0 2.592e-15
Rtr_753_7531 tree_753 tree_7531 0.8192
Cp_7531 tree_7531 0 2.592e-15
Rtr_753_7532 tree_753 tree_7532 0.8192
Cp_7532 tree_7532 0 2.592e-15
Rtr_753_7533 tree_753 tree_7533 0.8192
Cp_7533 tree_7533 0 2.592e-15
Rtr_753_7534 tree_753 tree_7534 0.8192
Cp_7534 tree_7534 0 2.592e-15
Rtr_753_7535 tree_753 tree_7535 0.8192
Cp_7535 tree_7535 0 2.592e-15
Rtr_753_7536 tree_753 tree_7536 0.8192
Cp_7536 tree_7536 0 2.592e-15
Rtr_753_7537 tree_753 tree_7537 0.8192
Cp_7537 tree_7537 0 2.592e-15
Rtr_753_7538 tree_753 tree_7538 0.8192
Cp_7538 tree_7538 0 2.592e-15
Rtr_753_7539 tree_753 tree_7539 0.8192
Cp_7539 tree_7539 0 2.592e-15
Rtr_753_7540 tree_753 tree_7540 0.8192
Cp_7540 tree_7540 0 2.592e-15
Rtr_754_7541 tree_754 tree_7541 0.8192
Cp_7541 tree_7541 0 2.592e-15
Rtr_754_7542 tree_754 tree_7542 0.8192
Cp_7542 tree_7542 0 2.592e-15
Rtr_754_7543 tree_754 tree_7543 0.8192
Cp_7543 tree_7543 0 2.592e-15
Rtr_754_7544 tree_754 tree_7544 0.8192
Cp_7544 tree_7544 0 2.592e-15
Rtr_754_7545 tree_754 tree_7545 0.8192
Cp_7545 tree_7545 0 2.592e-15
Rtr_754_7546 tree_754 tree_7546 0.8192
Cp_7546 tree_7546 0 2.592e-15
Rtr_754_7547 tree_754 tree_7547 0.8192
Cp_7547 tree_7547 0 2.592e-15
Rtr_754_7548 tree_754 tree_7548 0.8192
Cp_7548 tree_7548 0 2.592e-15
Rtr_754_7549 tree_754 tree_7549 0.8192
Cp_7549 tree_7549 0 2.592e-15
Rtr_754_7550 tree_754 tree_7550 0.8192
Cp_7550 tree_7550 0 2.592e-15
Rtr_755_7551 tree_755 tree_7551 0.8192
Cp_7551 tree_7551 0 2.592e-15
Rtr_755_7552 tree_755 tree_7552 0.8192
Cp_7552 tree_7552 0 2.592e-15
Rtr_755_7553 tree_755 tree_7553 0.8192
Cp_7553 tree_7553 0 2.592e-15
Rtr_755_7554 tree_755 tree_7554 0.8192
Cp_7554 tree_7554 0 2.592e-15
Rtr_755_7555 tree_755 tree_7555 0.8192
Cp_7555 tree_7555 0 2.592e-15
Rtr_755_7556 tree_755 tree_7556 0.8192
Cp_7556 tree_7556 0 2.592e-15
Rtr_755_7557 tree_755 tree_7557 0.8192
Cp_7557 tree_7557 0 2.592e-15
Rtr_755_7558 tree_755 tree_7558 0.8192
Cp_7558 tree_7558 0 2.592e-15
Rtr_755_7559 tree_755 tree_7559 0.8192
Cp_7559 tree_7559 0 2.592e-15
Rtr_755_7560 tree_755 tree_7560 0.8192
Cp_7560 tree_7560 0 2.592e-15
Rtr_756_7561 tree_756 tree_7561 0.8192
Cp_7561 tree_7561 0 2.592e-15
Rtr_756_7562 tree_756 tree_7562 0.8192
Cp_7562 tree_7562 0 2.592e-15
Rtr_756_7563 tree_756 tree_7563 0.8192
Cp_7563 tree_7563 0 2.592e-15
Rtr_756_7564 tree_756 tree_7564 0.8192
Cp_7564 tree_7564 0 2.592e-15
Rtr_756_7565 tree_756 tree_7565 0.8192
Cp_7565 tree_7565 0 2.592e-15
Rtr_756_7566 tree_756 tree_7566 0.8192
Cp_7566 tree_7566 0 2.592e-15
Rtr_756_7567 tree_756 tree_7567 0.8192
Cp_7567 tree_7567 0 2.592e-15
Rtr_756_7568 tree_756 tree_7568 0.8192
Cp_7568 tree_7568 0 2.592e-15
Rtr_756_7569 tree_756 tree_7569 0.8192
Cp_7569 tree_7569 0 2.592e-15
Rtr_756_7570 tree_756 tree_7570 0.8192
Cp_7570 tree_7570 0 2.592e-15
Rtr_757_7571 tree_757 tree_7571 0.8192
Cp_7571 tree_7571 0 2.592e-15
Rtr_757_7572 tree_757 tree_7572 0.8192
Cp_7572 tree_7572 0 2.592e-15
Rtr_757_7573 tree_757 tree_7573 0.8192
Cp_7573 tree_7573 0 2.592e-15
Rtr_757_7574 tree_757 tree_7574 0.8192
Cp_7574 tree_7574 0 2.592e-15
Rtr_757_7575 tree_757 tree_7575 0.8192
Cp_7575 tree_7575 0 2.592e-15
Rtr_757_7576 tree_757 tree_7576 0.8192
Cp_7576 tree_7576 0 2.592e-15
Rtr_757_7577 tree_757 tree_7577 0.8192
Cp_7577 tree_7577 0 2.592e-15
Rtr_757_7578 tree_757 tree_7578 0.8192
Cp_7578 tree_7578 0 2.592e-15
Rtr_757_7579 tree_757 tree_7579 0.8192
Cp_7579 tree_7579 0 2.592e-15
Rtr_757_7580 tree_757 tree_7580 0.8192
Cp_7580 tree_7580 0 2.592e-15
Rtr_758_7581 tree_758 tree_7581 0.8192
Cp_7581 tree_7581 0 2.592e-15
Rtr_758_7582 tree_758 tree_7582 0.8192
Cp_7582 tree_7582 0 2.592e-15
Rtr_758_7583 tree_758 tree_7583 0.8192
Cp_7583 tree_7583 0 2.592e-15
Rtr_758_7584 tree_758 tree_7584 0.8192
Cp_7584 tree_7584 0 2.592e-15
Rtr_758_7585 tree_758 tree_7585 0.8192
Cp_7585 tree_7585 0 2.592e-15
Rtr_758_7586 tree_758 tree_7586 0.8192
Cp_7586 tree_7586 0 2.592e-15
Rtr_758_7587 tree_758 tree_7587 0.8192
Cp_7587 tree_7587 0 2.592e-15
Rtr_758_7588 tree_758 tree_7588 0.8192
Cp_7588 tree_7588 0 2.592e-15
Rtr_758_7589 tree_758 tree_7589 0.8192
Cp_7589 tree_7589 0 2.592e-15
Rtr_758_7590 tree_758 tree_7590 0.8192
Cp_7590 tree_7590 0 2.592e-15
Rtr_759_7591 tree_759 tree_7591 0.8192
Cp_7591 tree_7591 0 2.592e-15
Rtr_759_7592 tree_759 tree_7592 0.8192
Cp_7592 tree_7592 0 2.592e-15
Rtr_759_7593 tree_759 tree_7593 0.8192
Cp_7593 tree_7593 0 2.592e-15
Rtr_759_7594 tree_759 tree_7594 0.8192
Cp_7594 tree_7594 0 2.592e-15
Rtr_759_7595 tree_759 tree_7595 0.8192
Cp_7595 tree_7595 0 2.592e-15
Rtr_759_7596 tree_759 tree_7596 0.8192
Cp_7596 tree_7596 0 2.592e-15
Rtr_759_7597 tree_759 tree_7597 0.8192
Cp_7597 tree_7597 0 2.592e-15
Rtr_759_7598 tree_759 tree_7598 0.8192
Cp_7598 tree_7598 0 2.592e-15
Rtr_759_7599 tree_759 tree_7599 0.8192
Cp_7599 tree_7599 0 2.592e-15
Rtr_759_7600 tree_759 tree_7600 0.8192
Cp_7600 tree_7600 0 2.592e-15
Rtr_760_7601 tree_760 tree_7601 0.8192
Cp_7601 tree_7601 0 2.592e-15
Rtr_760_7602 tree_760 tree_7602 0.8192
Cp_7602 tree_7602 0 2.592e-15
Rtr_760_7603 tree_760 tree_7603 0.8192
Cp_7603 tree_7603 0 2.592e-15
Rtr_760_7604 tree_760 tree_7604 0.8192
Cp_7604 tree_7604 0 2.592e-15
Rtr_760_7605 tree_760 tree_7605 0.8192
Cp_7605 tree_7605 0 2.592e-15
Rtr_760_7606 tree_760 tree_7606 0.8192
Cp_7606 tree_7606 0 2.592e-15
Rtr_760_7607 tree_760 tree_7607 0.8192
Cp_7607 tree_7607 0 2.592e-15
Rtr_760_7608 tree_760 tree_7608 0.8192
Cp_7608 tree_7608 0 2.592e-15
Rtr_760_7609 tree_760 tree_7609 0.8192
Cp_7609 tree_7609 0 2.592e-15
Rtr_760_7610 tree_760 tree_7610 0.8192
Cp_7610 tree_7610 0 2.592e-15
Rtr_761_7611 tree_761 tree_7611 0.8192
Cp_7611 tree_7611 0 2.592e-15
Rtr_761_7612 tree_761 tree_7612 0.8192
Cp_7612 tree_7612 0 2.592e-15
Rtr_761_7613 tree_761 tree_7613 0.8192
Cp_7613 tree_7613 0 2.592e-15
Rtr_761_7614 tree_761 tree_7614 0.8192
Cp_7614 tree_7614 0 2.592e-15
Rtr_761_7615 tree_761 tree_7615 0.8192
Cp_7615 tree_7615 0 2.592e-15
Rtr_761_7616 tree_761 tree_7616 0.8192
Cp_7616 tree_7616 0 2.592e-15
Rtr_761_7617 tree_761 tree_7617 0.8192
Cp_7617 tree_7617 0 2.592e-15
Rtr_761_7618 tree_761 tree_7618 0.8192
Cp_7618 tree_7618 0 2.592e-15
Rtr_761_7619 tree_761 tree_7619 0.8192
Cp_7619 tree_7619 0 2.592e-15
Rtr_761_7620 tree_761 tree_7620 0.8192
Cp_7620 tree_7620 0 2.592e-15
Rtr_762_7621 tree_762 tree_7621 0.8192
Cp_7621 tree_7621 0 2.592e-15
Rtr_762_7622 tree_762 tree_7622 0.8192
Cp_7622 tree_7622 0 2.592e-15
Rtr_762_7623 tree_762 tree_7623 0.8192
Cp_7623 tree_7623 0 2.592e-15
Rtr_762_7624 tree_762 tree_7624 0.8192
Cp_7624 tree_7624 0 2.592e-15
Rtr_762_7625 tree_762 tree_7625 0.8192
Cp_7625 tree_7625 0 2.592e-15
Rtr_762_7626 tree_762 tree_7626 0.8192
Cp_7626 tree_7626 0 2.592e-15
Rtr_762_7627 tree_762 tree_7627 0.8192
Cp_7627 tree_7627 0 2.592e-15
Rtr_762_7628 tree_762 tree_7628 0.8192
Cp_7628 tree_7628 0 2.592e-15
Rtr_762_7629 tree_762 tree_7629 0.8192
Cp_7629 tree_7629 0 2.592e-15
Rtr_762_7630 tree_762 tree_7630 0.8192
Cp_7630 tree_7630 0 2.592e-15
Rtr_763_7631 tree_763 tree_7631 0.8192
Cp_7631 tree_7631 0 2.592e-15
Rtr_763_7632 tree_763 tree_7632 0.8192
Cp_7632 tree_7632 0 2.592e-15
Rtr_763_7633 tree_763 tree_7633 0.8192
Cp_7633 tree_7633 0 2.592e-15
Rtr_763_7634 tree_763 tree_7634 0.8192
Cp_7634 tree_7634 0 2.592e-15
Rtr_763_7635 tree_763 tree_7635 0.8192
Cp_7635 tree_7635 0 2.592e-15
Rtr_763_7636 tree_763 tree_7636 0.8192
Cp_7636 tree_7636 0 2.592e-15
Rtr_763_7637 tree_763 tree_7637 0.8192
Cp_7637 tree_7637 0 2.592e-15
Rtr_763_7638 tree_763 tree_7638 0.8192
Cp_7638 tree_7638 0 2.592e-15
Rtr_763_7639 tree_763 tree_7639 0.8192
Cp_7639 tree_7639 0 2.592e-15
Rtr_763_7640 tree_763 tree_7640 0.8192
Cp_7640 tree_7640 0 2.592e-15
Rtr_764_7641 tree_764 tree_7641 0.8192
Cp_7641 tree_7641 0 2.592e-15
Rtr_764_7642 tree_764 tree_7642 0.8192
Cp_7642 tree_7642 0 2.592e-15
Rtr_764_7643 tree_764 tree_7643 0.8192
Cp_7643 tree_7643 0 2.592e-15
Rtr_764_7644 tree_764 tree_7644 0.8192
Cp_7644 tree_7644 0 2.592e-15
Rtr_764_7645 tree_764 tree_7645 0.8192
Cp_7645 tree_7645 0 2.592e-15
Rtr_764_7646 tree_764 tree_7646 0.8192
Cp_7646 tree_7646 0 2.592e-15
Rtr_764_7647 tree_764 tree_7647 0.8192
Cp_7647 tree_7647 0 2.592e-15
Rtr_764_7648 tree_764 tree_7648 0.8192
Cp_7648 tree_7648 0 2.592e-15
Rtr_764_7649 tree_764 tree_7649 0.8192
Cp_7649 tree_7649 0 2.592e-15
Rtr_764_7650 tree_764 tree_7650 0.8192
Cp_7650 tree_7650 0 2.592e-15
Rtr_765_7651 tree_765 tree_7651 0.8192
Cp_7651 tree_7651 0 2.592e-15
Rtr_765_7652 tree_765 tree_7652 0.8192
Cp_7652 tree_7652 0 2.592e-15
Rtr_765_7653 tree_765 tree_7653 0.8192
Cp_7653 tree_7653 0 2.592e-15
Rtr_765_7654 tree_765 tree_7654 0.8192
Cp_7654 tree_7654 0 2.592e-15
Rtr_765_7655 tree_765 tree_7655 0.8192
Cp_7655 tree_7655 0 2.592e-15
Rtr_765_7656 tree_765 tree_7656 0.8192
Cp_7656 tree_7656 0 2.592e-15
Rtr_765_7657 tree_765 tree_7657 0.8192
Cp_7657 tree_7657 0 2.592e-15
Rtr_765_7658 tree_765 tree_7658 0.8192
Cp_7658 tree_7658 0 2.592e-15
Rtr_765_7659 tree_765 tree_7659 0.8192
Cp_7659 tree_7659 0 2.592e-15
Rtr_765_7660 tree_765 tree_7660 0.8192
Cp_7660 tree_7660 0 2.592e-15
Rtr_766_7661 tree_766 tree_7661 0.8192
Cp_7661 tree_7661 0 2.592e-15
Rtr_766_7662 tree_766 tree_7662 0.8192
Cp_7662 tree_7662 0 2.592e-15
Rtr_766_7663 tree_766 tree_7663 0.8192
Cp_7663 tree_7663 0 2.592e-15
Rtr_766_7664 tree_766 tree_7664 0.8192
Cp_7664 tree_7664 0 2.592e-15
Rtr_766_7665 tree_766 tree_7665 0.8192
Cp_7665 tree_7665 0 2.592e-15
Rtr_766_7666 tree_766 tree_7666 0.8192
Cp_7666 tree_7666 0 2.592e-15
Rtr_766_7667 tree_766 tree_7667 0.8192
Cp_7667 tree_7667 0 2.592e-15
Rtr_766_7668 tree_766 tree_7668 0.8192
Cp_7668 tree_7668 0 2.592e-15
Rtr_766_7669 tree_766 tree_7669 0.8192
Cp_7669 tree_7669 0 2.592e-15
Rtr_766_7670 tree_766 tree_7670 0.8192
Cp_7670 tree_7670 0 2.592e-15
Rtr_767_7671 tree_767 tree_7671 0.8192
Cp_7671 tree_7671 0 2.592e-15
Rtr_767_7672 tree_767 tree_7672 0.8192
Cp_7672 tree_7672 0 2.592e-15
Rtr_767_7673 tree_767 tree_7673 0.8192
Cp_7673 tree_7673 0 2.592e-15
Rtr_767_7674 tree_767 tree_7674 0.8192
Cp_7674 tree_7674 0 2.592e-15
Rtr_767_7675 tree_767 tree_7675 0.8192
Cp_7675 tree_7675 0 2.592e-15
Rtr_767_7676 tree_767 tree_7676 0.8192
Cp_7676 tree_7676 0 2.592e-15
Rtr_767_7677 tree_767 tree_7677 0.8192
Cp_7677 tree_7677 0 2.592e-15
Rtr_767_7678 tree_767 tree_7678 0.8192
Cp_7678 tree_7678 0 2.592e-15
Rtr_767_7679 tree_767 tree_7679 0.8192
Cp_7679 tree_7679 0 2.592e-15
Rtr_767_7680 tree_767 tree_7680 0.8192
Cp_7680 tree_7680 0 2.592e-15
Rtr_768_7681 tree_768 tree_7681 0.8192
Cp_7681 tree_7681 0 2.592e-15
Rtr_768_7682 tree_768 tree_7682 0.8192
Cp_7682 tree_7682 0 2.592e-15
Rtr_768_7683 tree_768 tree_7683 0.8192
Cp_7683 tree_7683 0 2.592e-15
Rtr_768_7684 tree_768 tree_7684 0.8192
Cp_7684 tree_7684 0 2.592e-15
Rtr_768_7685 tree_768 tree_7685 0.8192
Cp_7685 tree_7685 0 2.592e-15
Rtr_768_7686 tree_768 tree_7686 0.8192
Cp_7686 tree_7686 0 2.592e-15
Rtr_768_7687 tree_768 tree_7687 0.8192
Cp_7687 tree_7687 0 2.592e-15
Rtr_768_7688 tree_768 tree_7688 0.8192
Cp_7688 tree_7688 0 2.592e-15
Rtr_768_7689 tree_768 tree_7689 0.8192
Cp_7689 tree_7689 0 2.592e-15
Rtr_768_7690 tree_768 tree_7690 0.8192
Cp_7690 tree_7690 0 2.592e-15
Rtr_769_7691 tree_769 tree_7691 0.8192
Cp_7691 tree_7691 0 2.592e-15
Rtr_769_7692 tree_769 tree_7692 0.8192
Cp_7692 tree_7692 0 2.592e-15
Rtr_769_7693 tree_769 tree_7693 0.8192
Cp_7693 tree_7693 0 2.592e-15
Rtr_769_7694 tree_769 tree_7694 0.8192
Cp_7694 tree_7694 0 2.592e-15
Rtr_769_7695 tree_769 tree_7695 0.8192
Cp_7695 tree_7695 0 2.592e-15
Rtr_769_7696 tree_769 tree_7696 0.8192
Cp_7696 tree_7696 0 2.592e-15
Rtr_769_7697 tree_769 tree_7697 0.8192
Cp_7697 tree_7697 0 2.592e-15
Rtr_769_7698 tree_769 tree_7698 0.8192
Cp_7698 tree_7698 0 2.592e-15
Rtr_769_7699 tree_769 tree_7699 0.8192
Cp_7699 tree_7699 0 2.592e-15
Rtr_769_7700 tree_769 tree_7700 0.8192
Cp_7700 tree_7700 0 2.592e-15
Rtr_770_7701 tree_770 tree_7701 0.8192
Cp_7701 tree_7701 0 2.592e-15
Rtr_770_7702 tree_770 tree_7702 0.8192
Cp_7702 tree_7702 0 2.592e-15
Rtr_770_7703 tree_770 tree_7703 0.8192
Cp_7703 tree_7703 0 2.592e-15
Rtr_770_7704 tree_770 tree_7704 0.8192
Cp_7704 tree_7704 0 2.592e-15
Rtr_770_7705 tree_770 tree_7705 0.8192
Cp_7705 tree_7705 0 2.592e-15
Rtr_770_7706 tree_770 tree_7706 0.8192
Cp_7706 tree_7706 0 2.592e-15
Rtr_770_7707 tree_770 tree_7707 0.8192
Cp_7707 tree_7707 0 2.592e-15
Rtr_770_7708 tree_770 tree_7708 0.8192
Cp_7708 tree_7708 0 2.592e-15
Rtr_770_7709 tree_770 tree_7709 0.8192
Cp_7709 tree_7709 0 2.592e-15
Rtr_770_7710 tree_770 tree_7710 0.8192
Cp_7710 tree_7710 0 2.592e-15
Rtr_771_7711 tree_771 tree_7711 0.8192
Cp_7711 tree_7711 0 2.592e-15
Rtr_771_7712 tree_771 tree_7712 0.8192
Cp_7712 tree_7712 0 2.592e-15
Rtr_771_7713 tree_771 tree_7713 0.8192
Cp_7713 tree_7713 0 2.592e-15
Rtr_771_7714 tree_771 tree_7714 0.8192
Cp_7714 tree_7714 0 2.592e-15
Rtr_771_7715 tree_771 tree_7715 0.8192
Cp_7715 tree_7715 0 2.592e-15
Rtr_771_7716 tree_771 tree_7716 0.8192
Cp_7716 tree_7716 0 2.592e-15
Rtr_771_7717 tree_771 tree_7717 0.8192
Cp_7717 tree_7717 0 2.592e-15
Rtr_771_7718 tree_771 tree_7718 0.8192
Cp_7718 tree_7718 0 2.592e-15
Rtr_771_7719 tree_771 tree_7719 0.8192
Cp_7719 tree_7719 0 2.592e-15
Rtr_771_7720 tree_771 tree_7720 0.8192
Cp_7720 tree_7720 0 2.592e-15
Rtr_772_7721 tree_772 tree_7721 0.8192
Cp_7721 tree_7721 0 2.592e-15
Rtr_772_7722 tree_772 tree_7722 0.8192
Cp_7722 tree_7722 0 2.592e-15
Rtr_772_7723 tree_772 tree_7723 0.8192
Cp_7723 tree_7723 0 2.592e-15
Rtr_772_7724 tree_772 tree_7724 0.8192
Cp_7724 tree_7724 0 2.592e-15
Rtr_772_7725 tree_772 tree_7725 0.8192
Cp_7725 tree_7725 0 2.592e-15
Rtr_772_7726 tree_772 tree_7726 0.8192
Cp_7726 tree_7726 0 2.592e-15
Rtr_772_7727 tree_772 tree_7727 0.8192
Cp_7727 tree_7727 0 2.592e-15
Rtr_772_7728 tree_772 tree_7728 0.8192
Cp_7728 tree_7728 0 2.592e-15
Rtr_772_7729 tree_772 tree_7729 0.8192
Cp_7729 tree_7729 0 2.592e-15
Rtr_772_7730 tree_772 tree_7730 0.8192
Cp_7730 tree_7730 0 2.592e-15
Rtr_773_7731 tree_773 tree_7731 0.8192
Cp_7731 tree_7731 0 2.592e-15
Rtr_773_7732 tree_773 tree_7732 0.8192
Cp_7732 tree_7732 0 2.592e-15
Rtr_773_7733 tree_773 tree_7733 0.8192
Cp_7733 tree_7733 0 2.592e-15
Rtr_773_7734 tree_773 tree_7734 0.8192
Cp_7734 tree_7734 0 2.592e-15
Rtr_773_7735 tree_773 tree_7735 0.8192
Cp_7735 tree_7735 0 2.592e-15
Rtr_773_7736 tree_773 tree_7736 0.8192
Cp_7736 tree_7736 0 2.592e-15
Rtr_773_7737 tree_773 tree_7737 0.8192
Cp_7737 tree_7737 0 2.592e-15
Rtr_773_7738 tree_773 tree_7738 0.8192
Cp_7738 tree_7738 0 2.592e-15
Rtr_773_7739 tree_773 tree_7739 0.8192
Cp_7739 tree_7739 0 2.592e-15
Rtr_773_7740 tree_773 tree_7740 0.8192
Cp_7740 tree_7740 0 2.592e-15
Rtr_774_7741 tree_774 tree_7741 0.8192
Cp_7741 tree_7741 0 2.592e-15
Rtr_774_7742 tree_774 tree_7742 0.8192
Cp_7742 tree_7742 0 2.592e-15
Rtr_774_7743 tree_774 tree_7743 0.8192
Cp_7743 tree_7743 0 2.592e-15
Rtr_774_7744 tree_774 tree_7744 0.8192
Cp_7744 tree_7744 0 2.592e-15
Rtr_774_7745 tree_774 tree_7745 0.8192
Cp_7745 tree_7745 0 2.592e-15
Rtr_774_7746 tree_774 tree_7746 0.8192
Cp_7746 tree_7746 0 2.592e-15
Rtr_774_7747 tree_774 tree_7747 0.8192
Cp_7747 tree_7747 0 2.592e-15
Rtr_774_7748 tree_774 tree_7748 0.8192
Cp_7748 tree_7748 0 2.592e-15
Rtr_774_7749 tree_774 tree_7749 0.8192
Cp_7749 tree_7749 0 2.592e-15
Rtr_774_7750 tree_774 tree_7750 0.8192
Cp_7750 tree_7750 0 2.592e-15
Rtr_775_7751 tree_775 tree_7751 0.8192
Cp_7751 tree_7751 0 2.592e-15
Rtr_775_7752 tree_775 tree_7752 0.8192
Cp_7752 tree_7752 0 2.592e-15
Rtr_775_7753 tree_775 tree_7753 0.8192
Cp_7753 tree_7753 0 2.592e-15
Rtr_775_7754 tree_775 tree_7754 0.8192
Cp_7754 tree_7754 0 2.592e-15
Rtr_775_7755 tree_775 tree_7755 0.8192
Cp_7755 tree_7755 0 2.592e-15
Rtr_775_7756 tree_775 tree_7756 0.8192
Cp_7756 tree_7756 0 2.592e-15
Rtr_775_7757 tree_775 tree_7757 0.8192
Cp_7757 tree_7757 0 2.592e-15
Rtr_775_7758 tree_775 tree_7758 0.8192
Cp_7758 tree_7758 0 2.592e-15
Rtr_775_7759 tree_775 tree_7759 0.8192
Cp_7759 tree_7759 0 2.592e-15
Rtr_775_7760 tree_775 tree_7760 0.8192
Cp_7760 tree_7760 0 2.592e-15
Rtr_776_7761 tree_776 tree_7761 0.8192
Cp_7761 tree_7761 0 2.592e-15
Rtr_776_7762 tree_776 tree_7762 0.8192
Cp_7762 tree_7762 0 2.592e-15
Rtr_776_7763 tree_776 tree_7763 0.8192
Cp_7763 tree_7763 0 2.592e-15
Rtr_776_7764 tree_776 tree_7764 0.8192
Cp_7764 tree_7764 0 2.592e-15
Rtr_776_7765 tree_776 tree_7765 0.8192
Cp_7765 tree_7765 0 2.592e-15
Rtr_776_7766 tree_776 tree_7766 0.8192
Cp_7766 tree_7766 0 2.592e-15
Rtr_776_7767 tree_776 tree_7767 0.8192
Cp_7767 tree_7767 0 2.592e-15
Rtr_776_7768 tree_776 tree_7768 0.8192
Cp_7768 tree_7768 0 2.592e-15
Rtr_776_7769 tree_776 tree_7769 0.8192
Cp_7769 tree_7769 0 2.592e-15
Rtr_776_7770 tree_776 tree_7770 0.8192
Cp_7770 tree_7770 0 2.592e-15
Rtr_777_7771 tree_777 tree_7771 0.8192
Cp_7771 tree_7771 0 2.592e-15
Rtr_777_7772 tree_777 tree_7772 0.8192
Cp_7772 tree_7772 0 2.592e-15
Rtr_777_7773 tree_777 tree_7773 0.8192
Cp_7773 tree_7773 0 2.592e-15
Rtr_777_7774 tree_777 tree_7774 0.8192
Cp_7774 tree_7774 0 2.592e-15
Rtr_777_7775 tree_777 tree_7775 0.8192
Cp_7775 tree_7775 0 2.592e-15
Rtr_777_7776 tree_777 tree_7776 0.8192
Cp_7776 tree_7776 0 2.592e-15
Rtr_777_7777 tree_777 tree_7777 0.8192
Cp_7777 tree_7777 0 2.592e-15
Rtr_777_7778 tree_777 tree_7778 0.8192
Cp_7778 tree_7778 0 2.592e-15
Rtr_777_7779 tree_777 tree_7779 0.8192
Cp_7779 tree_7779 0 2.592e-15
Rtr_777_7780 tree_777 tree_7780 0.8192
Cp_7780 tree_7780 0 2.592e-15
Rtr_778_7781 tree_778 tree_7781 0.8192
Cp_7781 tree_7781 0 2.592e-15
Rtr_778_7782 tree_778 tree_7782 0.8192
Cp_7782 tree_7782 0 2.592e-15
Rtr_778_7783 tree_778 tree_7783 0.8192
Cp_7783 tree_7783 0 2.592e-15
Rtr_778_7784 tree_778 tree_7784 0.8192
Cp_7784 tree_7784 0 2.592e-15
Rtr_778_7785 tree_778 tree_7785 0.8192
Cp_7785 tree_7785 0 2.592e-15
Rtr_778_7786 tree_778 tree_7786 0.8192
Cp_7786 tree_7786 0 2.592e-15
Rtr_778_7787 tree_778 tree_7787 0.8192
Cp_7787 tree_7787 0 2.592e-15
Rtr_778_7788 tree_778 tree_7788 0.8192
Cp_7788 tree_7788 0 2.592e-15
Rtr_778_7789 tree_778 tree_7789 0.8192
Cp_7789 tree_7789 0 2.592e-15
Rtr_778_7790 tree_778 tree_7790 0.8192
Cp_7790 tree_7790 0 2.592e-15
Rtr_779_7791 tree_779 tree_7791 0.8192
Cp_7791 tree_7791 0 2.592e-15
Rtr_779_7792 tree_779 tree_7792 0.8192
Cp_7792 tree_7792 0 2.592e-15
Rtr_779_7793 tree_779 tree_7793 0.8192
Cp_7793 tree_7793 0 2.592e-15
Rtr_779_7794 tree_779 tree_7794 0.8192
Cp_7794 tree_7794 0 2.592e-15
Rtr_779_7795 tree_779 tree_7795 0.8192
Cp_7795 tree_7795 0 2.592e-15
Rtr_779_7796 tree_779 tree_7796 0.8192
Cp_7796 tree_7796 0 2.592e-15
Rtr_779_7797 tree_779 tree_7797 0.8192
Cp_7797 tree_7797 0 2.592e-15
Rtr_779_7798 tree_779 tree_7798 0.8192
Cp_7798 tree_7798 0 2.592e-15
Rtr_779_7799 tree_779 tree_7799 0.8192
Cp_7799 tree_7799 0 2.592e-15
Rtr_779_7800 tree_779 tree_7800 0.8192
Cp_7800 tree_7800 0 2.592e-15
Rtr_780_7801 tree_780 tree_7801 0.8192
Cp_7801 tree_7801 0 2.592e-15
Rtr_780_7802 tree_780 tree_7802 0.8192
Cp_7802 tree_7802 0 2.592e-15
Rtr_780_7803 tree_780 tree_7803 0.8192
Cp_7803 tree_7803 0 2.592e-15
Rtr_780_7804 tree_780 tree_7804 0.8192
Cp_7804 tree_7804 0 2.592e-15
Rtr_780_7805 tree_780 tree_7805 0.8192
Cp_7805 tree_7805 0 2.592e-15
Rtr_780_7806 tree_780 tree_7806 0.8192
Cp_7806 tree_7806 0 2.592e-15
Rtr_780_7807 tree_780 tree_7807 0.8192
Cp_7807 tree_7807 0 2.592e-15
Rtr_780_7808 tree_780 tree_7808 0.8192
Cp_7808 tree_7808 0 2.592e-15
Rtr_780_7809 tree_780 tree_7809 0.8192
Cp_7809 tree_7809 0 2.592e-15
Rtr_780_7810 tree_780 tree_7810 0.8192
Cp_7810 tree_7810 0 2.592e-15
Rtr_781_7811 tree_781 tree_7811 0.8192
Cp_7811 tree_7811 0 2.592e-15
Rtr_781_7812 tree_781 tree_7812 0.8192
Cp_7812 tree_7812 0 2.592e-15
Rtr_781_7813 tree_781 tree_7813 0.8192
Cp_7813 tree_7813 0 2.592e-15
Rtr_781_7814 tree_781 tree_7814 0.8192
Cp_7814 tree_7814 0 2.592e-15
Rtr_781_7815 tree_781 tree_7815 0.8192
Cp_7815 tree_7815 0 2.592e-15
Rtr_781_7816 tree_781 tree_7816 0.8192
Cp_7816 tree_7816 0 2.592e-15
Rtr_781_7817 tree_781 tree_7817 0.8192
Cp_7817 tree_7817 0 2.592e-15
Rtr_781_7818 tree_781 tree_7818 0.8192
Cp_7818 tree_7818 0 2.592e-15
Rtr_781_7819 tree_781 tree_7819 0.8192
Cp_7819 tree_7819 0 2.592e-15
Rtr_781_7820 tree_781 tree_7820 0.8192
Cp_7820 tree_7820 0 2.592e-15
Rtr_782_7821 tree_782 tree_7821 0.8192
Cp_7821 tree_7821 0 2.592e-15
Rtr_782_7822 tree_782 tree_7822 0.8192
Cp_7822 tree_7822 0 2.592e-15
Rtr_782_7823 tree_782 tree_7823 0.8192
Cp_7823 tree_7823 0 2.592e-15
Rtr_782_7824 tree_782 tree_7824 0.8192
Cp_7824 tree_7824 0 2.592e-15
Rtr_782_7825 tree_782 tree_7825 0.8192
Cp_7825 tree_7825 0 2.592e-15
Rtr_782_7826 tree_782 tree_7826 0.8192
Cp_7826 tree_7826 0 2.592e-15
Rtr_782_7827 tree_782 tree_7827 0.8192
Cp_7827 tree_7827 0 2.592e-15
Rtr_782_7828 tree_782 tree_7828 0.8192
Cp_7828 tree_7828 0 2.592e-15
Rtr_782_7829 tree_782 tree_7829 0.8192
Cp_7829 tree_7829 0 2.592e-15
Rtr_782_7830 tree_782 tree_7830 0.8192
Cp_7830 tree_7830 0 2.592e-15
Rtr_783_7831 tree_783 tree_7831 0.8192
Cp_7831 tree_7831 0 2.592e-15
Rtr_783_7832 tree_783 tree_7832 0.8192
Cp_7832 tree_7832 0 2.592e-15
Rtr_783_7833 tree_783 tree_7833 0.8192
Cp_7833 tree_7833 0 2.592e-15
Rtr_783_7834 tree_783 tree_7834 0.8192
Cp_7834 tree_7834 0 2.592e-15
Rtr_783_7835 tree_783 tree_7835 0.8192
Cp_7835 tree_7835 0 2.592e-15
Rtr_783_7836 tree_783 tree_7836 0.8192
Cp_7836 tree_7836 0 2.592e-15
Rtr_783_7837 tree_783 tree_7837 0.8192
Cp_7837 tree_7837 0 2.592e-15
Rtr_783_7838 tree_783 tree_7838 0.8192
Cp_7838 tree_7838 0 2.592e-15
Rtr_783_7839 tree_783 tree_7839 0.8192
Cp_7839 tree_7839 0 2.592e-15
Rtr_783_7840 tree_783 tree_7840 0.8192
Cp_7840 tree_7840 0 2.592e-15
Rtr_784_7841 tree_784 tree_7841 0.8192
Cp_7841 tree_7841 0 2.592e-15
Rtr_784_7842 tree_784 tree_7842 0.8192
Cp_7842 tree_7842 0 2.592e-15
Rtr_784_7843 tree_784 tree_7843 0.8192
Cp_7843 tree_7843 0 2.592e-15
Rtr_784_7844 tree_784 tree_7844 0.8192
Cp_7844 tree_7844 0 2.592e-15
Rtr_784_7845 tree_784 tree_7845 0.8192
Cp_7845 tree_7845 0 2.592e-15
Rtr_784_7846 tree_784 tree_7846 0.8192
Cp_7846 tree_7846 0 2.592e-15
Rtr_784_7847 tree_784 tree_7847 0.8192
Cp_7847 tree_7847 0 2.592e-15
Rtr_784_7848 tree_784 tree_7848 0.8192
Cp_7848 tree_7848 0 2.592e-15
Rtr_784_7849 tree_784 tree_7849 0.8192
Cp_7849 tree_7849 0 2.592e-15
Rtr_784_7850 tree_784 tree_7850 0.8192
Cp_7850 tree_7850 0 2.592e-15
Rtr_785_7851 tree_785 tree_7851 0.8192
Cp_7851 tree_7851 0 2.592e-15
Rtr_785_7852 tree_785 tree_7852 0.8192
Cp_7852 tree_7852 0 2.592e-15
Rtr_785_7853 tree_785 tree_7853 0.8192
Cp_7853 tree_7853 0 2.592e-15
Rtr_785_7854 tree_785 tree_7854 0.8192
Cp_7854 tree_7854 0 2.592e-15
Rtr_785_7855 tree_785 tree_7855 0.8192
Cp_7855 tree_7855 0 2.592e-15
Rtr_785_7856 tree_785 tree_7856 0.8192
Cp_7856 tree_7856 0 2.592e-15
Rtr_785_7857 tree_785 tree_7857 0.8192
Cp_7857 tree_7857 0 2.592e-15
Rtr_785_7858 tree_785 tree_7858 0.8192
Cp_7858 tree_7858 0 2.592e-15
Rtr_785_7859 tree_785 tree_7859 0.8192
Cp_7859 tree_7859 0 2.592e-15
Rtr_785_7860 tree_785 tree_7860 0.8192
Cp_7860 tree_7860 0 2.592e-15
Rtr_786_7861 tree_786 tree_7861 0.8192
Cp_7861 tree_7861 0 2.592e-15
Rtr_786_7862 tree_786 tree_7862 0.8192
Cp_7862 tree_7862 0 2.592e-15
Rtr_786_7863 tree_786 tree_7863 0.8192
Cp_7863 tree_7863 0 2.592e-15
Rtr_786_7864 tree_786 tree_7864 0.8192
Cp_7864 tree_7864 0 2.592e-15
Rtr_786_7865 tree_786 tree_7865 0.8192
Cp_7865 tree_7865 0 2.592e-15
Rtr_786_7866 tree_786 tree_7866 0.8192
Cp_7866 tree_7866 0 2.592e-15
Rtr_786_7867 tree_786 tree_7867 0.8192
Cp_7867 tree_7867 0 2.592e-15
Rtr_786_7868 tree_786 tree_7868 0.8192
Cp_7868 tree_7868 0 2.592e-15
Rtr_786_7869 tree_786 tree_7869 0.8192
Cp_7869 tree_7869 0 2.592e-15
Rtr_786_7870 tree_786 tree_7870 0.8192
Cp_7870 tree_7870 0 2.592e-15
Rtr_787_7871 tree_787 tree_7871 0.8192
Cp_7871 tree_7871 0 2.592e-15
Rtr_787_7872 tree_787 tree_7872 0.8192
Cp_7872 tree_7872 0 2.592e-15
Rtr_787_7873 tree_787 tree_7873 0.8192
Cp_7873 tree_7873 0 2.592e-15
Rtr_787_7874 tree_787 tree_7874 0.8192
Cp_7874 tree_7874 0 2.592e-15
Rtr_787_7875 tree_787 tree_7875 0.8192
Cp_7875 tree_7875 0 2.592e-15
Rtr_787_7876 tree_787 tree_7876 0.8192
Cp_7876 tree_7876 0 2.592e-15
Rtr_787_7877 tree_787 tree_7877 0.8192
Cp_7877 tree_7877 0 2.592e-15
Rtr_787_7878 tree_787 tree_7878 0.8192
Cp_7878 tree_7878 0 2.592e-15
Rtr_787_7879 tree_787 tree_7879 0.8192
Cp_7879 tree_7879 0 2.592e-15
Rtr_787_7880 tree_787 tree_7880 0.8192
Cp_7880 tree_7880 0 2.592e-15
Rtr_788_7881 tree_788 tree_7881 0.8192
Cp_7881 tree_7881 0 2.592e-15
Rtr_788_7882 tree_788 tree_7882 0.8192
Cp_7882 tree_7882 0 2.592e-15
Rtr_788_7883 tree_788 tree_7883 0.8192
Cp_7883 tree_7883 0 2.592e-15
Rtr_788_7884 tree_788 tree_7884 0.8192
Cp_7884 tree_7884 0 2.592e-15
Rtr_788_7885 tree_788 tree_7885 0.8192
Cp_7885 tree_7885 0 2.592e-15
Rtr_788_7886 tree_788 tree_7886 0.8192
Cp_7886 tree_7886 0 2.592e-15
Rtr_788_7887 tree_788 tree_7887 0.8192
Cp_7887 tree_7887 0 2.592e-15
Rtr_788_7888 tree_788 tree_7888 0.8192
Cp_7888 tree_7888 0 2.592e-15
Rtr_788_7889 tree_788 tree_7889 0.8192
Cp_7889 tree_7889 0 2.592e-15
Rtr_788_7890 tree_788 tree_7890 0.8192
Cp_7890 tree_7890 0 2.592e-15
Rtr_789_7891 tree_789 tree_7891 0.8192
Cp_7891 tree_7891 0 2.592e-15
Rtr_789_7892 tree_789 tree_7892 0.8192
Cp_7892 tree_7892 0 2.592e-15
Rtr_789_7893 tree_789 tree_7893 0.8192
Cp_7893 tree_7893 0 2.592e-15
Rtr_789_7894 tree_789 tree_7894 0.8192
Cp_7894 tree_7894 0 2.592e-15
Rtr_789_7895 tree_789 tree_7895 0.8192
Cp_7895 tree_7895 0 2.592e-15
Rtr_789_7896 tree_789 tree_7896 0.8192
Cp_7896 tree_7896 0 2.592e-15
Rtr_789_7897 tree_789 tree_7897 0.8192
Cp_7897 tree_7897 0 2.592e-15
Rtr_789_7898 tree_789 tree_7898 0.8192
Cp_7898 tree_7898 0 2.592e-15
Rtr_789_7899 tree_789 tree_7899 0.8192
Cp_7899 tree_7899 0 2.592e-15
Rtr_789_7900 tree_789 tree_7900 0.8192
Cp_7900 tree_7900 0 2.592e-15
Rtr_790_7901 tree_790 tree_7901 0.8192
Cp_7901 tree_7901 0 2.592e-15
Rtr_790_7902 tree_790 tree_7902 0.8192
Cp_7902 tree_7902 0 2.592e-15
Rtr_790_7903 tree_790 tree_7903 0.8192
Cp_7903 tree_7903 0 2.592e-15
Rtr_790_7904 tree_790 tree_7904 0.8192
Cp_7904 tree_7904 0 2.592e-15
Rtr_790_7905 tree_790 tree_7905 0.8192
Cp_7905 tree_7905 0 2.592e-15
Rtr_790_7906 tree_790 tree_7906 0.8192
Cp_7906 tree_7906 0 2.592e-15
Rtr_790_7907 tree_790 tree_7907 0.8192
Cp_7907 tree_7907 0 2.592e-15
Rtr_790_7908 tree_790 tree_7908 0.8192
Cp_7908 tree_7908 0 2.592e-15
Rtr_790_7909 tree_790 tree_7909 0.8192
Cp_7909 tree_7909 0 2.592e-15
Rtr_790_7910 tree_790 tree_7910 0.8192
Cp_7910 tree_7910 0 2.592e-15
Rtr_791_7911 tree_791 tree_7911 0.8192
Cp_7911 tree_7911 0 2.592e-15
Rtr_791_7912 tree_791 tree_7912 0.8192
Cp_7912 tree_7912 0 2.592e-15
Rtr_791_7913 tree_791 tree_7913 0.8192
Cp_7913 tree_7913 0 2.592e-15
Rtr_791_7914 tree_791 tree_7914 0.8192
Cp_7914 tree_7914 0 2.592e-15
Rtr_791_7915 tree_791 tree_7915 0.8192
Cp_7915 tree_7915 0 2.592e-15
Rtr_791_7916 tree_791 tree_7916 0.8192
Cp_7916 tree_7916 0 2.592e-15
Rtr_791_7917 tree_791 tree_7917 0.8192
Cp_7917 tree_7917 0 2.592e-15
Rtr_791_7918 tree_791 tree_7918 0.8192
Cp_7918 tree_7918 0 2.592e-15
Rtr_791_7919 tree_791 tree_7919 0.8192
Cp_7919 tree_7919 0 2.592e-15
Rtr_791_7920 tree_791 tree_7920 0.8192
Cp_7920 tree_7920 0 2.592e-15
Rtr_792_7921 tree_792 tree_7921 0.8192
Cp_7921 tree_7921 0 2.592e-15
Rtr_792_7922 tree_792 tree_7922 0.8192
Cp_7922 tree_7922 0 2.592e-15
Rtr_792_7923 tree_792 tree_7923 0.8192
Cp_7923 tree_7923 0 2.592e-15
Rtr_792_7924 tree_792 tree_7924 0.8192
Cp_7924 tree_7924 0 2.592e-15
Rtr_792_7925 tree_792 tree_7925 0.8192
Cp_7925 tree_7925 0 2.592e-15
Rtr_792_7926 tree_792 tree_7926 0.8192
Cp_7926 tree_7926 0 2.592e-15
Rtr_792_7927 tree_792 tree_7927 0.8192
Cp_7927 tree_7927 0 2.592e-15
Rtr_792_7928 tree_792 tree_7928 0.8192
Cp_7928 tree_7928 0 2.592e-15
Rtr_792_7929 tree_792 tree_7929 0.8192
Cp_7929 tree_7929 0 2.592e-15
Rtr_792_7930 tree_792 tree_7930 0.8192
Cp_7930 tree_7930 0 2.592e-15
Rtr_793_7931 tree_793 tree_7931 0.8192
Cp_7931 tree_7931 0 2.592e-15
Rtr_793_7932 tree_793 tree_7932 0.8192
Cp_7932 tree_7932 0 2.592e-15
Rtr_793_7933 tree_793 tree_7933 0.8192
Cp_7933 tree_7933 0 2.592e-15
Rtr_793_7934 tree_793 tree_7934 0.8192
Cp_7934 tree_7934 0 2.592e-15
Rtr_793_7935 tree_793 tree_7935 0.8192
Cp_7935 tree_7935 0 2.592e-15
Rtr_793_7936 tree_793 tree_7936 0.8192
Cp_7936 tree_7936 0 2.592e-15
Rtr_793_7937 tree_793 tree_7937 0.8192
Cp_7937 tree_7937 0 2.592e-15
Rtr_793_7938 tree_793 tree_7938 0.8192
Cp_7938 tree_7938 0 2.592e-15
Rtr_793_7939 tree_793 tree_7939 0.8192
Cp_7939 tree_7939 0 2.592e-15
Rtr_793_7940 tree_793 tree_7940 0.8192
Cp_7940 tree_7940 0 2.592e-15
Rtr_794_7941 tree_794 tree_7941 0.8192
Cp_7941 tree_7941 0 2.592e-15
Rtr_794_7942 tree_794 tree_7942 0.8192
Cp_7942 tree_7942 0 2.592e-15
Rtr_794_7943 tree_794 tree_7943 0.8192
Cp_7943 tree_7943 0 2.592e-15
Rtr_794_7944 tree_794 tree_7944 0.8192
Cp_7944 tree_7944 0 2.592e-15
Rtr_794_7945 tree_794 tree_7945 0.8192
Cp_7945 tree_7945 0 2.592e-15
Rtr_794_7946 tree_794 tree_7946 0.8192
Cp_7946 tree_7946 0 2.592e-15
Rtr_794_7947 tree_794 tree_7947 0.8192
Cp_7947 tree_7947 0 2.592e-15
Rtr_794_7948 tree_794 tree_7948 0.8192
Cp_7948 tree_7948 0 2.592e-15
Rtr_794_7949 tree_794 tree_7949 0.8192
Cp_7949 tree_7949 0 2.592e-15
Rtr_794_7950 tree_794 tree_7950 0.8192
Cp_7950 tree_7950 0 2.592e-15
Rtr_795_7951 tree_795 tree_7951 0.8192
Cp_7951 tree_7951 0 2.592e-15
Rtr_795_7952 tree_795 tree_7952 0.8192
Cp_7952 tree_7952 0 2.592e-15
Rtr_795_7953 tree_795 tree_7953 0.8192
Cp_7953 tree_7953 0 2.592e-15
Rtr_795_7954 tree_795 tree_7954 0.8192
Cp_7954 tree_7954 0 2.592e-15
Rtr_795_7955 tree_795 tree_7955 0.8192
Cp_7955 tree_7955 0 2.592e-15
Rtr_795_7956 tree_795 tree_7956 0.8192
Cp_7956 tree_7956 0 2.592e-15
Rtr_795_7957 tree_795 tree_7957 0.8192
Cp_7957 tree_7957 0 2.592e-15
Rtr_795_7958 tree_795 tree_7958 0.8192
Cp_7958 tree_7958 0 2.592e-15
Rtr_795_7959 tree_795 tree_7959 0.8192
Cp_7959 tree_7959 0 2.592e-15
Rtr_795_7960 tree_795 tree_7960 0.8192
Cp_7960 tree_7960 0 2.592e-15
Rtr_796_7961 tree_796 tree_7961 0.8192
Cp_7961 tree_7961 0 2.592e-15
Rtr_796_7962 tree_796 tree_7962 0.8192
Cp_7962 tree_7962 0 2.592e-15
Rtr_796_7963 tree_796 tree_7963 0.8192
Cp_7963 tree_7963 0 2.592e-15
Rtr_796_7964 tree_796 tree_7964 0.8192
Cp_7964 tree_7964 0 2.592e-15
Rtr_796_7965 tree_796 tree_7965 0.8192
Cp_7965 tree_7965 0 2.592e-15
Rtr_796_7966 tree_796 tree_7966 0.8192
Cp_7966 tree_7966 0 2.592e-15
Rtr_796_7967 tree_796 tree_7967 0.8192
Cp_7967 tree_7967 0 2.592e-15
Rtr_796_7968 tree_796 tree_7968 0.8192
Cp_7968 tree_7968 0 2.592e-15
Rtr_796_7969 tree_796 tree_7969 0.8192
Cp_7969 tree_7969 0 2.592e-15
Rtr_796_7970 tree_796 tree_7970 0.8192
Cp_7970 tree_7970 0 2.592e-15
Rtr_797_7971 tree_797 tree_7971 0.8192
Cp_7971 tree_7971 0 2.592e-15
Rtr_797_7972 tree_797 tree_7972 0.8192
Cp_7972 tree_7972 0 2.592e-15
Rtr_797_7973 tree_797 tree_7973 0.8192
Cp_7973 tree_7973 0 2.592e-15
Rtr_797_7974 tree_797 tree_7974 0.8192
Cp_7974 tree_7974 0 2.592e-15
Rtr_797_7975 tree_797 tree_7975 0.8192
Cp_7975 tree_7975 0 2.592e-15
Rtr_797_7976 tree_797 tree_7976 0.8192
Cp_7976 tree_7976 0 2.592e-15
Rtr_797_7977 tree_797 tree_7977 0.8192
Cp_7977 tree_7977 0 2.592e-15
Rtr_797_7978 tree_797 tree_7978 0.8192
Cp_7978 tree_7978 0 2.592e-15
Rtr_797_7979 tree_797 tree_7979 0.8192
Cp_7979 tree_7979 0 2.592e-15
Rtr_797_7980 tree_797 tree_7980 0.8192
Cp_7980 tree_7980 0 2.592e-15
Rtr_798_7981 tree_798 tree_7981 0.8192
Cp_7981 tree_7981 0 2.592e-15
Rtr_798_7982 tree_798 tree_7982 0.8192
Cp_7982 tree_7982 0 2.592e-15
Rtr_798_7983 tree_798 tree_7983 0.8192
Cp_7983 tree_7983 0 2.592e-15
Rtr_798_7984 tree_798 tree_7984 0.8192
Cp_7984 tree_7984 0 2.592e-15
Rtr_798_7985 tree_798 tree_7985 0.8192
Cp_7985 tree_7985 0 2.592e-15
Rtr_798_7986 tree_798 tree_7986 0.8192
Cp_7986 tree_7986 0 2.592e-15
Rtr_798_7987 tree_798 tree_7987 0.8192
Cp_7987 tree_7987 0 2.592e-15
Rtr_798_7988 tree_798 tree_7988 0.8192
Cp_7988 tree_7988 0 2.592e-15
Rtr_798_7989 tree_798 tree_7989 0.8192
Cp_7989 tree_7989 0 2.592e-15
Rtr_798_7990 tree_798 tree_7990 0.8192
Cp_7990 tree_7990 0 2.592e-15
Rtr_799_7991 tree_799 tree_7991 0.8192
Cp_7991 tree_7991 0 2.592e-15
Rtr_799_7992 tree_799 tree_7992 0.8192
Cp_7992 tree_7992 0 2.592e-15
Rtr_799_7993 tree_799 tree_7993 0.8192
Cp_7993 tree_7993 0 2.592e-15
Rtr_799_7994 tree_799 tree_7994 0.8192
Cp_7994 tree_7994 0 2.592e-15
Rtr_799_7995 tree_799 tree_7995 0.8192
Cp_7995 tree_7995 0 2.592e-15
Rtr_799_7996 tree_799 tree_7996 0.8192
Cp_7996 tree_7996 0 2.592e-15
Rtr_799_7997 tree_799 tree_7997 0.8192
Cp_7997 tree_7997 0 2.592e-15
Rtr_799_7998 tree_799 tree_7998 0.8192
Cp_7998 tree_7998 0 2.592e-15
Rtr_799_7999 tree_799 tree_7999 0.8192
Cp_7999 tree_7999 0 2.592e-15
Rtr_799_8000 tree_799 tree_8000 0.8192
Cp_8000 tree_8000 0 2.592e-15
Rtr_800_8001 tree_800 tree_8001 0.8192
Cp_8001 tree_8001 0 2.592e-15
Rtr_800_8002 tree_800 tree_8002 0.8192
Cp_8002 tree_8002 0 2.592e-15
Rtr_800_8003 tree_800 tree_8003 0.8192
Cp_8003 tree_8003 0 2.592e-15
Rtr_800_8004 tree_800 tree_8004 0.8192
Cp_8004 tree_8004 0 2.592e-15
Rtr_800_8005 tree_800 tree_8005 0.8192
Cp_8005 tree_8005 0 2.592e-15
Rtr_800_8006 tree_800 tree_8006 0.8192
Cp_8006 tree_8006 0 2.592e-15
Rtr_800_8007 tree_800 tree_8007 0.8192
Cp_8007 tree_8007 0 2.592e-15
Rtr_800_8008 tree_800 tree_8008 0.8192
Cp_8008 tree_8008 0 2.592e-15
Rtr_800_8009 tree_800 tree_8009 0.8192
Cp_8009 tree_8009 0 2.592e-15
Rtr_800_8010 tree_800 tree_8010 0.8192
Cp_8010 tree_8010 0 2.592e-15
Rtr_801_8011 tree_801 tree_8011 0.8192
Cp_8011 tree_8011 0 2.592e-15
Rtr_801_8012 tree_801 tree_8012 0.8192
Cp_8012 tree_8012 0 2.592e-15
Rtr_801_8013 tree_801 tree_8013 0.8192
Cp_8013 tree_8013 0 2.592e-15
Rtr_801_8014 tree_801 tree_8014 0.8192
Cp_8014 tree_8014 0 2.592e-15
Rtr_801_8015 tree_801 tree_8015 0.8192
Cp_8015 tree_8015 0 2.592e-15
Rtr_801_8016 tree_801 tree_8016 0.8192
Cp_8016 tree_8016 0 2.592e-15
Rtr_801_8017 tree_801 tree_8017 0.8192
Cp_8017 tree_8017 0 2.592e-15
Rtr_801_8018 tree_801 tree_8018 0.8192
Cp_8018 tree_8018 0 2.592e-15
Rtr_801_8019 tree_801 tree_8019 0.8192
Cp_8019 tree_8019 0 2.592e-15
Rtr_801_8020 tree_801 tree_8020 0.8192
Cp_8020 tree_8020 0 2.592e-15
Rtr_802_8021 tree_802 tree_8021 0.8192
Cp_8021 tree_8021 0 2.592e-15
Rtr_802_8022 tree_802 tree_8022 0.8192
Cp_8022 tree_8022 0 2.592e-15
Rtr_802_8023 tree_802 tree_8023 0.8192
Cp_8023 tree_8023 0 2.592e-15
Rtr_802_8024 tree_802 tree_8024 0.8192
Cp_8024 tree_8024 0 2.592e-15
Rtr_802_8025 tree_802 tree_8025 0.8192
Cp_8025 tree_8025 0 2.592e-15
Rtr_802_8026 tree_802 tree_8026 0.8192
Cp_8026 tree_8026 0 2.592e-15
Rtr_802_8027 tree_802 tree_8027 0.8192
Cp_8027 tree_8027 0 2.592e-15
Rtr_802_8028 tree_802 tree_8028 0.8192
Cp_8028 tree_8028 0 2.592e-15
Rtr_802_8029 tree_802 tree_8029 0.8192
Cp_8029 tree_8029 0 2.592e-15
Rtr_802_8030 tree_802 tree_8030 0.8192
Cp_8030 tree_8030 0 2.592e-15
Rtr_803_8031 tree_803 tree_8031 0.8192
Cp_8031 tree_8031 0 2.592e-15
Rtr_803_8032 tree_803 tree_8032 0.8192
Cp_8032 tree_8032 0 2.592e-15
Rtr_803_8033 tree_803 tree_8033 0.8192
Cp_8033 tree_8033 0 2.592e-15
Rtr_803_8034 tree_803 tree_8034 0.8192
Cp_8034 tree_8034 0 2.592e-15
Rtr_803_8035 tree_803 tree_8035 0.8192
Cp_8035 tree_8035 0 2.592e-15
Rtr_803_8036 tree_803 tree_8036 0.8192
Cp_8036 tree_8036 0 2.592e-15
Rtr_803_8037 tree_803 tree_8037 0.8192
Cp_8037 tree_8037 0 2.592e-15
Rtr_803_8038 tree_803 tree_8038 0.8192
Cp_8038 tree_8038 0 2.592e-15
Rtr_803_8039 tree_803 tree_8039 0.8192
Cp_8039 tree_8039 0 2.592e-15
Rtr_803_8040 tree_803 tree_8040 0.8192
Cp_8040 tree_8040 0 2.592e-15
Rtr_804_8041 tree_804 tree_8041 0.8192
Cp_8041 tree_8041 0 2.592e-15
Rtr_804_8042 tree_804 tree_8042 0.8192
Cp_8042 tree_8042 0 2.592e-15
Rtr_804_8043 tree_804 tree_8043 0.8192
Cp_8043 tree_8043 0 2.592e-15
Rtr_804_8044 tree_804 tree_8044 0.8192
Cp_8044 tree_8044 0 2.592e-15
Rtr_804_8045 tree_804 tree_8045 0.8192
Cp_8045 tree_8045 0 2.592e-15
Rtr_804_8046 tree_804 tree_8046 0.8192
Cp_8046 tree_8046 0 2.592e-15
Rtr_804_8047 tree_804 tree_8047 0.8192
Cp_8047 tree_8047 0 2.592e-15
Rtr_804_8048 tree_804 tree_8048 0.8192
Cp_8048 tree_8048 0 2.592e-15
Rtr_804_8049 tree_804 tree_8049 0.8192
Cp_8049 tree_8049 0 2.592e-15
Rtr_804_8050 tree_804 tree_8050 0.8192
Cp_8050 tree_8050 0 2.592e-15
Rtr_805_8051 tree_805 tree_8051 0.8192
Cp_8051 tree_8051 0 2.592e-15
Rtr_805_8052 tree_805 tree_8052 0.8192
Cp_8052 tree_8052 0 2.592e-15
Rtr_805_8053 tree_805 tree_8053 0.8192
Cp_8053 tree_8053 0 2.592e-15
Rtr_805_8054 tree_805 tree_8054 0.8192
Cp_8054 tree_8054 0 2.592e-15
Rtr_805_8055 tree_805 tree_8055 0.8192
Cp_8055 tree_8055 0 2.592e-15
Rtr_805_8056 tree_805 tree_8056 0.8192
Cp_8056 tree_8056 0 2.592e-15
Rtr_805_8057 tree_805 tree_8057 0.8192
Cp_8057 tree_8057 0 2.592e-15
Rtr_805_8058 tree_805 tree_8058 0.8192
Cp_8058 tree_8058 0 2.592e-15
Rtr_805_8059 tree_805 tree_8059 0.8192
Cp_8059 tree_8059 0 2.592e-15
Rtr_805_8060 tree_805 tree_8060 0.8192
Cp_8060 tree_8060 0 2.592e-15
Rtr_806_8061 tree_806 tree_8061 0.8192
Cp_8061 tree_8061 0 2.592e-15
Rtr_806_8062 tree_806 tree_8062 0.8192
Cp_8062 tree_8062 0 2.592e-15
Rtr_806_8063 tree_806 tree_8063 0.8192
Cp_8063 tree_8063 0 2.592e-15
Rtr_806_8064 tree_806 tree_8064 0.8192
Cp_8064 tree_8064 0 2.592e-15
Rtr_806_8065 tree_806 tree_8065 0.8192
Cp_8065 tree_8065 0 2.592e-15
Rtr_806_8066 tree_806 tree_8066 0.8192
Cp_8066 tree_8066 0 2.592e-15
Rtr_806_8067 tree_806 tree_8067 0.8192
Cp_8067 tree_8067 0 2.592e-15
Rtr_806_8068 tree_806 tree_8068 0.8192
Cp_8068 tree_8068 0 2.592e-15
Rtr_806_8069 tree_806 tree_8069 0.8192
Cp_8069 tree_8069 0 2.592e-15
Rtr_806_8070 tree_806 tree_8070 0.8192
Cp_8070 tree_8070 0 2.592e-15
Rtr_807_8071 tree_807 tree_8071 0.8192
Cp_8071 tree_8071 0 2.592e-15
Rtr_807_8072 tree_807 tree_8072 0.8192
Cp_8072 tree_8072 0 2.592e-15
Rtr_807_8073 tree_807 tree_8073 0.8192
Cp_8073 tree_8073 0 2.592e-15
Rtr_807_8074 tree_807 tree_8074 0.8192
Cp_8074 tree_8074 0 2.592e-15
Rtr_807_8075 tree_807 tree_8075 0.8192
Cp_8075 tree_8075 0 2.592e-15
Rtr_807_8076 tree_807 tree_8076 0.8192
Cp_8076 tree_8076 0 2.592e-15
Rtr_807_8077 tree_807 tree_8077 0.8192
Cp_8077 tree_8077 0 2.592e-15
Rtr_807_8078 tree_807 tree_8078 0.8192
Cp_8078 tree_8078 0 2.592e-15
Rtr_807_8079 tree_807 tree_8079 0.8192
Cp_8079 tree_8079 0 2.592e-15
Rtr_807_8080 tree_807 tree_8080 0.8192
Cp_8080 tree_8080 0 2.592e-15
Rtr_808_8081 tree_808 tree_8081 0.8192
Cp_8081 tree_8081 0 2.592e-15
Rtr_808_8082 tree_808 tree_8082 0.8192
Cp_8082 tree_8082 0 2.592e-15
Rtr_808_8083 tree_808 tree_8083 0.8192
Cp_8083 tree_8083 0 2.592e-15
Rtr_808_8084 tree_808 tree_8084 0.8192
Cp_8084 tree_8084 0 2.592e-15
Rtr_808_8085 tree_808 tree_8085 0.8192
Cp_8085 tree_8085 0 2.592e-15
Rtr_808_8086 tree_808 tree_8086 0.8192
Cp_8086 tree_8086 0 2.592e-15
Rtr_808_8087 tree_808 tree_8087 0.8192
Cp_8087 tree_8087 0 2.592e-15
Rtr_808_8088 tree_808 tree_8088 0.8192
Cp_8088 tree_8088 0 2.592e-15
Rtr_808_8089 tree_808 tree_8089 0.8192
Cp_8089 tree_8089 0 2.592e-15
Rtr_808_8090 tree_808 tree_8090 0.8192
Cp_8090 tree_8090 0 2.592e-15
Rtr_809_8091 tree_809 tree_8091 0.8192
Cp_8091 tree_8091 0 2.592e-15
Rtr_809_8092 tree_809 tree_8092 0.8192
Cp_8092 tree_8092 0 2.592e-15
Rtr_809_8093 tree_809 tree_8093 0.8192
Cp_8093 tree_8093 0 2.592e-15
Rtr_809_8094 tree_809 tree_8094 0.8192
Cp_8094 tree_8094 0 2.592e-15
Rtr_809_8095 tree_809 tree_8095 0.8192
Cp_8095 tree_8095 0 2.592e-15
Rtr_809_8096 tree_809 tree_8096 0.8192
Cp_8096 tree_8096 0 2.592e-15
Rtr_809_8097 tree_809 tree_8097 0.8192
Cp_8097 tree_8097 0 2.592e-15
Rtr_809_8098 tree_809 tree_8098 0.8192
Cp_8098 tree_8098 0 2.592e-15
Rtr_809_8099 tree_809 tree_8099 0.8192
Cp_8099 tree_8099 0 2.592e-15
Rtr_809_8100 tree_809 tree_8100 0.8192
Cp_8100 tree_8100 0 2.592e-15
Rtr_810_8101 tree_810 tree_8101 0.8192
Cp_8101 tree_8101 0 2.592e-15
Rtr_810_8102 tree_810 tree_8102 0.8192
Cp_8102 tree_8102 0 2.592e-15
Rtr_810_8103 tree_810 tree_8103 0.8192
Cp_8103 tree_8103 0 2.592e-15
Rtr_810_8104 tree_810 tree_8104 0.8192
Cp_8104 tree_8104 0 2.592e-15
Rtr_810_8105 tree_810 tree_8105 0.8192
Cp_8105 tree_8105 0 2.592e-15
Rtr_810_8106 tree_810 tree_8106 0.8192
Cp_8106 tree_8106 0 2.592e-15
Rtr_810_8107 tree_810 tree_8107 0.8192
Cp_8107 tree_8107 0 2.592e-15
Rtr_810_8108 tree_810 tree_8108 0.8192
Cp_8108 tree_8108 0 2.592e-15
Rtr_810_8109 tree_810 tree_8109 0.8192
Cp_8109 tree_8109 0 2.592e-15
Rtr_810_8110 tree_810 tree_8110 0.8192
Cp_8110 tree_8110 0 2.592e-15
Rtr_811_8111 tree_811 tree_8111 0.8192
Cp_8111 tree_8111 0 2.592e-15
Rtr_811_8112 tree_811 tree_8112 0.8192
Cp_8112 tree_8112 0 2.592e-15
Rtr_811_8113 tree_811 tree_8113 0.8192
Cp_8113 tree_8113 0 2.592e-15
Rtr_811_8114 tree_811 tree_8114 0.8192
Cp_8114 tree_8114 0 2.592e-15
Rtr_811_8115 tree_811 tree_8115 0.8192
Cp_8115 tree_8115 0 2.592e-15
Rtr_811_8116 tree_811 tree_8116 0.8192
Cp_8116 tree_8116 0 2.592e-15
Rtr_811_8117 tree_811 tree_8117 0.8192
Cp_8117 tree_8117 0 2.592e-15
Rtr_811_8118 tree_811 tree_8118 0.8192
Cp_8118 tree_8118 0 2.592e-15
Rtr_811_8119 tree_811 tree_8119 0.8192
Cp_8119 tree_8119 0 2.592e-15
Rtr_811_8120 tree_811 tree_8120 0.8192
Cp_8120 tree_8120 0 2.592e-15
Rtr_812_8121 tree_812 tree_8121 0.8192
Cp_8121 tree_8121 0 2.592e-15
Rtr_812_8122 tree_812 tree_8122 0.8192
Cp_8122 tree_8122 0 2.592e-15
Rtr_812_8123 tree_812 tree_8123 0.8192
Cp_8123 tree_8123 0 2.592e-15
Rtr_812_8124 tree_812 tree_8124 0.8192
Cp_8124 tree_8124 0 2.592e-15
Rtr_812_8125 tree_812 tree_8125 0.8192
Cp_8125 tree_8125 0 2.592e-15
Rtr_812_8126 tree_812 tree_8126 0.8192
Cp_8126 tree_8126 0 2.592e-15
Rtr_812_8127 tree_812 tree_8127 0.8192
Cp_8127 tree_8127 0 2.592e-15
Rtr_812_8128 tree_812 tree_8128 0.8192
Cp_8128 tree_8128 0 2.592e-15
Rtr_812_8129 tree_812 tree_8129 0.8192
Cp_8129 tree_8129 0 2.592e-15
Rtr_812_8130 tree_812 tree_8130 0.8192
Cp_8130 tree_8130 0 2.592e-15
Rtr_813_8131 tree_813 tree_8131 0.8192
Cp_8131 tree_8131 0 2.592e-15
Rtr_813_8132 tree_813 tree_8132 0.8192
Cp_8132 tree_8132 0 2.592e-15
Rtr_813_8133 tree_813 tree_8133 0.8192
Cp_8133 tree_8133 0 2.592e-15
Rtr_813_8134 tree_813 tree_8134 0.8192
Cp_8134 tree_8134 0 2.592e-15
Rtr_813_8135 tree_813 tree_8135 0.8192
Cp_8135 tree_8135 0 2.592e-15
Rtr_813_8136 tree_813 tree_8136 0.8192
Cp_8136 tree_8136 0 2.592e-15
Rtr_813_8137 tree_813 tree_8137 0.8192
Cp_8137 tree_8137 0 2.592e-15
Rtr_813_8138 tree_813 tree_8138 0.8192
Cp_8138 tree_8138 0 2.592e-15
Rtr_813_8139 tree_813 tree_8139 0.8192
Cp_8139 tree_8139 0 2.592e-15
Rtr_813_8140 tree_813 tree_8140 0.8192
Cp_8140 tree_8140 0 2.592e-15
Rtr_814_8141 tree_814 tree_8141 0.8192
Cp_8141 tree_8141 0 2.592e-15
Rtr_814_8142 tree_814 tree_8142 0.8192
Cp_8142 tree_8142 0 2.592e-15
Rtr_814_8143 tree_814 tree_8143 0.8192
Cp_8143 tree_8143 0 2.592e-15
Rtr_814_8144 tree_814 tree_8144 0.8192
Cp_8144 tree_8144 0 2.592e-15
Rtr_814_8145 tree_814 tree_8145 0.8192
Cp_8145 tree_8145 0 2.592e-15
Rtr_814_8146 tree_814 tree_8146 0.8192
Cp_8146 tree_8146 0 2.592e-15
Rtr_814_8147 tree_814 tree_8147 0.8192
Cp_8147 tree_8147 0 2.592e-15
Rtr_814_8148 tree_814 tree_8148 0.8192
Cp_8148 tree_8148 0 2.592e-15
Rtr_814_8149 tree_814 tree_8149 0.8192
Cp_8149 tree_8149 0 2.592e-15
Rtr_814_8150 tree_814 tree_8150 0.8192
Cp_8150 tree_8150 0 2.592e-15
Rtr_815_8151 tree_815 tree_8151 0.8192
Cp_8151 tree_8151 0 2.592e-15
Rtr_815_8152 tree_815 tree_8152 0.8192
Cp_8152 tree_8152 0 2.592e-15
Rtr_815_8153 tree_815 tree_8153 0.8192
Cp_8153 tree_8153 0 2.592e-15
Rtr_815_8154 tree_815 tree_8154 0.8192
Cp_8154 tree_8154 0 2.592e-15
Rtr_815_8155 tree_815 tree_8155 0.8192
Cp_8155 tree_8155 0 2.592e-15
Rtr_815_8156 tree_815 tree_8156 0.8192
Cp_8156 tree_8156 0 2.592e-15
Rtr_815_8157 tree_815 tree_8157 0.8192
Cp_8157 tree_8157 0 2.592e-15
Rtr_815_8158 tree_815 tree_8158 0.8192
Cp_8158 tree_8158 0 2.592e-15
Rtr_815_8159 tree_815 tree_8159 0.8192
Cp_8159 tree_8159 0 2.592e-15
Rtr_815_8160 tree_815 tree_8160 0.8192
Cp_8160 tree_8160 0 2.592e-15
Rtr_816_8161 tree_816 tree_8161 0.8192
Cp_8161 tree_8161 0 2.592e-15
Rtr_816_8162 tree_816 tree_8162 0.8192
Cp_8162 tree_8162 0 2.592e-15
Rtr_816_8163 tree_816 tree_8163 0.8192
Cp_8163 tree_8163 0 2.592e-15
Rtr_816_8164 tree_816 tree_8164 0.8192
Cp_8164 tree_8164 0 2.592e-15
Rtr_816_8165 tree_816 tree_8165 0.8192
Cp_8165 tree_8165 0 2.592e-15
Rtr_816_8166 tree_816 tree_8166 0.8192
Cp_8166 tree_8166 0 2.592e-15
Rtr_816_8167 tree_816 tree_8167 0.8192
Cp_8167 tree_8167 0 2.592e-15
Rtr_816_8168 tree_816 tree_8168 0.8192
Cp_8168 tree_8168 0 2.592e-15
Rtr_816_8169 tree_816 tree_8169 0.8192
Cp_8169 tree_8169 0 2.592e-15
Rtr_816_8170 tree_816 tree_8170 0.8192
Cp_8170 tree_8170 0 2.592e-15
Rtr_817_8171 tree_817 tree_8171 0.8192
Cp_8171 tree_8171 0 2.592e-15
Rtr_817_8172 tree_817 tree_8172 0.8192
Cp_8172 tree_8172 0 2.592e-15
Rtr_817_8173 tree_817 tree_8173 0.8192
Cp_8173 tree_8173 0 2.592e-15
Rtr_817_8174 tree_817 tree_8174 0.8192
Cp_8174 tree_8174 0 2.592e-15
Rtr_817_8175 tree_817 tree_8175 0.8192
Cp_8175 tree_8175 0 2.592e-15
Rtr_817_8176 tree_817 tree_8176 0.8192
Cp_8176 tree_8176 0 2.592e-15
Rtr_817_8177 tree_817 tree_8177 0.8192
Cp_8177 tree_8177 0 2.592e-15
Rtr_817_8178 tree_817 tree_8178 0.8192
Cp_8178 tree_8178 0 2.592e-15
Rtr_817_8179 tree_817 tree_8179 0.8192
Cp_8179 tree_8179 0 2.592e-15
Rtr_817_8180 tree_817 tree_8180 0.8192
Cp_8180 tree_8180 0 2.592e-15
Rtr_818_8181 tree_818 tree_8181 0.8192
Cp_8181 tree_8181 0 2.592e-15
Rtr_818_8182 tree_818 tree_8182 0.8192
Cp_8182 tree_8182 0 2.592e-15
Rtr_818_8183 tree_818 tree_8183 0.8192
Cp_8183 tree_8183 0 2.592e-15
Rtr_818_8184 tree_818 tree_8184 0.8192
Cp_8184 tree_8184 0 2.592e-15
Rtr_818_8185 tree_818 tree_8185 0.8192
Cp_8185 tree_8185 0 2.592e-15
Rtr_818_8186 tree_818 tree_8186 0.8192
Cp_8186 tree_8186 0 2.592e-15
Rtr_818_8187 tree_818 tree_8187 0.8192
Cp_8187 tree_8187 0 2.592e-15
Rtr_818_8188 tree_818 tree_8188 0.8192
Cp_8188 tree_8188 0 2.592e-15
Rtr_818_8189 tree_818 tree_8189 0.8192
Cp_8189 tree_8189 0 2.592e-15
Rtr_818_8190 tree_818 tree_8190 0.8192
Cp_8190 tree_8190 0 2.592e-15
Rtr_819_8191 tree_819 tree_8191 0.8192
Cp_8191 tree_8191 0 2.592e-15
Rtr_819_8192 tree_819 tree_8192 0.8192
Cp_8192 tree_8192 0 2.592e-15
Rtr_819_8193 tree_819 tree_8193 0.8192
Cp_8193 tree_8193 0 2.592e-15
Rtr_819_8194 tree_819 tree_8194 0.8192
Cp_8194 tree_8194 0 2.592e-15
Rtr_819_8195 tree_819 tree_8195 0.8192
Cp_8195 tree_8195 0 2.592e-15
Rtr_819_8196 tree_819 tree_8196 0.8192
Cp_8196 tree_8196 0 2.592e-15
Rtr_819_8197 tree_819 tree_8197 0.8192
Cp_8197 tree_8197 0 2.592e-15
Rtr_819_8198 tree_819 tree_8198 0.8192
Cp_8198 tree_8198 0 2.592e-15
Rtr_819_8199 tree_819 tree_8199 0.8192
Cp_8199 tree_8199 0 2.592e-15
Rtr_819_8200 tree_819 tree_8200 0.8192
Cp_8200 tree_8200 0 2.592e-15
Rtr_820_8201 tree_820 tree_8201 0.8192
Cp_8201 tree_8201 0 2.592e-15
Rtr_820_8202 tree_820 tree_8202 0.8192
Cp_8202 tree_8202 0 2.592e-15
Rtr_820_8203 tree_820 tree_8203 0.8192
Cp_8203 tree_8203 0 2.592e-15
Rtr_820_8204 tree_820 tree_8204 0.8192
Cp_8204 tree_8204 0 2.592e-15
Rtr_820_8205 tree_820 tree_8205 0.8192
Cp_8205 tree_8205 0 2.592e-15
Rtr_820_8206 tree_820 tree_8206 0.8192
Cp_8206 tree_8206 0 2.592e-15
Rtr_820_8207 tree_820 tree_8207 0.8192
Cp_8207 tree_8207 0 2.592e-15
Rtr_820_8208 tree_820 tree_8208 0.8192
Cp_8208 tree_8208 0 2.592e-15
Rtr_820_8209 tree_820 tree_8209 0.8192
Cp_8209 tree_8209 0 2.592e-15
Rtr_820_8210 tree_820 tree_8210 0.8192
Cp_8210 tree_8210 0 2.592e-15
Rtr_821_8211 tree_821 tree_8211 0.8192
Cp_8211 tree_8211 0 2.592e-15
Rtr_821_8212 tree_821 tree_8212 0.8192
Cp_8212 tree_8212 0 2.592e-15
Rtr_821_8213 tree_821 tree_8213 0.8192
Cp_8213 tree_8213 0 2.592e-15
Rtr_821_8214 tree_821 tree_8214 0.8192
Cp_8214 tree_8214 0 2.592e-15
Rtr_821_8215 tree_821 tree_8215 0.8192
Cp_8215 tree_8215 0 2.592e-15
Rtr_821_8216 tree_821 tree_8216 0.8192
Cp_8216 tree_8216 0 2.592e-15
Rtr_821_8217 tree_821 tree_8217 0.8192
Cp_8217 tree_8217 0 2.592e-15
Rtr_821_8218 tree_821 tree_8218 0.8192
Cp_8218 tree_8218 0 2.592e-15
Rtr_821_8219 tree_821 tree_8219 0.8192
Cp_8219 tree_8219 0 2.592e-15
Rtr_821_8220 tree_821 tree_8220 0.8192
Cp_8220 tree_8220 0 2.592e-15
Rtr_822_8221 tree_822 tree_8221 0.8192
Cp_8221 tree_8221 0 2.592e-15
Rtr_822_8222 tree_822 tree_8222 0.8192
Cp_8222 tree_8222 0 2.592e-15
Rtr_822_8223 tree_822 tree_8223 0.8192
Cp_8223 tree_8223 0 2.592e-15
Rtr_822_8224 tree_822 tree_8224 0.8192
Cp_8224 tree_8224 0 2.592e-15
Rtr_822_8225 tree_822 tree_8225 0.8192
Cp_8225 tree_8225 0 2.592e-15
Rtr_822_8226 tree_822 tree_8226 0.8192
Cp_8226 tree_8226 0 2.592e-15
Rtr_822_8227 tree_822 tree_8227 0.8192
Cp_8227 tree_8227 0 2.592e-15
Rtr_822_8228 tree_822 tree_8228 0.8192
Cp_8228 tree_8228 0 2.592e-15
Rtr_822_8229 tree_822 tree_8229 0.8192
Cp_8229 tree_8229 0 2.592e-15
Rtr_822_8230 tree_822 tree_8230 0.8192
Cp_8230 tree_8230 0 2.592e-15
Rtr_823_8231 tree_823 tree_8231 0.8192
Cp_8231 tree_8231 0 2.592e-15
Rtr_823_8232 tree_823 tree_8232 0.8192
Cp_8232 tree_8232 0 2.592e-15
Rtr_823_8233 tree_823 tree_8233 0.8192
Cp_8233 tree_8233 0 2.592e-15
Rtr_823_8234 tree_823 tree_8234 0.8192
Cp_8234 tree_8234 0 2.592e-15
Rtr_823_8235 tree_823 tree_8235 0.8192
Cp_8235 tree_8235 0 2.592e-15
Rtr_823_8236 tree_823 tree_8236 0.8192
Cp_8236 tree_8236 0 2.592e-15
Rtr_823_8237 tree_823 tree_8237 0.8192
Cp_8237 tree_8237 0 2.592e-15
Rtr_823_8238 tree_823 tree_8238 0.8192
Cp_8238 tree_8238 0 2.592e-15
Rtr_823_8239 tree_823 tree_8239 0.8192
Cp_8239 tree_8239 0 2.592e-15
Rtr_823_8240 tree_823 tree_8240 0.8192
Cp_8240 tree_8240 0 2.592e-15
Rtr_824_8241 tree_824 tree_8241 0.8192
Cp_8241 tree_8241 0 2.592e-15
Rtr_824_8242 tree_824 tree_8242 0.8192
Cp_8242 tree_8242 0 2.592e-15
Rtr_824_8243 tree_824 tree_8243 0.8192
Cp_8243 tree_8243 0 2.592e-15
Rtr_824_8244 tree_824 tree_8244 0.8192
Cp_8244 tree_8244 0 2.592e-15
Rtr_824_8245 tree_824 tree_8245 0.8192
Cp_8245 tree_8245 0 2.592e-15
Rtr_824_8246 tree_824 tree_8246 0.8192
Cp_8246 tree_8246 0 2.592e-15
Rtr_824_8247 tree_824 tree_8247 0.8192
Cp_8247 tree_8247 0 2.592e-15
Rtr_824_8248 tree_824 tree_8248 0.8192
Cp_8248 tree_8248 0 2.592e-15
Rtr_824_8249 tree_824 tree_8249 0.8192
Cp_8249 tree_8249 0 2.592e-15
Rtr_824_8250 tree_824 tree_8250 0.8192
Cp_8250 tree_8250 0 2.592e-15
Rtr_825_8251 tree_825 tree_8251 0.8192
Cp_8251 tree_8251 0 2.592e-15
Rtr_825_8252 tree_825 tree_8252 0.8192
Cp_8252 tree_8252 0 2.592e-15
Rtr_825_8253 tree_825 tree_8253 0.8192
Cp_8253 tree_8253 0 2.592e-15
Rtr_825_8254 tree_825 tree_8254 0.8192
Cp_8254 tree_8254 0 2.592e-15
Rtr_825_8255 tree_825 tree_8255 0.8192
Cp_8255 tree_8255 0 2.592e-15
Rtr_825_8256 tree_825 tree_8256 0.8192
Cp_8256 tree_8256 0 2.592e-15
Rtr_825_8257 tree_825 tree_8257 0.8192
Cp_8257 tree_8257 0 2.592e-15
Rtr_825_8258 tree_825 tree_8258 0.8192
Cp_8258 tree_8258 0 2.592e-15
Rtr_825_8259 tree_825 tree_8259 0.8192
Cp_8259 tree_8259 0 2.592e-15
Rtr_825_8260 tree_825 tree_8260 0.8192
Cp_8260 tree_8260 0 2.592e-15
Rtr_826_8261 tree_826 tree_8261 0.8192
Cp_8261 tree_8261 0 2.592e-15
Rtr_826_8262 tree_826 tree_8262 0.8192
Cp_8262 tree_8262 0 2.592e-15
Rtr_826_8263 tree_826 tree_8263 0.8192
Cp_8263 tree_8263 0 2.592e-15
Rtr_826_8264 tree_826 tree_8264 0.8192
Cp_8264 tree_8264 0 2.592e-15
Rtr_826_8265 tree_826 tree_8265 0.8192
Cp_8265 tree_8265 0 2.592e-15
Rtr_826_8266 tree_826 tree_8266 0.8192
Cp_8266 tree_8266 0 2.592e-15
Rtr_826_8267 tree_826 tree_8267 0.8192
Cp_8267 tree_8267 0 2.592e-15
Rtr_826_8268 tree_826 tree_8268 0.8192
Cp_8268 tree_8268 0 2.592e-15
Rtr_826_8269 tree_826 tree_8269 0.8192
Cp_8269 tree_8269 0 2.592e-15
Rtr_826_8270 tree_826 tree_8270 0.8192
Cp_8270 tree_8270 0 2.592e-15
Rtr_827_8271 tree_827 tree_8271 0.8192
Cp_8271 tree_8271 0 2.592e-15
Rtr_827_8272 tree_827 tree_8272 0.8192
Cp_8272 tree_8272 0 2.592e-15
Rtr_827_8273 tree_827 tree_8273 0.8192
Cp_8273 tree_8273 0 2.592e-15
Rtr_827_8274 tree_827 tree_8274 0.8192
Cp_8274 tree_8274 0 2.592e-15
Rtr_827_8275 tree_827 tree_8275 0.8192
Cp_8275 tree_8275 0 2.592e-15
Rtr_827_8276 tree_827 tree_8276 0.8192
Cp_8276 tree_8276 0 2.592e-15
Rtr_827_8277 tree_827 tree_8277 0.8192
Cp_8277 tree_8277 0 2.592e-15
Rtr_827_8278 tree_827 tree_8278 0.8192
Cp_8278 tree_8278 0 2.592e-15
Rtr_827_8279 tree_827 tree_8279 0.8192
Cp_8279 tree_8279 0 2.592e-15
Rtr_827_8280 tree_827 tree_8280 0.8192
Cp_8280 tree_8280 0 2.592e-15
Rtr_828_8281 tree_828 tree_8281 0.8192
Cp_8281 tree_8281 0 2.592e-15
Rtr_828_8282 tree_828 tree_8282 0.8192
Cp_8282 tree_8282 0 2.592e-15
Rtr_828_8283 tree_828 tree_8283 0.8192
Cp_8283 tree_8283 0 2.592e-15
Rtr_828_8284 tree_828 tree_8284 0.8192
Cp_8284 tree_8284 0 2.592e-15
Rtr_828_8285 tree_828 tree_8285 0.8192
Cp_8285 tree_8285 0 2.592e-15
Rtr_828_8286 tree_828 tree_8286 0.8192
Cp_8286 tree_8286 0 2.592e-15
Rtr_828_8287 tree_828 tree_8287 0.8192
Cp_8287 tree_8287 0 2.592e-15
Rtr_828_8288 tree_828 tree_8288 0.8192
Cp_8288 tree_8288 0 2.592e-15
Rtr_828_8289 tree_828 tree_8289 0.8192
Cp_8289 tree_8289 0 2.592e-15
Rtr_828_8290 tree_828 tree_8290 0.8192
Cp_8290 tree_8290 0 2.592e-15
Rtr_829_8291 tree_829 tree_8291 0.8192
Cp_8291 tree_8291 0 2.592e-15
Rtr_829_8292 tree_829 tree_8292 0.8192
Cp_8292 tree_8292 0 2.592e-15
Rtr_829_8293 tree_829 tree_8293 0.8192
Cp_8293 tree_8293 0 2.592e-15
Rtr_829_8294 tree_829 tree_8294 0.8192
Cp_8294 tree_8294 0 2.592e-15
Rtr_829_8295 tree_829 tree_8295 0.8192
Cp_8295 tree_8295 0 2.592e-15
Rtr_829_8296 tree_829 tree_8296 0.8192
Cp_8296 tree_8296 0 2.592e-15
Rtr_829_8297 tree_829 tree_8297 0.8192
Cp_8297 tree_8297 0 2.592e-15
Rtr_829_8298 tree_829 tree_8298 0.8192
Cp_8298 tree_8298 0 2.592e-15
Rtr_829_8299 tree_829 tree_8299 0.8192
Cp_8299 tree_8299 0 2.592e-15
Rtr_829_8300 tree_829 tree_8300 0.8192
Cp_8300 tree_8300 0 2.592e-15
Rtr_830_8301 tree_830 tree_8301 0.8192
Cp_8301 tree_8301 0 2.592e-15
Rtr_830_8302 tree_830 tree_8302 0.8192
Cp_8302 tree_8302 0 2.592e-15
Rtr_830_8303 tree_830 tree_8303 0.8192
Cp_8303 tree_8303 0 2.592e-15
Rtr_830_8304 tree_830 tree_8304 0.8192
Cp_8304 tree_8304 0 2.592e-15
Rtr_830_8305 tree_830 tree_8305 0.8192
Cp_8305 tree_8305 0 2.592e-15
Rtr_830_8306 tree_830 tree_8306 0.8192
Cp_8306 tree_8306 0 2.592e-15
Rtr_830_8307 tree_830 tree_8307 0.8192
Cp_8307 tree_8307 0 2.592e-15
Rtr_830_8308 tree_830 tree_8308 0.8192
Cp_8308 tree_8308 0 2.592e-15
Rtr_830_8309 tree_830 tree_8309 0.8192
Cp_8309 tree_8309 0 2.592e-15
Rtr_830_8310 tree_830 tree_8310 0.8192
Cp_8310 tree_8310 0 2.592e-15
Rtr_831_8311 tree_831 tree_8311 0.8192
Cp_8311 tree_8311 0 2.592e-15
Rtr_831_8312 tree_831 tree_8312 0.8192
Cp_8312 tree_8312 0 2.592e-15
Rtr_831_8313 tree_831 tree_8313 0.8192
Cp_8313 tree_8313 0 2.592e-15
Rtr_831_8314 tree_831 tree_8314 0.8192
Cp_8314 tree_8314 0 2.592e-15
Rtr_831_8315 tree_831 tree_8315 0.8192
Cp_8315 tree_8315 0 2.592e-15
Rtr_831_8316 tree_831 tree_8316 0.8192
Cp_8316 tree_8316 0 2.592e-15
Rtr_831_8317 tree_831 tree_8317 0.8192
Cp_8317 tree_8317 0 2.592e-15
Rtr_831_8318 tree_831 tree_8318 0.8192
Cp_8318 tree_8318 0 2.592e-15
Rtr_831_8319 tree_831 tree_8319 0.8192
Cp_8319 tree_8319 0 2.592e-15
Rtr_831_8320 tree_831 tree_8320 0.8192
Cp_8320 tree_8320 0 2.592e-15
Rtr_832_8321 tree_832 tree_8321 0.8192
Cp_8321 tree_8321 0 2.592e-15
Rtr_832_8322 tree_832 tree_8322 0.8192
Cp_8322 tree_8322 0 2.592e-15
Rtr_832_8323 tree_832 tree_8323 0.8192
Cp_8323 tree_8323 0 2.592e-15
Rtr_832_8324 tree_832 tree_8324 0.8192
Cp_8324 tree_8324 0 2.592e-15
Rtr_832_8325 tree_832 tree_8325 0.8192
Cp_8325 tree_8325 0 2.592e-15
Rtr_832_8326 tree_832 tree_8326 0.8192
Cp_8326 tree_8326 0 2.592e-15
Rtr_832_8327 tree_832 tree_8327 0.8192
Cp_8327 tree_8327 0 2.592e-15
Rtr_832_8328 tree_832 tree_8328 0.8192
Cp_8328 tree_8328 0 2.592e-15
Rtr_832_8329 tree_832 tree_8329 0.8192
Cp_8329 tree_8329 0 2.592e-15
Rtr_832_8330 tree_832 tree_8330 0.8192
Cp_8330 tree_8330 0 2.592e-15
Rtr_833_8331 tree_833 tree_8331 0.8192
Cp_8331 tree_8331 0 2.592e-15
Rtr_833_8332 tree_833 tree_8332 0.8192
Cp_8332 tree_8332 0 2.592e-15
Rtr_833_8333 tree_833 tree_8333 0.8192
Cp_8333 tree_8333 0 2.592e-15
Rtr_833_8334 tree_833 tree_8334 0.8192
Cp_8334 tree_8334 0 2.592e-15
Rtr_833_8335 tree_833 tree_8335 0.8192
Cp_8335 tree_8335 0 2.592e-15
Rtr_833_8336 tree_833 tree_8336 0.8192
Cp_8336 tree_8336 0 2.592e-15
Rtr_833_8337 tree_833 tree_8337 0.8192
Cp_8337 tree_8337 0 2.592e-15
Rtr_833_8338 tree_833 tree_8338 0.8192
Cp_8338 tree_8338 0 2.592e-15
Rtr_833_8339 tree_833 tree_8339 0.8192
Cp_8339 tree_8339 0 2.592e-15
Rtr_833_8340 tree_833 tree_8340 0.8192
Cp_8340 tree_8340 0 2.592e-15
Rtr_834_8341 tree_834 tree_8341 0.8192
Cp_8341 tree_8341 0 2.592e-15
Rtr_834_8342 tree_834 tree_8342 0.8192
Cp_8342 tree_8342 0 2.592e-15
Rtr_834_8343 tree_834 tree_8343 0.8192
Cp_8343 tree_8343 0 2.592e-15
Rtr_834_8344 tree_834 tree_8344 0.8192
Cp_8344 tree_8344 0 2.592e-15
Rtr_834_8345 tree_834 tree_8345 0.8192
Cp_8345 tree_8345 0 2.592e-15
Rtr_834_8346 tree_834 tree_8346 0.8192
Cp_8346 tree_8346 0 2.592e-15
Rtr_834_8347 tree_834 tree_8347 0.8192
Cp_8347 tree_8347 0 2.592e-15
Rtr_834_8348 tree_834 tree_8348 0.8192
Cp_8348 tree_8348 0 2.592e-15
Rtr_834_8349 tree_834 tree_8349 0.8192
Cp_8349 tree_8349 0 2.592e-15
Rtr_834_8350 tree_834 tree_8350 0.8192
Cp_8350 tree_8350 0 2.592e-15
Rtr_835_8351 tree_835 tree_8351 0.8192
Cp_8351 tree_8351 0 2.592e-15
Rtr_835_8352 tree_835 tree_8352 0.8192
Cp_8352 tree_8352 0 2.592e-15
Rtr_835_8353 tree_835 tree_8353 0.8192
Cp_8353 tree_8353 0 2.592e-15
Rtr_835_8354 tree_835 tree_8354 0.8192
Cp_8354 tree_8354 0 2.592e-15
Rtr_835_8355 tree_835 tree_8355 0.8192
Cp_8355 tree_8355 0 2.592e-15
Rtr_835_8356 tree_835 tree_8356 0.8192
Cp_8356 tree_8356 0 2.592e-15
Rtr_835_8357 tree_835 tree_8357 0.8192
Cp_8357 tree_8357 0 2.592e-15
Rtr_835_8358 tree_835 tree_8358 0.8192
Cp_8358 tree_8358 0 2.592e-15
Rtr_835_8359 tree_835 tree_8359 0.8192
Cp_8359 tree_8359 0 2.592e-15
Rtr_835_8360 tree_835 tree_8360 0.8192
Cp_8360 tree_8360 0 2.592e-15
Rtr_836_8361 tree_836 tree_8361 0.8192
Cp_8361 tree_8361 0 2.592e-15
Rtr_836_8362 tree_836 tree_8362 0.8192
Cp_8362 tree_8362 0 2.592e-15
Rtr_836_8363 tree_836 tree_8363 0.8192
Cp_8363 tree_8363 0 2.592e-15
Rtr_836_8364 tree_836 tree_8364 0.8192
Cp_8364 tree_8364 0 2.592e-15
Rtr_836_8365 tree_836 tree_8365 0.8192
Cp_8365 tree_8365 0 2.592e-15
Rtr_836_8366 tree_836 tree_8366 0.8192
Cp_8366 tree_8366 0 2.592e-15
Rtr_836_8367 tree_836 tree_8367 0.8192
Cp_8367 tree_8367 0 2.592e-15
Rtr_836_8368 tree_836 tree_8368 0.8192
Cp_8368 tree_8368 0 2.592e-15
Rtr_836_8369 tree_836 tree_8369 0.8192
Cp_8369 tree_8369 0 2.592e-15
Rtr_836_8370 tree_836 tree_8370 0.8192
Cp_8370 tree_8370 0 2.592e-15
Rtr_837_8371 tree_837 tree_8371 0.8192
Cp_8371 tree_8371 0 2.592e-15
Rtr_837_8372 tree_837 tree_8372 0.8192
Cp_8372 tree_8372 0 2.592e-15
Rtr_837_8373 tree_837 tree_8373 0.8192
Cp_8373 tree_8373 0 2.592e-15
Rtr_837_8374 tree_837 tree_8374 0.8192
Cp_8374 tree_8374 0 2.592e-15
Rtr_837_8375 tree_837 tree_8375 0.8192
Cp_8375 tree_8375 0 2.592e-15
Rtr_837_8376 tree_837 tree_8376 0.8192
Cp_8376 tree_8376 0 2.592e-15
Rtr_837_8377 tree_837 tree_8377 0.8192
Cp_8377 tree_8377 0 2.592e-15
Rtr_837_8378 tree_837 tree_8378 0.8192
Cp_8378 tree_8378 0 2.592e-15
Rtr_837_8379 tree_837 tree_8379 0.8192
Cp_8379 tree_8379 0 2.592e-15
Rtr_837_8380 tree_837 tree_8380 0.8192
Cp_8380 tree_8380 0 2.592e-15
Rtr_838_8381 tree_838 tree_8381 0.8192
Cp_8381 tree_8381 0 2.592e-15
Rtr_838_8382 tree_838 tree_8382 0.8192
Cp_8382 tree_8382 0 2.592e-15
Rtr_838_8383 tree_838 tree_8383 0.8192
Cp_8383 tree_8383 0 2.592e-15
Rtr_838_8384 tree_838 tree_8384 0.8192
Cp_8384 tree_8384 0 2.592e-15
Rtr_838_8385 tree_838 tree_8385 0.8192
Cp_8385 tree_8385 0 2.592e-15
Rtr_838_8386 tree_838 tree_8386 0.8192
Cp_8386 tree_8386 0 2.592e-15
Rtr_838_8387 tree_838 tree_8387 0.8192
Cp_8387 tree_8387 0 2.592e-15
Rtr_838_8388 tree_838 tree_8388 0.8192
Cp_8388 tree_8388 0 2.592e-15
Rtr_838_8389 tree_838 tree_8389 0.8192
Cp_8389 tree_8389 0 2.592e-15
Rtr_838_8390 tree_838 tree_8390 0.8192
Cp_8390 tree_8390 0 2.592e-15
Rtr_839_8391 tree_839 tree_8391 0.8192
Cp_8391 tree_8391 0 2.592e-15
Rtr_839_8392 tree_839 tree_8392 0.8192
Cp_8392 tree_8392 0 2.592e-15
Rtr_839_8393 tree_839 tree_8393 0.8192
Cp_8393 tree_8393 0 2.592e-15
Rtr_839_8394 tree_839 tree_8394 0.8192
Cp_8394 tree_8394 0 2.592e-15
Rtr_839_8395 tree_839 tree_8395 0.8192
Cp_8395 tree_8395 0 2.592e-15
Rtr_839_8396 tree_839 tree_8396 0.8192
Cp_8396 tree_8396 0 2.592e-15
Rtr_839_8397 tree_839 tree_8397 0.8192
Cp_8397 tree_8397 0 2.592e-15
Rtr_839_8398 tree_839 tree_8398 0.8192
Cp_8398 tree_8398 0 2.592e-15
Rtr_839_8399 tree_839 tree_8399 0.8192
Cp_8399 tree_8399 0 2.592e-15
Rtr_839_8400 tree_839 tree_8400 0.8192
Cp_8400 tree_8400 0 2.592e-15
Rtr_840_8401 tree_840 tree_8401 0.8192
Cp_8401 tree_8401 0 2.592e-15
Rtr_840_8402 tree_840 tree_8402 0.8192
Cp_8402 tree_8402 0 2.592e-15
Rtr_840_8403 tree_840 tree_8403 0.8192
Cp_8403 tree_8403 0 2.592e-15
Rtr_840_8404 tree_840 tree_8404 0.8192
Cp_8404 tree_8404 0 2.592e-15
Rtr_840_8405 tree_840 tree_8405 0.8192
Cp_8405 tree_8405 0 2.592e-15
Rtr_840_8406 tree_840 tree_8406 0.8192
Cp_8406 tree_8406 0 2.592e-15
Rtr_840_8407 tree_840 tree_8407 0.8192
Cp_8407 tree_8407 0 2.592e-15
Rtr_840_8408 tree_840 tree_8408 0.8192
Cp_8408 tree_8408 0 2.592e-15
Rtr_840_8409 tree_840 tree_8409 0.8192
Cp_8409 tree_8409 0 2.592e-15
Rtr_840_8410 tree_840 tree_8410 0.8192
Cp_8410 tree_8410 0 2.592e-15
Rtr_841_8411 tree_841 tree_8411 0.8192
Cp_8411 tree_8411 0 2.592e-15
Rtr_841_8412 tree_841 tree_8412 0.8192
Cp_8412 tree_8412 0 2.592e-15
Rtr_841_8413 tree_841 tree_8413 0.8192
Cp_8413 tree_8413 0 2.592e-15
Rtr_841_8414 tree_841 tree_8414 0.8192
Cp_8414 tree_8414 0 2.592e-15
Rtr_841_8415 tree_841 tree_8415 0.8192
Cp_8415 tree_8415 0 2.592e-15
Rtr_841_8416 tree_841 tree_8416 0.8192
Cp_8416 tree_8416 0 2.592e-15
Rtr_841_8417 tree_841 tree_8417 0.8192
Cp_8417 tree_8417 0 2.592e-15
Rtr_841_8418 tree_841 tree_8418 0.8192
Cp_8418 tree_8418 0 2.592e-15
Rtr_841_8419 tree_841 tree_8419 0.8192
Cp_8419 tree_8419 0 2.592e-15
Rtr_841_8420 tree_841 tree_8420 0.8192
Cp_8420 tree_8420 0 2.592e-15
Rtr_842_8421 tree_842 tree_8421 0.8192
Cp_8421 tree_8421 0 2.592e-15
Rtr_842_8422 tree_842 tree_8422 0.8192
Cp_8422 tree_8422 0 2.592e-15
Rtr_842_8423 tree_842 tree_8423 0.8192
Cp_8423 tree_8423 0 2.592e-15
Rtr_842_8424 tree_842 tree_8424 0.8192
Cp_8424 tree_8424 0 2.592e-15
Rtr_842_8425 tree_842 tree_8425 0.8192
Cp_8425 tree_8425 0 2.592e-15
Rtr_842_8426 tree_842 tree_8426 0.8192
Cp_8426 tree_8426 0 2.592e-15
Rtr_842_8427 tree_842 tree_8427 0.8192
Cp_8427 tree_8427 0 2.592e-15
Rtr_842_8428 tree_842 tree_8428 0.8192
Cp_8428 tree_8428 0 2.592e-15
Rtr_842_8429 tree_842 tree_8429 0.8192
Cp_8429 tree_8429 0 2.592e-15
Rtr_842_8430 tree_842 tree_8430 0.8192
Cp_8430 tree_8430 0 2.592e-15
Rtr_843_8431 tree_843 tree_8431 0.8192
Cp_8431 tree_8431 0 2.592e-15
Rtr_843_8432 tree_843 tree_8432 0.8192
Cp_8432 tree_8432 0 2.592e-15
Rtr_843_8433 tree_843 tree_8433 0.8192
Cp_8433 tree_8433 0 2.592e-15
Rtr_843_8434 tree_843 tree_8434 0.8192
Cp_8434 tree_8434 0 2.592e-15
Rtr_843_8435 tree_843 tree_8435 0.8192
Cp_8435 tree_8435 0 2.592e-15
Rtr_843_8436 tree_843 tree_8436 0.8192
Cp_8436 tree_8436 0 2.592e-15
Rtr_843_8437 tree_843 tree_8437 0.8192
Cp_8437 tree_8437 0 2.592e-15
Rtr_843_8438 tree_843 tree_8438 0.8192
Cp_8438 tree_8438 0 2.592e-15
Rtr_843_8439 tree_843 tree_8439 0.8192
Cp_8439 tree_8439 0 2.592e-15
Rtr_843_8440 tree_843 tree_8440 0.8192
Cp_8440 tree_8440 0 2.592e-15
Rtr_844_8441 tree_844 tree_8441 0.8192
Cp_8441 tree_8441 0 2.592e-15
Rtr_844_8442 tree_844 tree_8442 0.8192
Cp_8442 tree_8442 0 2.592e-15
Rtr_844_8443 tree_844 tree_8443 0.8192
Cp_8443 tree_8443 0 2.592e-15
Rtr_844_8444 tree_844 tree_8444 0.8192
Cp_8444 tree_8444 0 2.592e-15
Rtr_844_8445 tree_844 tree_8445 0.8192
Cp_8445 tree_8445 0 2.592e-15
Rtr_844_8446 tree_844 tree_8446 0.8192
Cp_8446 tree_8446 0 2.592e-15
Rtr_844_8447 tree_844 tree_8447 0.8192
Cp_8447 tree_8447 0 2.592e-15
Rtr_844_8448 tree_844 tree_8448 0.8192
Cp_8448 tree_8448 0 2.592e-15
Rtr_844_8449 tree_844 tree_8449 0.8192
Cp_8449 tree_8449 0 2.592e-15
Rtr_844_8450 tree_844 tree_8450 0.8192
Cp_8450 tree_8450 0 2.592e-15
Rtr_845_8451 tree_845 tree_8451 0.8192
Cp_8451 tree_8451 0 2.592e-15
Rtr_845_8452 tree_845 tree_8452 0.8192
Cp_8452 tree_8452 0 2.592e-15
Rtr_845_8453 tree_845 tree_8453 0.8192
Cp_8453 tree_8453 0 2.592e-15
Rtr_845_8454 tree_845 tree_8454 0.8192
Cp_8454 tree_8454 0 2.592e-15
Rtr_845_8455 tree_845 tree_8455 0.8192
Cp_8455 tree_8455 0 2.592e-15
Rtr_845_8456 tree_845 tree_8456 0.8192
Cp_8456 tree_8456 0 2.592e-15
Rtr_845_8457 tree_845 tree_8457 0.8192
Cp_8457 tree_8457 0 2.592e-15
Rtr_845_8458 tree_845 tree_8458 0.8192
Cp_8458 tree_8458 0 2.592e-15
Rtr_845_8459 tree_845 tree_8459 0.8192
Cp_8459 tree_8459 0 2.592e-15
Rtr_845_8460 tree_845 tree_8460 0.8192
Cp_8460 tree_8460 0 2.592e-15
Rtr_846_8461 tree_846 tree_8461 0.8192
Cp_8461 tree_8461 0 2.592e-15
Rtr_846_8462 tree_846 tree_8462 0.8192
Cp_8462 tree_8462 0 2.592e-15
Rtr_846_8463 tree_846 tree_8463 0.8192
Cp_8463 tree_8463 0 2.592e-15
Rtr_846_8464 tree_846 tree_8464 0.8192
Cp_8464 tree_8464 0 2.592e-15
Rtr_846_8465 tree_846 tree_8465 0.8192
Cp_8465 tree_8465 0 2.592e-15
Rtr_846_8466 tree_846 tree_8466 0.8192
Cp_8466 tree_8466 0 2.592e-15
Rtr_846_8467 tree_846 tree_8467 0.8192
Cp_8467 tree_8467 0 2.592e-15
Rtr_846_8468 tree_846 tree_8468 0.8192
Cp_8468 tree_8468 0 2.592e-15
Rtr_846_8469 tree_846 tree_8469 0.8192
Cp_8469 tree_8469 0 2.592e-15
Rtr_846_8470 tree_846 tree_8470 0.8192
Cp_8470 tree_8470 0 2.592e-15
Rtr_847_8471 tree_847 tree_8471 0.8192
Cp_8471 tree_8471 0 2.592e-15
Rtr_847_8472 tree_847 tree_8472 0.8192
Cp_8472 tree_8472 0 2.592e-15
Rtr_847_8473 tree_847 tree_8473 0.8192
Cp_8473 tree_8473 0 2.592e-15
Rtr_847_8474 tree_847 tree_8474 0.8192
Cp_8474 tree_8474 0 2.592e-15
Rtr_847_8475 tree_847 tree_8475 0.8192
Cp_8475 tree_8475 0 2.592e-15
Rtr_847_8476 tree_847 tree_8476 0.8192
Cp_8476 tree_8476 0 2.592e-15
Rtr_847_8477 tree_847 tree_8477 0.8192
Cp_8477 tree_8477 0 2.592e-15
Rtr_847_8478 tree_847 tree_8478 0.8192
Cp_8478 tree_8478 0 2.592e-15
Rtr_847_8479 tree_847 tree_8479 0.8192
Cp_8479 tree_8479 0 2.592e-15
Rtr_847_8480 tree_847 tree_8480 0.8192
Cp_8480 tree_8480 0 2.592e-15
Rtr_848_8481 tree_848 tree_8481 0.8192
Cp_8481 tree_8481 0 2.592e-15
Rtr_848_8482 tree_848 tree_8482 0.8192
Cp_8482 tree_8482 0 2.592e-15
Rtr_848_8483 tree_848 tree_8483 0.8192
Cp_8483 tree_8483 0 2.592e-15
Rtr_848_8484 tree_848 tree_8484 0.8192
Cp_8484 tree_8484 0 2.592e-15
Rtr_848_8485 tree_848 tree_8485 0.8192
Cp_8485 tree_8485 0 2.592e-15
Rtr_848_8486 tree_848 tree_8486 0.8192
Cp_8486 tree_8486 0 2.592e-15
Rtr_848_8487 tree_848 tree_8487 0.8192
Cp_8487 tree_8487 0 2.592e-15
Rtr_848_8488 tree_848 tree_8488 0.8192
Cp_8488 tree_8488 0 2.592e-15
Rtr_848_8489 tree_848 tree_8489 0.8192
Cp_8489 tree_8489 0 2.592e-15
Rtr_848_8490 tree_848 tree_8490 0.8192
Cp_8490 tree_8490 0 2.592e-15
Rtr_849_8491 tree_849 tree_8491 0.8192
Cp_8491 tree_8491 0 2.592e-15
Rtr_849_8492 tree_849 tree_8492 0.8192
Cp_8492 tree_8492 0 2.592e-15
Rtr_849_8493 tree_849 tree_8493 0.8192
Cp_8493 tree_8493 0 2.592e-15
Rtr_849_8494 tree_849 tree_8494 0.8192
Cp_8494 tree_8494 0 2.592e-15
Rtr_849_8495 tree_849 tree_8495 0.8192
Cp_8495 tree_8495 0 2.592e-15
Rtr_849_8496 tree_849 tree_8496 0.8192
Cp_8496 tree_8496 0 2.592e-15
Rtr_849_8497 tree_849 tree_8497 0.8192
Cp_8497 tree_8497 0 2.592e-15
Rtr_849_8498 tree_849 tree_8498 0.8192
Cp_8498 tree_8498 0 2.592e-15
Rtr_849_8499 tree_849 tree_8499 0.8192
Cp_8499 tree_8499 0 2.592e-15
Rtr_849_8500 tree_849 tree_8500 0.8192
Cp_8500 tree_8500 0 2.592e-15
Rtr_850_8501 tree_850 tree_8501 0.8192
Cp_8501 tree_8501 0 2.592e-15
Rtr_850_8502 tree_850 tree_8502 0.8192
Cp_8502 tree_8502 0 2.592e-15
Rtr_850_8503 tree_850 tree_8503 0.8192
Cp_8503 tree_8503 0 2.592e-15
Rtr_850_8504 tree_850 tree_8504 0.8192
Cp_8504 tree_8504 0 2.592e-15
Rtr_850_8505 tree_850 tree_8505 0.8192
Cp_8505 tree_8505 0 2.592e-15
Rtr_850_8506 tree_850 tree_8506 0.8192
Cp_8506 tree_8506 0 2.592e-15
Rtr_850_8507 tree_850 tree_8507 0.8192
Cp_8507 tree_8507 0 2.592e-15
Rtr_850_8508 tree_850 tree_8508 0.8192
Cp_8508 tree_8508 0 2.592e-15
Rtr_850_8509 tree_850 tree_8509 0.8192
Cp_8509 tree_8509 0 2.592e-15
Rtr_850_8510 tree_850 tree_8510 0.8192
Cp_8510 tree_8510 0 2.592e-15
Rtr_851_8511 tree_851 tree_8511 0.8192
Cp_8511 tree_8511 0 2.592e-15
Rtr_851_8512 tree_851 tree_8512 0.8192
Cp_8512 tree_8512 0 2.592e-15
Rtr_851_8513 tree_851 tree_8513 0.8192
Cp_8513 tree_8513 0 2.592e-15
Rtr_851_8514 tree_851 tree_8514 0.8192
Cp_8514 tree_8514 0 2.592e-15
Rtr_851_8515 tree_851 tree_8515 0.8192
Cp_8515 tree_8515 0 2.592e-15
Rtr_851_8516 tree_851 tree_8516 0.8192
Cp_8516 tree_8516 0 2.592e-15
Rtr_851_8517 tree_851 tree_8517 0.8192
Cp_8517 tree_8517 0 2.592e-15
Rtr_851_8518 tree_851 tree_8518 0.8192
Cp_8518 tree_8518 0 2.592e-15
Rtr_851_8519 tree_851 tree_8519 0.8192
Cp_8519 tree_8519 0 2.592e-15
Rtr_851_8520 tree_851 tree_8520 0.8192
Cp_8520 tree_8520 0 2.592e-15
Rtr_852_8521 tree_852 tree_8521 0.8192
Cp_8521 tree_8521 0 2.592e-15
Rtr_852_8522 tree_852 tree_8522 0.8192
Cp_8522 tree_8522 0 2.592e-15
Rtr_852_8523 tree_852 tree_8523 0.8192
Cp_8523 tree_8523 0 2.592e-15
Rtr_852_8524 tree_852 tree_8524 0.8192
Cp_8524 tree_8524 0 2.592e-15
Rtr_852_8525 tree_852 tree_8525 0.8192
Cp_8525 tree_8525 0 2.592e-15
Rtr_852_8526 tree_852 tree_8526 0.8192
Cp_8526 tree_8526 0 2.592e-15
Rtr_852_8527 tree_852 tree_8527 0.8192
Cp_8527 tree_8527 0 2.592e-15
Rtr_852_8528 tree_852 tree_8528 0.8192
Cp_8528 tree_8528 0 2.592e-15
Rtr_852_8529 tree_852 tree_8529 0.8192
Cp_8529 tree_8529 0 2.592e-15
Rtr_852_8530 tree_852 tree_8530 0.8192
Cp_8530 tree_8530 0 2.592e-15
Rtr_853_8531 tree_853 tree_8531 0.8192
Cp_8531 tree_8531 0 2.592e-15
Rtr_853_8532 tree_853 tree_8532 0.8192
Cp_8532 tree_8532 0 2.592e-15
Rtr_853_8533 tree_853 tree_8533 0.8192
Cp_8533 tree_8533 0 2.592e-15
Rtr_853_8534 tree_853 tree_8534 0.8192
Cp_8534 tree_8534 0 2.592e-15
Rtr_853_8535 tree_853 tree_8535 0.8192
Cp_8535 tree_8535 0 2.592e-15
Rtr_853_8536 tree_853 tree_8536 0.8192
Cp_8536 tree_8536 0 2.592e-15
Rtr_853_8537 tree_853 tree_8537 0.8192
Cp_8537 tree_8537 0 2.592e-15
Rtr_853_8538 tree_853 tree_8538 0.8192
Cp_8538 tree_8538 0 2.592e-15
Rtr_853_8539 tree_853 tree_8539 0.8192
Cp_8539 tree_8539 0 2.592e-15
Rtr_853_8540 tree_853 tree_8540 0.8192
Cp_8540 tree_8540 0 2.592e-15
Rtr_854_8541 tree_854 tree_8541 0.8192
Cp_8541 tree_8541 0 2.592e-15
Rtr_854_8542 tree_854 tree_8542 0.8192
Cp_8542 tree_8542 0 2.592e-15
Rtr_854_8543 tree_854 tree_8543 0.8192
Cp_8543 tree_8543 0 2.592e-15
Rtr_854_8544 tree_854 tree_8544 0.8192
Cp_8544 tree_8544 0 2.592e-15
Rtr_854_8545 tree_854 tree_8545 0.8192
Cp_8545 tree_8545 0 2.592e-15
Rtr_854_8546 tree_854 tree_8546 0.8192
Cp_8546 tree_8546 0 2.592e-15
Rtr_854_8547 tree_854 tree_8547 0.8192
Cp_8547 tree_8547 0 2.592e-15
Rtr_854_8548 tree_854 tree_8548 0.8192
Cp_8548 tree_8548 0 2.592e-15
Rtr_854_8549 tree_854 tree_8549 0.8192
Cp_8549 tree_8549 0 2.592e-15
Rtr_854_8550 tree_854 tree_8550 0.8192
Cp_8550 tree_8550 0 2.592e-15
Rtr_855_8551 tree_855 tree_8551 0.8192
Cp_8551 tree_8551 0 2.592e-15
Rtr_855_8552 tree_855 tree_8552 0.8192
Cp_8552 tree_8552 0 2.592e-15
Rtr_855_8553 tree_855 tree_8553 0.8192
Cp_8553 tree_8553 0 2.592e-15
Rtr_855_8554 tree_855 tree_8554 0.8192
Cp_8554 tree_8554 0 2.592e-15
Rtr_855_8555 tree_855 tree_8555 0.8192
Cp_8555 tree_8555 0 2.592e-15
Rtr_855_8556 tree_855 tree_8556 0.8192
Cp_8556 tree_8556 0 2.592e-15
Rtr_855_8557 tree_855 tree_8557 0.8192
Cp_8557 tree_8557 0 2.592e-15
Rtr_855_8558 tree_855 tree_8558 0.8192
Cp_8558 tree_8558 0 2.592e-15
Rtr_855_8559 tree_855 tree_8559 0.8192
Cp_8559 tree_8559 0 2.592e-15
Rtr_855_8560 tree_855 tree_8560 0.8192
Cp_8560 tree_8560 0 2.592e-15
Rtr_856_8561 tree_856 tree_8561 0.8192
Cp_8561 tree_8561 0 2.592e-15
Rtr_856_8562 tree_856 tree_8562 0.8192
Cp_8562 tree_8562 0 2.592e-15
Rtr_856_8563 tree_856 tree_8563 0.8192
Cp_8563 tree_8563 0 2.592e-15
Rtr_856_8564 tree_856 tree_8564 0.8192
Cp_8564 tree_8564 0 2.592e-15
Rtr_856_8565 tree_856 tree_8565 0.8192
Cp_8565 tree_8565 0 2.592e-15
Rtr_856_8566 tree_856 tree_8566 0.8192
Cp_8566 tree_8566 0 2.592e-15
Rtr_856_8567 tree_856 tree_8567 0.8192
Cp_8567 tree_8567 0 2.592e-15
Rtr_856_8568 tree_856 tree_8568 0.8192
Cp_8568 tree_8568 0 2.592e-15
Rtr_856_8569 tree_856 tree_8569 0.8192
Cp_8569 tree_8569 0 2.592e-15
Rtr_856_8570 tree_856 tree_8570 0.8192
Cp_8570 tree_8570 0 2.592e-15
Rtr_857_8571 tree_857 tree_8571 0.8192
Cp_8571 tree_8571 0 2.592e-15
Rtr_857_8572 tree_857 tree_8572 0.8192
Cp_8572 tree_8572 0 2.592e-15
Rtr_857_8573 tree_857 tree_8573 0.8192
Cp_8573 tree_8573 0 2.592e-15
Rtr_857_8574 tree_857 tree_8574 0.8192
Cp_8574 tree_8574 0 2.592e-15
Rtr_857_8575 tree_857 tree_8575 0.8192
Cp_8575 tree_8575 0 2.592e-15
Rtr_857_8576 tree_857 tree_8576 0.8192
Cp_8576 tree_8576 0 2.592e-15
Rtr_857_8577 tree_857 tree_8577 0.8192
Cp_8577 tree_8577 0 2.592e-15
Rtr_857_8578 tree_857 tree_8578 0.8192
Cp_8578 tree_8578 0 2.592e-15
Rtr_857_8579 tree_857 tree_8579 0.8192
Cp_8579 tree_8579 0 2.592e-15
Rtr_857_8580 tree_857 tree_8580 0.8192
Cp_8580 tree_8580 0 2.592e-15
Rtr_858_8581 tree_858 tree_8581 0.8192
Cp_8581 tree_8581 0 2.592e-15
Rtr_858_8582 tree_858 tree_8582 0.8192
Cp_8582 tree_8582 0 2.592e-15
Rtr_858_8583 tree_858 tree_8583 0.8192
Cp_8583 tree_8583 0 2.592e-15
Rtr_858_8584 tree_858 tree_8584 0.8192
Cp_8584 tree_8584 0 2.592e-15
Rtr_858_8585 tree_858 tree_8585 0.8192
Cp_8585 tree_8585 0 2.592e-15
Rtr_858_8586 tree_858 tree_8586 0.8192
Cp_8586 tree_8586 0 2.592e-15
Rtr_858_8587 tree_858 tree_8587 0.8192
Cp_8587 tree_8587 0 2.592e-15
Rtr_858_8588 tree_858 tree_8588 0.8192
Cp_8588 tree_8588 0 2.592e-15
Rtr_858_8589 tree_858 tree_8589 0.8192
Cp_8589 tree_8589 0 2.592e-15
Rtr_858_8590 tree_858 tree_8590 0.8192
Cp_8590 tree_8590 0 2.592e-15
Rtr_859_8591 tree_859 tree_8591 0.8192
Cp_8591 tree_8591 0 2.592e-15
Rtr_859_8592 tree_859 tree_8592 0.8192
Cp_8592 tree_8592 0 2.592e-15
Rtr_859_8593 tree_859 tree_8593 0.8192
Cp_8593 tree_8593 0 2.592e-15
Rtr_859_8594 tree_859 tree_8594 0.8192
Cp_8594 tree_8594 0 2.592e-15
Rtr_859_8595 tree_859 tree_8595 0.8192
Cp_8595 tree_8595 0 2.592e-15
Rtr_859_8596 tree_859 tree_8596 0.8192
Cp_8596 tree_8596 0 2.592e-15
Rtr_859_8597 tree_859 tree_8597 0.8192
Cp_8597 tree_8597 0 2.592e-15
Rtr_859_8598 tree_859 tree_8598 0.8192
Cp_8598 tree_8598 0 2.592e-15
Rtr_859_8599 tree_859 tree_8599 0.8192
Cp_8599 tree_8599 0 2.592e-15
Rtr_859_8600 tree_859 tree_8600 0.8192
Cp_8600 tree_8600 0 2.592e-15
Rtr_860_8601 tree_860 tree_8601 0.8192
Cp_8601 tree_8601 0 2.592e-15
Rtr_860_8602 tree_860 tree_8602 0.8192
Cp_8602 tree_8602 0 2.592e-15
Rtr_860_8603 tree_860 tree_8603 0.8192
Cp_8603 tree_8603 0 2.592e-15
Rtr_860_8604 tree_860 tree_8604 0.8192
Cp_8604 tree_8604 0 2.592e-15
Rtr_860_8605 tree_860 tree_8605 0.8192
Cp_8605 tree_8605 0 2.592e-15
Rtr_860_8606 tree_860 tree_8606 0.8192
Cp_8606 tree_8606 0 2.592e-15
Rtr_860_8607 tree_860 tree_8607 0.8192
Cp_8607 tree_8607 0 2.592e-15
Rtr_860_8608 tree_860 tree_8608 0.8192
Cp_8608 tree_8608 0 2.592e-15
Rtr_860_8609 tree_860 tree_8609 0.8192
Cp_8609 tree_8609 0 2.592e-15
Rtr_860_8610 tree_860 tree_8610 0.8192
Cp_8610 tree_8610 0 2.592e-15
Rtr_861_8611 tree_861 tree_8611 0.8192
Cp_8611 tree_8611 0 2.592e-15
Rtr_861_8612 tree_861 tree_8612 0.8192
Cp_8612 tree_8612 0 2.592e-15
Rtr_861_8613 tree_861 tree_8613 0.8192
Cp_8613 tree_8613 0 2.592e-15
Rtr_861_8614 tree_861 tree_8614 0.8192
Cp_8614 tree_8614 0 2.592e-15
Rtr_861_8615 tree_861 tree_8615 0.8192
Cp_8615 tree_8615 0 2.592e-15
Rtr_861_8616 tree_861 tree_8616 0.8192
Cp_8616 tree_8616 0 2.592e-15
Rtr_861_8617 tree_861 tree_8617 0.8192
Cp_8617 tree_8617 0 2.592e-15
Rtr_861_8618 tree_861 tree_8618 0.8192
Cp_8618 tree_8618 0 2.592e-15
Rtr_861_8619 tree_861 tree_8619 0.8192
Cp_8619 tree_8619 0 2.592e-15
Rtr_861_8620 tree_861 tree_8620 0.8192
Cp_8620 tree_8620 0 2.592e-15
Rtr_862_8621 tree_862 tree_8621 0.8192
Cp_8621 tree_8621 0 2.592e-15
Rtr_862_8622 tree_862 tree_8622 0.8192
Cp_8622 tree_8622 0 2.592e-15
Rtr_862_8623 tree_862 tree_8623 0.8192
Cp_8623 tree_8623 0 2.592e-15
Rtr_862_8624 tree_862 tree_8624 0.8192
Cp_8624 tree_8624 0 2.592e-15
Rtr_862_8625 tree_862 tree_8625 0.8192
Cp_8625 tree_8625 0 2.592e-15
Rtr_862_8626 tree_862 tree_8626 0.8192
Cp_8626 tree_8626 0 2.592e-15
Rtr_862_8627 tree_862 tree_8627 0.8192
Cp_8627 tree_8627 0 2.592e-15
Rtr_862_8628 tree_862 tree_8628 0.8192
Cp_8628 tree_8628 0 2.592e-15
Rtr_862_8629 tree_862 tree_8629 0.8192
Cp_8629 tree_8629 0 2.592e-15
Rtr_862_8630 tree_862 tree_8630 0.8192
Cp_8630 tree_8630 0 2.592e-15
Rtr_863_8631 tree_863 tree_8631 0.8192
Cp_8631 tree_8631 0 2.592e-15
Rtr_863_8632 tree_863 tree_8632 0.8192
Cp_8632 tree_8632 0 2.592e-15
Rtr_863_8633 tree_863 tree_8633 0.8192
Cp_8633 tree_8633 0 2.592e-15
Rtr_863_8634 tree_863 tree_8634 0.8192
Cp_8634 tree_8634 0 2.592e-15
Rtr_863_8635 tree_863 tree_8635 0.8192
Cp_8635 tree_8635 0 2.592e-15
Rtr_863_8636 tree_863 tree_8636 0.8192
Cp_8636 tree_8636 0 2.592e-15
Rtr_863_8637 tree_863 tree_8637 0.8192
Cp_8637 tree_8637 0 2.592e-15
Rtr_863_8638 tree_863 tree_8638 0.8192
Cp_8638 tree_8638 0 2.592e-15
Rtr_863_8639 tree_863 tree_8639 0.8192
Cp_8639 tree_8639 0 2.592e-15
Rtr_863_8640 tree_863 tree_8640 0.8192
Cp_8640 tree_8640 0 2.592e-15
Rtr_864_8641 tree_864 tree_8641 0.8192
Cp_8641 tree_8641 0 2.592e-15
Rtr_864_8642 tree_864 tree_8642 0.8192
Cp_8642 tree_8642 0 2.592e-15
Rtr_864_8643 tree_864 tree_8643 0.8192
Cp_8643 tree_8643 0 2.592e-15
Rtr_864_8644 tree_864 tree_8644 0.8192
Cp_8644 tree_8644 0 2.592e-15
Rtr_864_8645 tree_864 tree_8645 0.8192
Cp_8645 tree_8645 0 2.592e-15
Rtr_864_8646 tree_864 tree_8646 0.8192
Cp_8646 tree_8646 0 2.592e-15
Rtr_864_8647 tree_864 tree_8647 0.8192
Cp_8647 tree_8647 0 2.592e-15
Rtr_864_8648 tree_864 tree_8648 0.8192
Cp_8648 tree_8648 0 2.592e-15
Rtr_864_8649 tree_864 tree_8649 0.8192
Cp_8649 tree_8649 0 2.592e-15
Rtr_864_8650 tree_864 tree_8650 0.8192
Cp_8650 tree_8650 0 2.592e-15
Rtr_865_8651 tree_865 tree_8651 0.8192
Cp_8651 tree_8651 0 2.592e-15
Rtr_865_8652 tree_865 tree_8652 0.8192
Cp_8652 tree_8652 0 2.592e-15
Rtr_865_8653 tree_865 tree_8653 0.8192
Cp_8653 tree_8653 0 2.592e-15
Rtr_865_8654 tree_865 tree_8654 0.8192
Cp_8654 tree_8654 0 2.592e-15
Rtr_865_8655 tree_865 tree_8655 0.8192
Cp_8655 tree_8655 0 2.592e-15
Rtr_865_8656 tree_865 tree_8656 0.8192
Cp_8656 tree_8656 0 2.592e-15
Rtr_865_8657 tree_865 tree_8657 0.8192
Cp_8657 tree_8657 0 2.592e-15
Rtr_865_8658 tree_865 tree_8658 0.8192
Cp_8658 tree_8658 0 2.592e-15
Rtr_865_8659 tree_865 tree_8659 0.8192
Cp_8659 tree_8659 0 2.592e-15
Rtr_865_8660 tree_865 tree_8660 0.8192
Cp_8660 tree_8660 0 2.592e-15
Rtr_866_8661 tree_866 tree_8661 0.8192
Cp_8661 tree_8661 0 2.592e-15
Rtr_866_8662 tree_866 tree_8662 0.8192
Cp_8662 tree_8662 0 2.592e-15
Rtr_866_8663 tree_866 tree_8663 0.8192
Cp_8663 tree_8663 0 2.592e-15
Rtr_866_8664 tree_866 tree_8664 0.8192
Cp_8664 tree_8664 0 2.592e-15
Rtr_866_8665 tree_866 tree_8665 0.8192
Cp_8665 tree_8665 0 2.592e-15
Rtr_866_8666 tree_866 tree_8666 0.8192
Cp_8666 tree_8666 0 2.592e-15
Rtr_866_8667 tree_866 tree_8667 0.8192
Cp_8667 tree_8667 0 2.592e-15
Rtr_866_8668 tree_866 tree_8668 0.8192
Cp_8668 tree_8668 0 2.592e-15
Rtr_866_8669 tree_866 tree_8669 0.8192
Cp_8669 tree_8669 0 2.592e-15
Rtr_866_8670 tree_866 tree_8670 0.8192
Cp_8670 tree_8670 0 2.592e-15
Rtr_867_8671 tree_867 tree_8671 0.8192
Cp_8671 tree_8671 0 2.592e-15
Rtr_867_8672 tree_867 tree_8672 0.8192
Cp_8672 tree_8672 0 2.592e-15
Rtr_867_8673 tree_867 tree_8673 0.8192
Cp_8673 tree_8673 0 2.592e-15
Rtr_867_8674 tree_867 tree_8674 0.8192
Cp_8674 tree_8674 0 2.592e-15
Rtr_867_8675 tree_867 tree_8675 0.8192
Cp_8675 tree_8675 0 2.592e-15
Rtr_867_8676 tree_867 tree_8676 0.8192
Cp_8676 tree_8676 0 2.592e-15
Rtr_867_8677 tree_867 tree_8677 0.8192
Cp_8677 tree_8677 0 2.592e-15
Rtr_867_8678 tree_867 tree_8678 0.8192
Cp_8678 tree_8678 0 2.592e-15
Rtr_867_8679 tree_867 tree_8679 0.8192
Cp_8679 tree_8679 0 2.592e-15
Rtr_867_8680 tree_867 tree_8680 0.8192
Cp_8680 tree_8680 0 2.592e-15
Rtr_868_8681 tree_868 tree_8681 0.8192
Cp_8681 tree_8681 0 2.592e-15
Rtr_868_8682 tree_868 tree_8682 0.8192
Cp_8682 tree_8682 0 2.592e-15
Rtr_868_8683 tree_868 tree_8683 0.8192
Cp_8683 tree_8683 0 2.592e-15
Rtr_868_8684 tree_868 tree_8684 0.8192
Cp_8684 tree_8684 0 2.592e-15
Rtr_868_8685 tree_868 tree_8685 0.8192
Cp_8685 tree_8685 0 2.592e-15
Rtr_868_8686 tree_868 tree_8686 0.8192
Cp_8686 tree_8686 0 2.592e-15
Rtr_868_8687 tree_868 tree_8687 0.8192
Cp_8687 tree_8687 0 2.592e-15
Rtr_868_8688 tree_868 tree_8688 0.8192
Cp_8688 tree_8688 0 2.592e-15
Rtr_868_8689 tree_868 tree_8689 0.8192
Cp_8689 tree_8689 0 2.592e-15
Rtr_868_8690 tree_868 tree_8690 0.8192
Cp_8690 tree_8690 0 2.592e-15
Rtr_869_8691 tree_869 tree_8691 0.8192
Cp_8691 tree_8691 0 2.592e-15
Rtr_869_8692 tree_869 tree_8692 0.8192
Cp_8692 tree_8692 0 2.592e-15
Rtr_869_8693 tree_869 tree_8693 0.8192
Cp_8693 tree_8693 0 2.592e-15
Rtr_869_8694 tree_869 tree_8694 0.8192
Cp_8694 tree_8694 0 2.592e-15
Rtr_869_8695 tree_869 tree_8695 0.8192
Cp_8695 tree_8695 0 2.592e-15
Rtr_869_8696 tree_869 tree_8696 0.8192
Cp_8696 tree_8696 0 2.592e-15
Rtr_869_8697 tree_869 tree_8697 0.8192
Cp_8697 tree_8697 0 2.592e-15
Rtr_869_8698 tree_869 tree_8698 0.8192
Cp_8698 tree_8698 0 2.592e-15
Rtr_869_8699 tree_869 tree_8699 0.8192
Cp_8699 tree_8699 0 2.592e-15
Rtr_869_8700 tree_869 tree_8700 0.8192
Cp_8700 tree_8700 0 2.592e-15
Rtr_870_8701 tree_870 tree_8701 0.8192
Cp_8701 tree_8701 0 2.592e-15
Rtr_870_8702 tree_870 tree_8702 0.8192
Cp_8702 tree_8702 0 2.592e-15
Rtr_870_8703 tree_870 tree_8703 0.8192
Cp_8703 tree_8703 0 2.592e-15
Rtr_870_8704 tree_870 tree_8704 0.8192
Cp_8704 tree_8704 0 2.592e-15
Rtr_870_8705 tree_870 tree_8705 0.8192
Cp_8705 tree_8705 0 2.592e-15
Rtr_870_8706 tree_870 tree_8706 0.8192
Cp_8706 tree_8706 0 2.592e-15
Rtr_870_8707 tree_870 tree_8707 0.8192
Cp_8707 tree_8707 0 2.592e-15
Rtr_870_8708 tree_870 tree_8708 0.8192
Cp_8708 tree_8708 0 2.592e-15
Rtr_870_8709 tree_870 tree_8709 0.8192
Cp_8709 tree_8709 0 2.592e-15
Rtr_870_8710 tree_870 tree_8710 0.8192
Cp_8710 tree_8710 0 2.592e-15
Rtr_871_8711 tree_871 tree_8711 0.8192
Cp_8711 tree_8711 0 2.592e-15
Rtr_871_8712 tree_871 tree_8712 0.8192
Cp_8712 tree_8712 0 2.592e-15
Rtr_871_8713 tree_871 tree_8713 0.8192
Cp_8713 tree_8713 0 2.592e-15
Rtr_871_8714 tree_871 tree_8714 0.8192
Cp_8714 tree_8714 0 2.592e-15
Rtr_871_8715 tree_871 tree_8715 0.8192
Cp_8715 tree_8715 0 2.592e-15
Rtr_871_8716 tree_871 tree_8716 0.8192
Cp_8716 tree_8716 0 2.592e-15
Rtr_871_8717 tree_871 tree_8717 0.8192
Cp_8717 tree_8717 0 2.592e-15
Rtr_871_8718 tree_871 tree_8718 0.8192
Cp_8718 tree_8718 0 2.592e-15
Rtr_871_8719 tree_871 tree_8719 0.8192
Cp_8719 tree_8719 0 2.592e-15
Rtr_871_8720 tree_871 tree_8720 0.8192
Cp_8720 tree_8720 0 2.592e-15
Rtr_872_8721 tree_872 tree_8721 0.8192
Cp_8721 tree_8721 0 2.592e-15
Rtr_872_8722 tree_872 tree_8722 0.8192
Cp_8722 tree_8722 0 2.592e-15
Rtr_872_8723 tree_872 tree_8723 0.8192
Cp_8723 tree_8723 0 2.592e-15
Rtr_872_8724 tree_872 tree_8724 0.8192
Cp_8724 tree_8724 0 2.592e-15
Rtr_872_8725 tree_872 tree_8725 0.8192
Cp_8725 tree_8725 0 2.592e-15
Rtr_872_8726 tree_872 tree_8726 0.8192
Cp_8726 tree_8726 0 2.592e-15
Rtr_872_8727 tree_872 tree_8727 0.8192
Cp_8727 tree_8727 0 2.592e-15
Rtr_872_8728 tree_872 tree_8728 0.8192
Cp_8728 tree_8728 0 2.592e-15
Rtr_872_8729 tree_872 tree_8729 0.8192
Cp_8729 tree_8729 0 2.592e-15
Rtr_872_8730 tree_872 tree_8730 0.8192
Cp_8730 tree_8730 0 2.592e-15
Rtr_873_8731 tree_873 tree_8731 0.8192
Cp_8731 tree_8731 0 2.592e-15
Rtr_873_8732 tree_873 tree_8732 0.8192
Cp_8732 tree_8732 0 2.592e-15
Rtr_873_8733 tree_873 tree_8733 0.8192
Cp_8733 tree_8733 0 2.592e-15
Rtr_873_8734 tree_873 tree_8734 0.8192
Cp_8734 tree_8734 0 2.592e-15
Rtr_873_8735 tree_873 tree_8735 0.8192
Cp_8735 tree_8735 0 2.592e-15
Rtr_873_8736 tree_873 tree_8736 0.8192
Cp_8736 tree_8736 0 2.592e-15
Rtr_873_8737 tree_873 tree_8737 0.8192
Cp_8737 tree_8737 0 2.592e-15
Rtr_873_8738 tree_873 tree_8738 0.8192
Cp_8738 tree_8738 0 2.592e-15
Rtr_873_8739 tree_873 tree_8739 0.8192
Cp_8739 tree_8739 0 2.592e-15
Rtr_873_8740 tree_873 tree_8740 0.8192
Cp_8740 tree_8740 0 2.592e-15
Rtr_874_8741 tree_874 tree_8741 0.8192
Cp_8741 tree_8741 0 2.592e-15
Rtr_874_8742 tree_874 tree_8742 0.8192
Cp_8742 tree_8742 0 2.592e-15
Rtr_874_8743 tree_874 tree_8743 0.8192
Cp_8743 tree_8743 0 2.592e-15
Rtr_874_8744 tree_874 tree_8744 0.8192
Cp_8744 tree_8744 0 2.592e-15
Rtr_874_8745 tree_874 tree_8745 0.8192
Cp_8745 tree_8745 0 2.592e-15
Rtr_874_8746 tree_874 tree_8746 0.8192
Cp_8746 tree_8746 0 2.592e-15
Rtr_874_8747 tree_874 tree_8747 0.8192
Cp_8747 tree_8747 0 2.592e-15
Rtr_874_8748 tree_874 tree_8748 0.8192
Cp_8748 tree_8748 0 2.592e-15
Rtr_874_8749 tree_874 tree_8749 0.8192
Cp_8749 tree_8749 0 2.592e-15
Rtr_874_8750 tree_874 tree_8750 0.8192
Cp_8750 tree_8750 0 2.592e-15
Rtr_875_8751 tree_875 tree_8751 0.8192
Cp_8751 tree_8751 0 2.592e-15
Rtr_875_8752 tree_875 tree_8752 0.8192
Cp_8752 tree_8752 0 2.592e-15
Rtr_875_8753 tree_875 tree_8753 0.8192
Cp_8753 tree_8753 0 2.592e-15
Rtr_875_8754 tree_875 tree_8754 0.8192
Cp_8754 tree_8754 0 2.592e-15
Rtr_875_8755 tree_875 tree_8755 0.8192
Cp_8755 tree_8755 0 2.592e-15
Rtr_875_8756 tree_875 tree_8756 0.8192
Cp_8756 tree_8756 0 2.592e-15
Rtr_875_8757 tree_875 tree_8757 0.8192
Cp_8757 tree_8757 0 2.592e-15
Rtr_875_8758 tree_875 tree_8758 0.8192
Cp_8758 tree_8758 0 2.592e-15
Rtr_875_8759 tree_875 tree_8759 0.8192
Cp_8759 tree_8759 0 2.592e-15
Rtr_875_8760 tree_875 tree_8760 0.8192
Cp_8760 tree_8760 0 2.592e-15
Rtr_876_8761 tree_876 tree_8761 0.8192
Cp_8761 tree_8761 0 2.592e-15
Rtr_876_8762 tree_876 tree_8762 0.8192
Cp_8762 tree_8762 0 2.592e-15
Rtr_876_8763 tree_876 tree_8763 0.8192
Cp_8763 tree_8763 0 2.592e-15
Rtr_876_8764 tree_876 tree_8764 0.8192
Cp_8764 tree_8764 0 2.592e-15
Rtr_876_8765 tree_876 tree_8765 0.8192
Cp_8765 tree_8765 0 2.592e-15
Rtr_876_8766 tree_876 tree_8766 0.8192
Cp_8766 tree_8766 0 2.592e-15
Rtr_876_8767 tree_876 tree_8767 0.8192
Cp_8767 tree_8767 0 2.592e-15
Rtr_876_8768 tree_876 tree_8768 0.8192
Cp_8768 tree_8768 0 2.592e-15
Rtr_876_8769 tree_876 tree_8769 0.8192
Cp_8769 tree_8769 0 2.592e-15
Rtr_876_8770 tree_876 tree_8770 0.8192
Cp_8770 tree_8770 0 2.592e-15
Rtr_877_8771 tree_877 tree_8771 0.8192
Cp_8771 tree_8771 0 2.592e-15
Rtr_877_8772 tree_877 tree_8772 0.8192
Cp_8772 tree_8772 0 2.592e-15
Rtr_877_8773 tree_877 tree_8773 0.8192
Cp_8773 tree_8773 0 2.592e-15
Rtr_877_8774 tree_877 tree_8774 0.8192
Cp_8774 tree_8774 0 2.592e-15
Rtr_877_8775 tree_877 tree_8775 0.8192
Cp_8775 tree_8775 0 2.592e-15
Rtr_877_8776 tree_877 tree_8776 0.8192
Cp_8776 tree_8776 0 2.592e-15
Rtr_877_8777 tree_877 tree_8777 0.8192
Cp_8777 tree_8777 0 2.592e-15
Rtr_877_8778 tree_877 tree_8778 0.8192
Cp_8778 tree_8778 0 2.592e-15
Rtr_877_8779 tree_877 tree_8779 0.8192
Cp_8779 tree_8779 0 2.592e-15
Rtr_877_8780 tree_877 tree_8780 0.8192
Cp_8780 tree_8780 0 2.592e-15
Rtr_878_8781 tree_878 tree_8781 0.8192
Cp_8781 tree_8781 0 2.592e-15
Rtr_878_8782 tree_878 tree_8782 0.8192
Cp_8782 tree_8782 0 2.592e-15
Rtr_878_8783 tree_878 tree_8783 0.8192
Cp_8783 tree_8783 0 2.592e-15
Rtr_878_8784 tree_878 tree_8784 0.8192
Cp_8784 tree_8784 0 2.592e-15
Rtr_878_8785 tree_878 tree_8785 0.8192
Cp_8785 tree_8785 0 2.592e-15
Rtr_878_8786 tree_878 tree_8786 0.8192
Cp_8786 tree_8786 0 2.592e-15
Rtr_878_8787 tree_878 tree_8787 0.8192
Cp_8787 tree_8787 0 2.592e-15
Rtr_878_8788 tree_878 tree_8788 0.8192
Cp_8788 tree_8788 0 2.592e-15
Rtr_878_8789 tree_878 tree_8789 0.8192
Cp_8789 tree_8789 0 2.592e-15
Rtr_878_8790 tree_878 tree_8790 0.8192
Cp_8790 tree_8790 0 2.592e-15
Rtr_879_8791 tree_879 tree_8791 0.8192
Cp_8791 tree_8791 0 2.592e-15
Rtr_879_8792 tree_879 tree_8792 0.8192
Cp_8792 tree_8792 0 2.592e-15
Rtr_879_8793 tree_879 tree_8793 0.8192
Cp_8793 tree_8793 0 2.592e-15
Rtr_879_8794 tree_879 tree_8794 0.8192
Cp_8794 tree_8794 0 2.592e-15
Rtr_879_8795 tree_879 tree_8795 0.8192
Cp_8795 tree_8795 0 2.592e-15
Rtr_879_8796 tree_879 tree_8796 0.8192
Cp_8796 tree_8796 0 2.592e-15
Rtr_879_8797 tree_879 tree_8797 0.8192
Cp_8797 tree_8797 0 2.592e-15
Rtr_879_8798 tree_879 tree_8798 0.8192
Cp_8798 tree_8798 0 2.592e-15
Rtr_879_8799 tree_879 tree_8799 0.8192
Cp_8799 tree_8799 0 2.592e-15
Rtr_879_8800 tree_879 tree_8800 0.8192
Cp_8800 tree_8800 0 2.592e-15
Rtr_880_8801 tree_880 tree_8801 0.8192
Cp_8801 tree_8801 0 2.592e-15
Rtr_880_8802 tree_880 tree_8802 0.8192
Cp_8802 tree_8802 0 2.592e-15
Rtr_880_8803 tree_880 tree_8803 0.8192
Cp_8803 tree_8803 0 2.592e-15
Rtr_880_8804 tree_880 tree_8804 0.8192
Cp_8804 tree_8804 0 2.592e-15
Rtr_880_8805 tree_880 tree_8805 0.8192
Cp_8805 tree_8805 0 2.592e-15
Rtr_880_8806 tree_880 tree_8806 0.8192
Cp_8806 tree_8806 0 2.592e-15
Rtr_880_8807 tree_880 tree_8807 0.8192
Cp_8807 tree_8807 0 2.592e-15
Rtr_880_8808 tree_880 tree_8808 0.8192
Cp_8808 tree_8808 0 2.592e-15
Rtr_880_8809 tree_880 tree_8809 0.8192
Cp_8809 tree_8809 0 2.592e-15
Rtr_880_8810 tree_880 tree_8810 0.8192
Cp_8810 tree_8810 0 2.592e-15
Rtr_881_8811 tree_881 tree_8811 0.8192
Cp_8811 tree_8811 0 2.592e-15
Rtr_881_8812 tree_881 tree_8812 0.8192
Cp_8812 tree_8812 0 2.592e-15
Rtr_881_8813 tree_881 tree_8813 0.8192
Cp_8813 tree_8813 0 2.592e-15
Rtr_881_8814 tree_881 tree_8814 0.8192
Cp_8814 tree_8814 0 2.592e-15
Rtr_881_8815 tree_881 tree_8815 0.8192
Cp_8815 tree_8815 0 2.592e-15
Rtr_881_8816 tree_881 tree_8816 0.8192
Cp_8816 tree_8816 0 2.592e-15
Rtr_881_8817 tree_881 tree_8817 0.8192
Cp_8817 tree_8817 0 2.592e-15
Rtr_881_8818 tree_881 tree_8818 0.8192
Cp_8818 tree_8818 0 2.592e-15
Rtr_881_8819 tree_881 tree_8819 0.8192
Cp_8819 tree_8819 0 2.592e-15
Rtr_881_8820 tree_881 tree_8820 0.8192
Cp_8820 tree_8820 0 2.592e-15
Rtr_882_8821 tree_882 tree_8821 0.8192
Cp_8821 tree_8821 0 2.592e-15
Rtr_882_8822 tree_882 tree_8822 0.8192
Cp_8822 tree_8822 0 2.592e-15
Rtr_882_8823 tree_882 tree_8823 0.8192
Cp_8823 tree_8823 0 2.592e-15
Rtr_882_8824 tree_882 tree_8824 0.8192
Cp_8824 tree_8824 0 2.592e-15
Rtr_882_8825 tree_882 tree_8825 0.8192
Cp_8825 tree_8825 0 2.592e-15
Rtr_882_8826 tree_882 tree_8826 0.8192
Cp_8826 tree_8826 0 2.592e-15
Rtr_882_8827 tree_882 tree_8827 0.8192
Cp_8827 tree_8827 0 2.592e-15
Rtr_882_8828 tree_882 tree_8828 0.8192
Cp_8828 tree_8828 0 2.592e-15
Rtr_882_8829 tree_882 tree_8829 0.8192
Cp_8829 tree_8829 0 2.592e-15
Rtr_882_8830 tree_882 tree_8830 0.8192
Cp_8830 tree_8830 0 2.592e-15
Rtr_883_8831 tree_883 tree_8831 0.8192
Cp_8831 tree_8831 0 2.592e-15
Rtr_883_8832 tree_883 tree_8832 0.8192
Cp_8832 tree_8832 0 2.592e-15
Rtr_883_8833 tree_883 tree_8833 0.8192
Cp_8833 tree_8833 0 2.592e-15
Rtr_883_8834 tree_883 tree_8834 0.8192
Cp_8834 tree_8834 0 2.592e-15
Rtr_883_8835 tree_883 tree_8835 0.8192
Cp_8835 tree_8835 0 2.592e-15
Rtr_883_8836 tree_883 tree_8836 0.8192
Cp_8836 tree_8836 0 2.592e-15
Rtr_883_8837 tree_883 tree_8837 0.8192
Cp_8837 tree_8837 0 2.592e-15
Rtr_883_8838 tree_883 tree_8838 0.8192
Cp_8838 tree_8838 0 2.592e-15
Rtr_883_8839 tree_883 tree_8839 0.8192
Cp_8839 tree_8839 0 2.592e-15
Rtr_883_8840 tree_883 tree_8840 0.8192
Cp_8840 tree_8840 0 2.592e-15
Rtr_884_8841 tree_884 tree_8841 0.8192
Cp_8841 tree_8841 0 2.592e-15
Rtr_884_8842 tree_884 tree_8842 0.8192
Cp_8842 tree_8842 0 2.592e-15
Rtr_884_8843 tree_884 tree_8843 0.8192
Cp_8843 tree_8843 0 2.592e-15
Rtr_884_8844 tree_884 tree_8844 0.8192
Cp_8844 tree_8844 0 2.592e-15
Rtr_884_8845 tree_884 tree_8845 0.8192
Cp_8845 tree_8845 0 2.592e-15
Rtr_884_8846 tree_884 tree_8846 0.8192
Cp_8846 tree_8846 0 2.592e-15
Rtr_884_8847 tree_884 tree_8847 0.8192
Cp_8847 tree_8847 0 2.592e-15
Rtr_884_8848 tree_884 tree_8848 0.8192
Cp_8848 tree_8848 0 2.592e-15
Rtr_884_8849 tree_884 tree_8849 0.8192
Cp_8849 tree_8849 0 2.592e-15
Rtr_884_8850 tree_884 tree_8850 0.8192
Cp_8850 tree_8850 0 2.592e-15
Rtr_885_8851 tree_885 tree_8851 0.8192
Cp_8851 tree_8851 0 2.592e-15
Rtr_885_8852 tree_885 tree_8852 0.8192
Cp_8852 tree_8852 0 2.592e-15
Rtr_885_8853 tree_885 tree_8853 0.8192
Cp_8853 tree_8853 0 2.592e-15
Rtr_885_8854 tree_885 tree_8854 0.8192
Cp_8854 tree_8854 0 2.592e-15
Rtr_885_8855 tree_885 tree_8855 0.8192
Cp_8855 tree_8855 0 2.592e-15
Rtr_885_8856 tree_885 tree_8856 0.8192
Cp_8856 tree_8856 0 2.592e-15
Rtr_885_8857 tree_885 tree_8857 0.8192
Cp_8857 tree_8857 0 2.592e-15
Rtr_885_8858 tree_885 tree_8858 0.8192
Cp_8858 tree_8858 0 2.592e-15
Rtr_885_8859 tree_885 tree_8859 0.8192
Cp_8859 tree_8859 0 2.592e-15
Rtr_885_8860 tree_885 tree_8860 0.8192
Cp_8860 tree_8860 0 2.592e-15
Rtr_886_8861 tree_886 tree_8861 0.8192
Cp_8861 tree_8861 0 2.592e-15
Rtr_886_8862 tree_886 tree_8862 0.8192
Cp_8862 tree_8862 0 2.592e-15
Rtr_886_8863 tree_886 tree_8863 0.8192
Cp_8863 tree_8863 0 2.592e-15
Rtr_886_8864 tree_886 tree_8864 0.8192
Cp_8864 tree_8864 0 2.592e-15
Rtr_886_8865 tree_886 tree_8865 0.8192
Cp_8865 tree_8865 0 2.592e-15
Rtr_886_8866 tree_886 tree_8866 0.8192
Cp_8866 tree_8866 0 2.592e-15
Rtr_886_8867 tree_886 tree_8867 0.8192
Cp_8867 tree_8867 0 2.592e-15
Rtr_886_8868 tree_886 tree_8868 0.8192
Cp_8868 tree_8868 0 2.592e-15
Rtr_886_8869 tree_886 tree_8869 0.8192
Cp_8869 tree_8869 0 2.592e-15
Rtr_886_8870 tree_886 tree_8870 0.8192
Cp_8870 tree_8870 0 2.592e-15
Rtr_887_8871 tree_887 tree_8871 0.8192
Cp_8871 tree_8871 0 2.592e-15
Rtr_887_8872 tree_887 tree_8872 0.8192
Cp_8872 tree_8872 0 2.592e-15
Rtr_887_8873 tree_887 tree_8873 0.8192
Cp_8873 tree_8873 0 2.592e-15
Rtr_887_8874 tree_887 tree_8874 0.8192
Cp_8874 tree_8874 0 2.592e-15
Rtr_887_8875 tree_887 tree_8875 0.8192
Cp_8875 tree_8875 0 2.592e-15
Rtr_887_8876 tree_887 tree_8876 0.8192
Cp_8876 tree_8876 0 2.592e-15
Rtr_887_8877 tree_887 tree_8877 0.8192
Cp_8877 tree_8877 0 2.592e-15
Rtr_887_8878 tree_887 tree_8878 0.8192
Cp_8878 tree_8878 0 2.592e-15
Rtr_887_8879 tree_887 tree_8879 0.8192
Cp_8879 tree_8879 0 2.592e-15
Rtr_887_8880 tree_887 tree_8880 0.8192
Cp_8880 tree_8880 0 2.592e-15
Rtr_888_8881 tree_888 tree_8881 0.8192
Cp_8881 tree_8881 0 2.592e-15
Rtr_888_8882 tree_888 tree_8882 0.8192
Cp_8882 tree_8882 0 2.592e-15
Rtr_888_8883 tree_888 tree_8883 0.8192
Cp_8883 tree_8883 0 2.592e-15
Rtr_888_8884 tree_888 tree_8884 0.8192
Cp_8884 tree_8884 0 2.592e-15
Rtr_888_8885 tree_888 tree_8885 0.8192
Cp_8885 tree_8885 0 2.592e-15
Rtr_888_8886 tree_888 tree_8886 0.8192
Cp_8886 tree_8886 0 2.592e-15
Rtr_888_8887 tree_888 tree_8887 0.8192
Cp_8887 tree_8887 0 2.592e-15
Rtr_888_8888 tree_888 tree_8888 0.8192
Cp_8888 tree_8888 0 2.592e-15
Rtr_888_8889 tree_888 tree_8889 0.8192
Cp_8889 tree_8889 0 2.592e-15
Rtr_888_8890 tree_888 tree_8890 0.8192
Cp_8890 tree_8890 0 2.592e-15
Rtr_889_8891 tree_889 tree_8891 0.8192
Cp_8891 tree_8891 0 2.592e-15
Rtr_889_8892 tree_889 tree_8892 0.8192
Cp_8892 tree_8892 0 2.592e-15
Rtr_889_8893 tree_889 tree_8893 0.8192
Cp_8893 tree_8893 0 2.592e-15
Rtr_889_8894 tree_889 tree_8894 0.8192
Cp_8894 tree_8894 0 2.592e-15
Rtr_889_8895 tree_889 tree_8895 0.8192
Cp_8895 tree_8895 0 2.592e-15
Rtr_889_8896 tree_889 tree_8896 0.8192
Cp_8896 tree_8896 0 2.592e-15
Rtr_889_8897 tree_889 tree_8897 0.8192
Cp_8897 tree_8897 0 2.592e-15
Rtr_889_8898 tree_889 tree_8898 0.8192
Cp_8898 tree_8898 0 2.592e-15
Rtr_889_8899 tree_889 tree_8899 0.8192
Cp_8899 tree_8899 0 2.592e-15
Rtr_889_8900 tree_889 tree_8900 0.8192
Cp_8900 tree_8900 0 2.592e-15
Rtr_890_8901 tree_890 tree_8901 0.8192
Cp_8901 tree_8901 0 2.592e-15
Rtr_890_8902 tree_890 tree_8902 0.8192
Cp_8902 tree_8902 0 2.592e-15
Rtr_890_8903 tree_890 tree_8903 0.8192
Cp_8903 tree_8903 0 2.592e-15
Rtr_890_8904 tree_890 tree_8904 0.8192
Cp_8904 tree_8904 0 2.592e-15
Rtr_890_8905 tree_890 tree_8905 0.8192
Cp_8905 tree_8905 0 2.592e-15
Rtr_890_8906 tree_890 tree_8906 0.8192
Cp_8906 tree_8906 0 2.592e-15
Rtr_890_8907 tree_890 tree_8907 0.8192
Cp_8907 tree_8907 0 2.592e-15
Rtr_890_8908 tree_890 tree_8908 0.8192
Cp_8908 tree_8908 0 2.592e-15
Rtr_890_8909 tree_890 tree_8909 0.8192
Cp_8909 tree_8909 0 2.592e-15
Rtr_890_8910 tree_890 tree_8910 0.8192
Cp_8910 tree_8910 0 2.592e-15
Rtr_891_8911 tree_891 tree_8911 0.8192
Cp_8911 tree_8911 0 2.592e-15
Rtr_891_8912 tree_891 tree_8912 0.8192
Cp_8912 tree_8912 0 2.592e-15
Rtr_891_8913 tree_891 tree_8913 0.8192
Cp_8913 tree_8913 0 2.592e-15
Rtr_891_8914 tree_891 tree_8914 0.8192
Cp_8914 tree_8914 0 2.592e-15
Rtr_891_8915 tree_891 tree_8915 0.8192
Cp_8915 tree_8915 0 2.592e-15
Rtr_891_8916 tree_891 tree_8916 0.8192
Cp_8916 tree_8916 0 2.592e-15
Rtr_891_8917 tree_891 tree_8917 0.8192
Cp_8917 tree_8917 0 2.592e-15
Rtr_891_8918 tree_891 tree_8918 0.8192
Cp_8918 tree_8918 0 2.592e-15
Rtr_891_8919 tree_891 tree_8919 0.8192
Cp_8919 tree_8919 0 2.592e-15
Rtr_891_8920 tree_891 tree_8920 0.8192
Cp_8920 tree_8920 0 2.592e-15
Rtr_892_8921 tree_892 tree_8921 0.8192
Cp_8921 tree_8921 0 2.592e-15
Rtr_892_8922 tree_892 tree_8922 0.8192
Cp_8922 tree_8922 0 2.592e-15
Rtr_892_8923 tree_892 tree_8923 0.8192
Cp_8923 tree_8923 0 2.592e-15
Rtr_892_8924 tree_892 tree_8924 0.8192
Cp_8924 tree_8924 0 2.592e-15
Rtr_892_8925 tree_892 tree_8925 0.8192
Cp_8925 tree_8925 0 2.592e-15
Rtr_892_8926 tree_892 tree_8926 0.8192
Cp_8926 tree_8926 0 2.592e-15
Rtr_892_8927 tree_892 tree_8927 0.8192
Cp_8927 tree_8927 0 2.592e-15
Rtr_892_8928 tree_892 tree_8928 0.8192
Cp_8928 tree_8928 0 2.592e-15
Rtr_892_8929 tree_892 tree_8929 0.8192
Cp_8929 tree_8929 0 2.592e-15
Rtr_892_8930 tree_892 tree_8930 0.8192
Cp_8930 tree_8930 0 2.592e-15
Rtr_893_8931 tree_893 tree_8931 0.8192
Cp_8931 tree_8931 0 2.592e-15
Rtr_893_8932 tree_893 tree_8932 0.8192
Cp_8932 tree_8932 0 2.592e-15
Rtr_893_8933 tree_893 tree_8933 0.8192
Cp_8933 tree_8933 0 2.592e-15
Rtr_893_8934 tree_893 tree_8934 0.8192
Cp_8934 tree_8934 0 2.592e-15
Rtr_893_8935 tree_893 tree_8935 0.8192
Cp_8935 tree_8935 0 2.592e-15
Rtr_893_8936 tree_893 tree_8936 0.8192
Cp_8936 tree_8936 0 2.592e-15
Rtr_893_8937 tree_893 tree_8937 0.8192
Cp_8937 tree_8937 0 2.592e-15
Rtr_893_8938 tree_893 tree_8938 0.8192
Cp_8938 tree_8938 0 2.592e-15
Rtr_893_8939 tree_893 tree_8939 0.8192
Cp_8939 tree_8939 0 2.592e-15
Rtr_893_8940 tree_893 tree_8940 0.8192
Cp_8940 tree_8940 0 2.592e-15
Rtr_894_8941 tree_894 tree_8941 0.8192
Cp_8941 tree_8941 0 2.592e-15
Rtr_894_8942 tree_894 tree_8942 0.8192
Cp_8942 tree_8942 0 2.592e-15
Rtr_894_8943 tree_894 tree_8943 0.8192
Cp_8943 tree_8943 0 2.592e-15
Rtr_894_8944 tree_894 tree_8944 0.8192
Cp_8944 tree_8944 0 2.592e-15
Rtr_894_8945 tree_894 tree_8945 0.8192
Cp_8945 tree_8945 0 2.592e-15
Rtr_894_8946 tree_894 tree_8946 0.8192
Cp_8946 tree_8946 0 2.592e-15
Rtr_894_8947 tree_894 tree_8947 0.8192
Cp_8947 tree_8947 0 2.592e-15
Rtr_894_8948 tree_894 tree_8948 0.8192
Cp_8948 tree_8948 0 2.592e-15
Rtr_894_8949 tree_894 tree_8949 0.8192
Cp_8949 tree_8949 0 2.592e-15
Rtr_894_8950 tree_894 tree_8950 0.8192
Cp_8950 tree_8950 0 2.592e-15
Rtr_895_8951 tree_895 tree_8951 0.8192
Cp_8951 tree_8951 0 2.592e-15
Rtr_895_8952 tree_895 tree_8952 0.8192
Cp_8952 tree_8952 0 2.592e-15
Rtr_895_8953 tree_895 tree_8953 0.8192
Cp_8953 tree_8953 0 2.592e-15
Rtr_895_8954 tree_895 tree_8954 0.8192
Cp_8954 tree_8954 0 2.592e-15
Rtr_895_8955 tree_895 tree_8955 0.8192
Cp_8955 tree_8955 0 2.592e-15
Rtr_895_8956 tree_895 tree_8956 0.8192
Cp_8956 tree_8956 0 2.592e-15
Rtr_895_8957 tree_895 tree_8957 0.8192
Cp_8957 tree_8957 0 2.592e-15
Rtr_895_8958 tree_895 tree_8958 0.8192
Cp_8958 tree_8958 0 2.592e-15
Rtr_895_8959 tree_895 tree_8959 0.8192
Cp_8959 tree_8959 0 2.592e-15
Rtr_895_8960 tree_895 tree_8960 0.8192
Cp_8960 tree_8960 0 2.592e-15
Rtr_896_8961 tree_896 tree_8961 0.8192
Cp_8961 tree_8961 0 2.592e-15
Rtr_896_8962 tree_896 tree_8962 0.8192
Cp_8962 tree_8962 0 2.592e-15
Rtr_896_8963 tree_896 tree_8963 0.8192
Cp_8963 tree_8963 0 2.592e-15
Rtr_896_8964 tree_896 tree_8964 0.8192
Cp_8964 tree_8964 0 2.592e-15
Rtr_896_8965 tree_896 tree_8965 0.8192
Cp_8965 tree_8965 0 2.592e-15
Rtr_896_8966 tree_896 tree_8966 0.8192
Cp_8966 tree_8966 0 2.592e-15
Rtr_896_8967 tree_896 tree_8967 0.8192
Cp_8967 tree_8967 0 2.592e-15
Rtr_896_8968 tree_896 tree_8968 0.8192
Cp_8968 tree_8968 0 2.592e-15
Rtr_896_8969 tree_896 tree_8969 0.8192
Cp_8969 tree_8969 0 2.592e-15
Rtr_896_8970 tree_896 tree_8970 0.8192
Cp_8970 tree_8970 0 2.592e-15
Rtr_897_8971 tree_897 tree_8971 0.8192
Cp_8971 tree_8971 0 2.592e-15
Rtr_897_8972 tree_897 tree_8972 0.8192
Cp_8972 tree_8972 0 2.592e-15
Rtr_897_8973 tree_897 tree_8973 0.8192
Cp_8973 tree_8973 0 2.592e-15
Rtr_897_8974 tree_897 tree_8974 0.8192
Cp_8974 tree_8974 0 2.592e-15
Rtr_897_8975 tree_897 tree_8975 0.8192
Cp_8975 tree_8975 0 2.592e-15
Rtr_897_8976 tree_897 tree_8976 0.8192
Cp_8976 tree_8976 0 2.592e-15
Rtr_897_8977 tree_897 tree_8977 0.8192
Cp_8977 tree_8977 0 2.592e-15
Rtr_897_8978 tree_897 tree_8978 0.8192
Cp_8978 tree_8978 0 2.592e-15
Rtr_897_8979 tree_897 tree_8979 0.8192
Cp_8979 tree_8979 0 2.592e-15
Rtr_897_8980 tree_897 tree_8980 0.8192
Cp_8980 tree_8980 0 2.592e-15
Rtr_898_8981 tree_898 tree_8981 0.8192
Cp_8981 tree_8981 0 2.592e-15
Rtr_898_8982 tree_898 tree_8982 0.8192
Cp_8982 tree_8982 0 2.592e-15
Rtr_898_8983 tree_898 tree_8983 0.8192
Cp_8983 tree_8983 0 2.592e-15
Rtr_898_8984 tree_898 tree_8984 0.8192
Cp_8984 tree_8984 0 2.592e-15
Rtr_898_8985 tree_898 tree_8985 0.8192
Cp_8985 tree_8985 0 2.592e-15
Rtr_898_8986 tree_898 tree_8986 0.8192
Cp_8986 tree_8986 0 2.592e-15
Rtr_898_8987 tree_898 tree_8987 0.8192
Cp_8987 tree_8987 0 2.592e-15
Rtr_898_8988 tree_898 tree_8988 0.8192
Cp_8988 tree_8988 0 2.592e-15
Rtr_898_8989 tree_898 tree_8989 0.8192
Cp_8989 tree_8989 0 2.592e-15
Rtr_898_8990 tree_898 tree_8990 0.8192
Cp_8990 tree_8990 0 2.592e-15
Rtr_899_8991 tree_899 tree_8991 0.8192
Cp_8991 tree_8991 0 2.592e-15
Rtr_899_8992 tree_899 tree_8992 0.8192
Cp_8992 tree_8992 0 2.592e-15
Rtr_899_8993 tree_899 tree_8993 0.8192
Cp_8993 tree_8993 0 2.592e-15
Rtr_899_8994 tree_899 tree_8994 0.8192
Cp_8994 tree_8994 0 2.592e-15
Rtr_899_8995 tree_899 tree_8995 0.8192
Cp_8995 tree_8995 0 2.592e-15
Rtr_899_8996 tree_899 tree_8996 0.8192
Cp_8996 tree_8996 0 2.592e-15
Rtr_899_8997 tree_899 tree_8997 0.8192
Cp_8997 tree_8997 0 2.592e-15
Rtr_899_8998 tree_899 tree_8998 0.8192
Cp_8998 tree_8998 0 2.592e-15
Rtr_899_8999 tree_899 tree_8999 0.8192
Cp_8999 tree_8999 0 2.592e-15
Rtr_899_9000 tree_899 tree_9000 0.8192
Cp_9000 tree_9000 0 2.592e-15
Rtr_900_9001 tree_900 tree_9001 0.8192
Cp_9001 tree_9001 0 2.592e-15
Rtr_900_9002 tree_900 tree_9002 0.8192
Cp_9002 tree_9002 0 2.592e-15
Rtr_900_9003 tree_900 tree_9003 0.8192
Cp_9003 tree_9003 0 2.592e-15
Rtr_900_9004 tree_900 tree_9004 0.8192
Cp_9004 tree_9004 0 2.592e-15
Rtr_900_9005 tree_900 tree_9005 0.8192
Cp_9005 tree_9005 0 2.592e-15
Rtr_900_9006 tree_900 tree_9006 0.8192
Cp_9006 tree_9006 0 2.592e-15
Rtr_900_9007 tree_900 tree_9007 0.8192
Cp_9007 tree_9007 0 2.592e-15
Rtr_900_9008 tree_900 tree_9008 0.8192
Cp_9008 tree_9008 0 2.592e-15
Rtr_900_9009 tree_900 tree_9009 0.8192
Cp_9009 tree_9009 0 2.592e-15
Rtr_900_9010 tree_900 tree_9010 0.8192
Cp_9010 tree_9010 0 2.592e-15
Rtr_901_9011 tree_901 tree_9011 0.8192
Cp_9011 tree_9011 0 2.592e-15
Rtr_901_9012 tree_901 tree_9012 0.8192
Cp_9012 tree_9012 0 2.592e-15
Rtr_901_9013 tree_901 tree_9013 0.8192
Cp_9013 tree_9013 0 2.592e-15
Rtr_901_9014 tree_901 tree_9014 0.8192
Cp_9014 tree_9014 0 2.592e-15
Rtr_901_9015 tree_901 tree_9015 0.8192
Cp_9015 tree_9015 0 2.592e-15
Rtr_901_9016 tree_901 tree_9016 0.8192
Cp_9016 tree_9016 0 2.592e-15
Rtr_901_9017 tree_901 tree_9017 0.8192
Cp_9017 tree_9017 0 2.592e-15
Rtr_901_9018 tree_901 tree_9018 0.8192
Cp_9018 tree_9018 0 2.592e-15
Rtr_901_9019 tree_901 tree_9019 0.8192
Cp_9019 tree_9019 0 2.592e-15
Rtr_901_9020 tree_901 tree_9020 0.8192
Cp_9020 tree_9020 0 2.592e-15
Rtr_902_9021 tree_902 tree_9021 0.8192
Cp_9021 tree_9021 0 2.592e-15
Rtr_902_9022 tree_902 tree_9022 0.8192
Cp_9022 tree_9022 0 2.592e-15
Rtr_902_9023 tree_902 tree_9023 0.8192
Cp_9023 tree_9023 0 2.592e-15
Rtr_902_9024 tree_902 tree_9024 0.8192
Cp_9024 tree_9024 0 2.592e-15
Rtr_902_9025 tree_902 tree_9025 0.8192
Cp_9025 tree_9025 0 2.592e-15
Rtr_902_9026 tree_902 tree_9026 0.8192
Cp_9026 tree_9026 0 2.592e-15
Rtr_902_9027 tree_902 tree_9027 0.8192
Cp_9027 tree_9027 0 2.592e-15
Rtr_902_9028 tree_902 tree_9028 0.8192
Cp_9028 tree_9028 0 2.592e-15
Rtr_902_9029 tree_902 tree_9029 0.8192
Cp_9029 tree_9029 0 2.592e-15
Rtr_902_9030 tree_902 tree_9030 0.8192
Cp_9030 tree_9030 0 2.592e-15
Rtr_903_9031 tree_903 tree_9031 0.8192
Cp_9031 tree_9031 0 2.592e-15
Rtr_903_9032 tree_903 tree_9032 0.8192
Cp_9032 tree_9032 0 2.592e-15
Rtr_903_9033 tree_903 tree_9033 0.8192
Cp_9033 tree_9033 0 2.592e-15
Rtr_903_9034 tree_903 tree_9034 0.8192
Cp_9034 tree_9034 0 2.592e-15
Rtr_903_9035 tree_903 tree_9035 0.8192
Cp_9035 tree_9035 0 2.592e-15
Rtr_903_9036 tree_903 tree_9036 0.8192
Cp_9036 tree_9036 0 2.592e-15
Rtr_903_9037 tree_903 tree_9037 0.8192
Cp_9037 tree_9037 0 2.592e-15
Rtr_903_9038 tree_903 tree_9038 0.8192
Cp_9038 tree_9038 0 2.592e-15
Rtr_903_9039 tree_903 tree_9039 0.8192
Cp_9039 tree_9039 0 2.592e-15
Rtr_903_9040 tree_903 tree_9040 0.8192
Cp_9040 tree_9040 0 2.592e-15
Rtr_904_9041 tree_904 tree_9041 0.8192
Cp_9041 tree_9041 0 2.592e-15
Rtr_904_9042 tree_904 tree_9042 0.8192
Cp_9042 tree_9042 0 2.592e-15
Rtr_904_9043 tree_904 tree_9043 0.8192
Cp_9043 tree_9043 0 2.592e-15
Rtr_904_9044 tree_904 tree_9044 0.8192
Cp_9044 tree_9044 0 2.592e-15
Rtr_904_9045 tree_904 tree_9045 0.8192
Cp_9045 tree_9045 0 2.592e-15
Rtr_904_9046 tree_904 tree_9046 0.8192
Cp_9046 tree_9046 0 2.592e-15
Rtr_904_9047 tree_904 tree_9047 0.8192
Cp_9047 tree_9047 0 2.592e-15
Rtr_904_9048 tree_904 tree_9048 0.8192
Cp_9048 tree_9048 0 2.592e-15
Rtr_904_9049 tree_904 tree_9049 0.8192
Cp_9049 tree_9049 0 2.592e-15
Rtr_904_9050 tree_904 tree_9050 0.8192
Cp_9050 tree_9050 0 2.592e-15
Rtr_905_9051 tree_905 tree_9051 0.8192
Cp_9051 tree_9051 0 2.592e-15
Rtr_905_9052 tree_905 tree_9052 0.8192
Cp_9052 tree_9052 0 2.592e-15
Rtr_905_9053 tree_905 tree_9053 0.8192
Cp_9053 tree_9053 0 2.592e-15
Rtr_905_9054 tree_905 tree_9054 0.8192
Cp_9054 tree_9054 0 2.592e-15
Rtr_905_9055 tree_905 tree_9055 0.8192
Cp_9055 tree_9055 0 2.592e-15
Rtr_905_9056 tree_905 tree_9056 0.8192
Cp_9056 tree_9056 0 2.592e-15
Rtr_905_9057 tree_905 tree_9057 0.8192
Cp_9057 tree_9057 0 2.592e-15
Rtr_905_9058 tree_905 tree_9058 0.8192
Cp_9058 tree_9058 0 2.592e-15
Rtr_905_9059 tree_905 tree_9059 0.8192
Cp_9059 tree_9059 0 2.592e-15
Rtr_905_9060 tree_905 tree_9060 0.8192
Cp_9060 tree_9060 0 2.592e-15
Rtr_906_9061 tree_906 tree_9061 0.8192
Cp_9061 tree_9061 0 2.592e-15
Rtr_906_9062 tree_906 tree_9062 0.8192
Cp_9062 tree_9062 0 2.592e-15
Rtr_906_9063 tree_906 tree_9063 0.8192
Cp_9063 tree_9063 0 2.592e-15
Rtr_906_9064 tree_906 tree_9064 0.8192
Cp_9064 tree_9064 0 2.592e-15
Rtr_906_9065 tree_906 tree_9065 0.8192
Cp_9065 tree_9065 0 2.592e-15
Rtr_906_9066 tree_906 tree_9066 0.8192
Cp_9066 tree_9066 0 2.592e-15
Rtr_906_9067 tree_906 tree_9067 0.8192
Cp_9067 tree_9067 0 2.592e-15
Rtr_906_9068 tree_906 tree_9068 0.8192
Cp_9068 tree_9068 0 2.592e-15
Rtr_906_9069 tree_906 tree_9069 0.8192
Cp_9069 tree_9069 0 2.592e-15
Rtr_906_9070 tree_906 tree_9070 0.8192
Cp_9070 tree_9070 0 2.592e-15
Rtr_907_9071 tree_907 tree_9071 0.8192
Cp_9071 tree_9071 0 2.592e-15
Rtr_907_9072 tree_907 tree_9072 0.8192
Cp_9072 tree_9072 0 2.592e-15
Rtr_907_9073 tree_907 tree_9073 0.8192
Cp_9073 tree_9073 0 2.592e-15
Rtr_907_9074 tree_907 tree_9074 0.8192
Cp_9074 tree_9074 0 2.592e-15
Rtr_907_9075 tree_907 tree_9075 0.8192
Cp_9075 tree_9075 0 2.592e-15
Rtr_907_9076 tree_907 tree_9076 0.8192
Cp_9076 tree_9076 0 2.592e-15
Rtr_907_9077 tree_907 tree_9077 0.8192
Cp_9077 tree_9077 0 2.592e-15
Rtr_907_9078 tree_907 tree_9078 0.8192
Cp_9078 tree_9078 0 2.592e-15
Rtr_907_9079 tree_907 tree_9079 0.8192
Cp_9079 tree_9079 0 2.592e-15
Rtr_907_9080 tree_907 tree_9080 0.8192
Cp_9080 tree_9080 0 2.592e-15
Rtr_908_9081 tree_908 tree_9081 0.8192
Cp_9081 tree_9081 0 2.592e-15
Rtr_908_9082 tree_908 tree_9082 0.8192
Cp_9082 tree_9082 0 2.592e-15
Rtr_908_9083 tree_908 tree_9083 0.8192
Cp_9083 tree_9083 0 2.592e-15
Rtr_908_9084 tree_908 tree_9084 0.8192
Cp_9084 tree_9084 0 2.592e-15
Rtr_908_9085 tree_908 tree_9085 0.8192
Cp_9085 tree_9085 0 2.592e-15
Rtr_908_9086 tree_908 tree_9086 0.8192
Cp_9086 tree_9086 0 2.592e-15
Rtr_908_9087 tree_908 tree_9087 0.8192
Cp_9087 tree_9087 0 2.592e-15
Rtr_908_9088 tree_908 tree_9088 0.8192
Cp_9088 tree_9088 0 2.592e-15
Rtr_908_9089 tree_908 tree_9089 0.8192
Cp_9089 tree_9089 0 2.592e-15
Rtr_908_9090 tree_908 tree_9090 0.8192
Cp_9090 tree_9090 0 2.592e-15
Rtr_909_9091 tree_909 tree_9091 0.8192
Cp_9091 tree_9091 0 2.592e-15
Rtr_909_9092 tree_909 tree_9092 0.8192
Cp_9092 tree_9092 0 2.592e-15
Rtr_909_9093 tree_909 tree_9093 0.8192
Cp_9093 tree_9093 0 2.592e-15
Rtr_909_9094 tree_909 tree_9094 0.8192
Cp_9094 tree_9094 0 2.592e-15
Rtr_909_9095 tree_909 tree_9095 0.8192
Cp_9095 tree_9095 0 2.592e-15
Rtr_909_9096 tree_909 tree_9096 0.8192
Cp_9096 tree_9096 0 2.592e-15
Rtr_909_9097 tree_909 tree_9097 0.8192
Cp_9097 tree_9097 0 2.592e-15
Rtr_909_9098 tree_909 tree_9098 0.8192
Cp_9098 tree_9098 0 2.592e-15
Rtr_909_9099 tree_909 tree_9099 0.8192
Cp_9099 tree_9099 0 2.592e-15
Rtr_909_9100 tree_909 tree_9100 0.8192
Cp_9100 tree_9100 0 2.592e-15
Rtr_910_9101 tree_910 tree_9101 0.8192
Cp_9101 tree_9101 0 2.592e-15
Rtr_910_9102 tree_910 tree_9102 0.8192
Cp_9102 tree_9102 0 2.592e-15
Rtr_910_9103 tree_910 tree_9103 0.8192
Cp_9103 tree_9103 0 2.592e-15
Rtr_910_9104 tree_910 tree_9104 0.8192
Cp_9104 tree_9104 0 2.592e-15
Rtr_910_9105 tree_910 tree_9105 0.8192
Cp_9105 tree_9105 0 2.592e-15
Rtr_910_9106 tree_910 tree_9106 0.8192
Cp_9106 tree_9106 0 2.592e-15
Rtr_910_9107 tree_910 tree_9107 0.8192
Cp_9107 tree_9107 0 2.592e-15
Rtr_910_9108 tree_910 tree_9108 0.8192
Cp_9108 tree_9108 0 2.592e-15
Rtr_910_9109 tree_910 tree_9109 0.8192
Cp_9109 tree_9109 0 2.592e-15
Rtr_910_9110 tree_910 tree_9110 0.8192
Cp_9110 tree_9110 0 2.592e-15
Rtr_911_9111 tree_911 tree_9111 0.8192
Cp_9111 tree_9111 0 2.592e-15
Rtr_911_9112 tree_911 tree_9112 0.8192
Cp_9112 tree_9112 0 2.592e-15
Rtr_911_9113 tree_911 tree_9113 0.8192
Cp_9113 tree_9113 0 2.592e-15
Rtr_911_9114 tree_911 tree_9114 0.8192
Cp_9114 tree_9114 0 2.592e-15
Rtr_911_9115 tree_911 tree_9115 0.8192
Cp_9115 tree_9115 0 2.592e-15
Rtr_911_9116 tree_911 tree_9116 0.8192
Cp_9116 tree_9116 0 2.592e-15
Rtr_911_9117 tree_911 tree_9117 0.8192
Cp_9117 tree_9117 0 2.592e-15
Rtr_911_9118 tree_911 tree_9118 0.8192
Cp_9118 tree_9118 0 2.592e-15
Rtr_911_9119 tree_911 tree_9119 0.8192
Cp_9119 tree_9119 0 2.592e-15
Rtr_911_9120 tree_911 tree_9120 0.8192
Cp_9120 tree_9120 0 2.592e-15
Rtr_912_9121 tree_912 tree_9121 0.8192
Cp_9121 tree_9121 0 2.592e-15
Rtr_912_9122 tree_912 tree_9122 0.8192
Cp_9122 tree_9122 0 2.592e-15
Rtr_912_9123 tree_912 tree_9123 0.8192
Cp_9123 tree_9123 0 2.592e-15
Rtr_912_9124 tree_912 tree_9124 0.8192
Cp_9124 tree_9124 0 2.592e-15
Rtr_912_9125 tree_912 tree_9125 0.8192
Cp_9125 tree_9125 0 2.592e-15
Rtr_912_9126 tree_912 tree_9126 0.8192
Cp_9126 tree_9126 0 2.592e-15
Rtr_912_9127 tree_912 tree_9127 0.8192
Cp_9127 tree_9127 0 2.592e-15
Rtr_912_9128 tree_912 tree_9128 0.8192
Cp_9128 tree_9128 0 2.592e-15
Rtr_912_9129 tree_912 tree_9129 0.8192
Cp_9129 tree_9129 0 2.592e-15
Rtr_912_9130 tree_912 tree_9130 0.8192
Cp_9130 tree_9130 0 2.592e-15
Rtr_913_9131 tree_913 tree_9131 0.8192
Cp_9131 tree_9131 0 2.592e-15
Rtr_913_9132 tree_913 tree_9132 0.8192
Cp_9132 tree_9132 0 2.592e-15
Rtr_913_9133 tree_913 tree_9133 0.8192
Cp_9133 tree_9133 0 2.592e-15
Rtr_913_9134 tree_913 tree_9134 0.8192
Cp_9134 tree_9134 0 2.592e-15
Rtr_913_9135 tree_913 tree_9135 0.8192
Cp_9135 tree_9135 0 2.592e-15
Rtr_913_9136 tree_913 tree_9136 0.8192
Cp_9136 tree_9136 0 2.592e-15
Rtr_913_9137 tree_913 tree_9137 0.8192
Cp_9137 tree_9137 0 2.592e-15
Rtr_913_9138 tree_913 tree_9138 0.8192
Cp_9138 tree_9138 0 2.592e-15
Rtr_913_9139 tree_913 tree_9139 0.8192
Cp_9139 tree_9139 0 2.592e-15
Rtr_913_9140 tree_913 tree_9140 0.8192
Cp_9140 tree_9140 0 2.592e-15
Rtr_914_9141 tree_914 tree_9141 0.8192
Cp_9141 tree_9141 0 2.592e-15
Rtr_914_9142 tree_914 tree_9142 0.8192
Cp_9142 tree_9142 0 2.592e-15
Rtr_914_9143 tree_914 tree_9143 0.8192
Cp_9143 tree_9143 0 2.592e-15
Rtr_914_9144 tree_914 tree_9144 0.8192
Cp_9144 tree_9144 0 2.592e-15
Rtr_914_9145 tree_914 tree_9145 0.8192
Cp_9145 tree_9145 0 2.592e-15
Rtr_914_9146 tree_914 tree_9146 0.8192
Cp_9146 tree_9146 0 2.592e-15
Rtr_914_9147 tree_914 tree_9147 0.8192
Cp_9147 tree_9147 0 2.592e-15
Rtr_914_9148 tree_914 tree_9148 0.8192
Cp_9148 tree_9148 0 2.592e-15
Rtr_914_9149 tree_914 tree_9149 0.8192
Cp_9149 tree_9149 0 2.592e-15
Rtr_914_9150 tree_914 tree_9150 0.8192
Cp_9150 tree_9150 0 2.592e-15
Rtr_915_9151 tree_915 tree_9151 0.8192
Cp_9151 tree_9151 0 2.592e-15
Rtr_915_9152 tree_915 tree_9152 0.8192
Cp_9152 tree_9152 0 2.592e-15
Rtr_915_9153 tree_915 tree_9153 0.8192
Cp_9153 tree_9153 0 2.592e-15
Rtr_915_9154 tree_915 tree_9154 0.8192
Cp_9154 tree_9154 0 2.592e-15
Rtr_915_9155 tree_915 tree_9155 0.8192
Cp_9155 tree_9155 0 2.592e-15
Rtr_915_9156 tree_915 tree_9156 0.8192
Cp_9156 tree_9156 0 2.592e-15
Rtr_915_9157 tree_915 tree_9157 0.8192
Cp_9157 tree_9157 0 2.592e-15
Rtr_915_9158 tree_915 tree_9158 0.8192
Cp_9158 tree_9158 0 2.592e-15
Rtr_915_9159 tree_915 tree_9159 0.8192
Cp_9159 tree_9159 0 2.592e-15
Rtr_915_9160 tree_915 tree_9160 0.8192
Cp_9160 tree_9160 0 2.592e-15
Rtr_916_9161 tree_916 tree_9161 0.8192
Cp_9161 tree_9161 0 2.592e-15
Rtr_916_9162 tree_916 tree_9162 0.8192
Cp_9162 tree_9162 0 2.592e-15
Rtr_916_9163 tree_916 tree_9163 0.8192
Cp_9163 tree_9163 0 2.592e-15
Rtr_916_9164 tree_916 tree_9164 0.8192
Cp_9164 tree_9164 0 2.592e-15
Rtr_916_9165 tree_916 tree_9165 0.8192
Cp_9165 tree_9165 0 2.592e-15
Rtr_916_9166 tree_916 tree_9166 0.8192
Cp_9166 tree_9166 0 2.592e-15
Rtr_916_9167 tree_916 tree_9167 0.8192
Cp_9167 tree_9167 0 2.592e-15
Rtr_916_9168 tree_916 tree_9168 0.8192
Cp_9168 tree_9168 0 2.592e-15
Rtr_916_9169 tree_916 tree_9169 0.8192
Cp_9169 tree_9169 0 2.592e-15
Rtr_916_9170 tree_916 tree_9170 0.8192
Cp_9170 tree_9170 0 2.592e-15
Rtr_917_9171 tree_917 tree_9171 0.8192
Cp_9171 tree_9171 0 2.592e-15
Rtr_917_9172 tree_917 tree_9172 0.8192
Cp_9172 tree_9172 0 2.592e-15
Rtr_917_9173 tree_917 tree_9173 0.8192
Cp_9173 tree_9173 0 2.592e-15
Rtr_917_9174 tree_917 tree_9174 0.8192
Cp_9174 tree_9174 0 2.592e-15
Rtr_917_9175 tree_917 tree_9175 0.8192
Cp_9175 tree_9175 0 2.592e-15
Rtr_917_9176 tree_917 tree_9176 0.8192
Cp_9176 tree_9176 0 2.592e-15
Rtr_917_9177 tree_917 tree_9177 0.8192
Cp_9177 tree_9177 0 2.592e-15
Rtr_917_9178 tree_917 tree_9178 0.8192
Cp_9178 tree_9178 0 2.592e-15
Rtr_917_9179 tree_917 tree_9179 0.8192
Cp_9179 tree_9179 0 2.592e-15
Rtr_917_9180 tree_917 tree_9180 0.8192
Cp_9180 tree_9180 0 2.592e-15
Rtr_918_9181 tree_918 tree_9181 0.8192
Cp_9181 tree_9181 0 2.592e-15
Rtr_918_9182 tree_918 tree_9182 0.8192
Cp_9182 tree_9182 0 2.592e-15
Rtr_918_9183 tree_918 tree_9183 0.8192
Cp_9183 tree_9183 0 2.592e-15
Rtr_918_9184 tree_918 tree_9184 0.8192
Cp_9184 tree_9184 0 2.592e-15
Rtr_918_9185 tree_918 tree_9185 0.8192
Cp_9185 tree_9185 0 2.592e-15
Rtr_918_9186 tree_918 tree_9186 0.8192
Cp_9186 tree_9186 0 2.592e-15
Rtr_918_9187 tree_918 tree_9187 0.8192
Cp_9187 tree_9187 0 2.592e-15
Rtr_918_9188 tree_918 tree_9188 0.8192
Cp_9188 tree_9188 0 2.592e-15
Rtr_918_9189 tree_918 tree_9189 0.8192
Cp_9189 tree_9189 0 2.592e-15
Rtr_918_9190 tree_918 tree_9190 0.8192
Cp_9190 tree_9190 0 2.592e-15
Rtr_919_9191 tree_919 tree_9191 0.8192
Cp_9191 tree_9191 0 2.592e-15
Rtr_919_9192 tree_919 tree_9192 0.8192
Cp_9192 tree_9192 0 2.592e-15
Rtr_919_9193 tree_919 tree_9193 0.8192
Cp_9193 tree_9193 0 2.592e-15
Rtr_919_9194 tree_919 tree_9194 0.8192
Cp_9194 tree_9194 0 2.592e-15
Rtr_919_9195 tree_919 tree_9195 0.8192
Cp_9195 tree_9195 0 2.592e-15
Rtr_919_9196 tree_919 tree_9196 0.8192
Cp_9196 tree_9196 0 2.592e-15
Rtr_919_9197 tree_919 tree_9197 0.8192
Cp_9197 tree_9197 0 2.592e-15
Rtr_919_9198 tree_919 tree_9198 0.8192
Cp_9198 tree_9198 0 2.592e-15
Rtr_919_9199 tree_919 tree_9199 0.8192
Cp_9199 tree_9199 0 2.592e-15
Rtr_919_9200 tree_919 tree_9200 0.8192
Cp_9200 tree_9200 0 2.592e-15
Rtr_920_9201 tree_920 tree_9201 0.8192
Cp_9201 tree_9201 0 2.592e-15
Rtr_920_9202 tree_920 tree_9202 0.8192
Cp_9202 tree_9202 0 2.592e-15
Rtr_920_9203 tree_920 tree_9203 0.8192
Cp_9203 tree_9203 0 2.592e-15
Rtr_920_9204 tree_920 tree_9204 0.8192
Cp_9204 tree_9204 0 2.592e-15
Rtr_920_9205 tree_920 tree_9205 0.8192
Cp_9205 tree_9205 0 2.592e-15
Rtr_920_9206 tree_920 tree_9206 0.8192
Cp_9206 tree_9206 0 2.592e-15
Rtr_920_9207 tree_920 tree_9207 0.8192
Cp_9207 tree_9207 0 2.592e-15
Rtr_920_9208 tree_920 tree_9208 0.8192
Cp_9208 tree_9208 0 2.592e-15
Rtr_920_9209 tree_920 tree_9209 0.8192
Cp_9209 tree_9209 0 2.592e-15
Rtr_920_9210 tree_920 tree_9210 0.8192
Cp_9210 tree_9210 0 2.592e-15
Rtr_921_9211 tree_921 tree_9211 0.8192
Cp_9211 tree_9211 0 2.592e-15
Rtr_921_9212 tree_921 tree_9212 0.8192
Cp_9212 tree_9212 0 2.592e-15
Rtr_921_9213 tree_921 tree_9213 0.8192
Cp_9213 tree_9213 0 2.592e-15
Rtr_921_9214 tree_921 tree_9214 0.8192
Cp_9214 tree_9214 0 2.592e-15
Rtr_921_9215 tree_921 tree_9215 0.8192
Cp_9215 tree_9215 0 2.592e-15
Rtr_921_9216 tree_921 tree_9216 0.8192
Cp_9216 tree_9216 0 2.592e-15
Rtr_921_9217 tree_921 tree_9217 0.8192
Cp_9217 tree_9217 0 2.592e-15
Rtr_921_9218 tree_921 tree_9218 0.8192
Cp_9218 tree_9218 0 2.592e-15
Rtr_921_9219 tree_921 tree_9219 0.8192
Cp_9219 tree_9219 0 2.592e-15
Rtr_921_9220 tree_921 tree_9220 0.8192
Cp_9220 tree_9220 0 2.592e-15
Rtr_922_9221 tree_922 tree_9221 0.8192
Cp_9221 tree_9221 0 2.592e-15
Rtr_922_9222 tree_922 tree_9222 0.8192
Cp_9222 tree_9222 0 2.592e-15
Rtr_922_9223 tree_922 tree_9223 0.8192
Cp_9223 tree_9223 0 2.592e-15
Rtr_922_9224 tree_922 tree_9224 0.8192
Cp_9224 tree_9224 0 2.592e-15
Rtr_922_9225 tree_922 tree_9225 0.8192
Cp_9225 tree_9225 0 2.592e-15
Rtr_922_9226 tree_922 tree_9226 0.8192
Cp_9226 tree_9226 0 2.592e-15
Rtr_922_9227 tree_922 tree_9227 0.8192
Cp_9227 tree_9227 0 2.592e-15
Rtr_922_9228 tree_922 tree_9228 0.8192
Cp_9228 tree_9228 0 2.592e-15
Rtr_922_9229 tree_922 tree_9229 0.8192
Cp_9229 tree_9229 0 2.592e-15
Rtr_922_9230 tree_922 tree_9230 0.8192
Cp_9230 tree_9230 0 2.592e-15
Rtr_923_9231 tree_923 tree_9231 0.8192
Cp_9231 tree_9231 0 2.592e-15
Rtr_923_9232 tree_923 tree_9232 0.8192
Cp_9232 tree_9232 0 2.592e-15
Rtr_923_9233 tree_923 tree_9233 0.8192
Cp_9233 tree_9233 0 2.592e-15
Rtr_923_9234 tree_923 tree_9234 0.8192
Cp_9234 tree_9234 0 2.592e-15
Rtr_923_9235 tree_923 tree_9235 0.8192
Cp_9235 tree_9235 0 2.592e-15
Rtr_923_9236 tree_923 tree_9236 0.8192
Cp_9236 tree_9236 0 2.592e-15
Rtr_923_9237 tree_923 tree_9237 0.8192
Cp_9237 tree_9237 0 2.592e-15
Rtr_923_9238 tree_923 tree_9238 0.8192
Cp_9238 tree_9238 0 2.592e-15
Rtr_923_9239 tree_923 tree_9239 0.8192
Cp_9239 tree_9239 0 2.592e-15
Rtr_923_9240 tree_923 tree_9240 0.8192
Cp_9240 tree_9240 0 2.592e-15
Rtr_924_9241 tree_924 tree_9241 0.8192
Cp_9241 tree_9241 0 2.592e-15
Rtr_924_9242 tree_924 tree_9242 0.8192
Cp_9242 tree_9242 0 2.592e-15
Rtr_924_9243 tree_924 tree_9243 0.8192
Cp_9243 tree_9243 0 2.592e-15
Rtr_924_9244 tree_924 tree_9244 0.8192
Cp_9244 tree_9244 0 2.592e-15
Rtr_924_9245 tree_924 tree_9245 0.8192
Cp_9245 tree_9245 0 2.592e-15
Rtr_924_9246 tree_924 tree_9246 0.8192
Cp_9246 tree_9246 0 2.592e-15
Rtr_924_9247 tree_924 tree_9247 0.8192
Cp_9247 tree_9247 0 2.592e-15
Rtr_924_9248 tree_924 tree_9248 0.8192
Cp_9248 tree_9248 0 2.592e-15
Rtr_924_9249 tree_924 tree_9249 0.8192
Cp_9249 tree_9249 0 2.592e-15
Rtr_924_9250 tree_924 tree_9250 0.8192
Cp_9250 tree_9250 0 2.592e-15
Rtr_925_9251 tree_925 tree_9251 0.8192
Cp_9251 tree_9251 0 2.592e-15
Rtr_925_9252 tree_925 tree_9252 0.8192
Cp_9252 tree_9252 0 2.592e-15
Rtr_925_9253 tree_925 tree_9253 0.8192
Cp_9253 tree_9253 0 2.592e-15
Rtr_925_9254 tree_925 tree_9254 0.8192
Cp_9254 tree_9254 0 2.592e-15
Rtr_925_9255 tree_925 tree_9255 0.8192
Cp_9255 tree_9255 0 2.592e-15
Rtr_925_9256 tree_925 tree_9256 0.8192
Cp_9256 tree_9256 0 2.592e-15
Rtr_925_9257 tree_925 tree_9257 0.8192
Cp_9257 tree_9257 0 2.592e-15
Rtr_925_9258 tree_925 tree_9258 0.8192
Cp_9258 tree_9258 0 2.592e-15
Rtr_925_9259 tree_925 tree_9259 0.8192
Cp_9259 tree_9259 0 2.592e-15
Rtr_925_9260 tree_925 tree_9260 0.8192
Cp_9260 tree_9260 0 2.592e-15
Rtr_926_9261 tree_926 tree_9261 0.8192
Cp_9261 tree_9261 0 2.592e-15
Rtr_926_9262 tree_926 tree_9262 0.8192
Cp_9262 tree_9262 0 2.592e-15
Rtr_926_9263 tree_926 tree_9263 0.8192
Cp_9263 tree_9263 0 2.592e-15
Rtr_926_9264 tree_926 tree_9264 0.8192
Cp_9264 tree_9264 0 2.592e-15
Rtr_926_9265 tree_926 tree_9265 0.8192
Cp_9265 tree_9265 0 2.592e-15
Rtr_926_9266 tree_926 tree_9266 0.8192
Cp_9266 tree_9266 0 2.592e-15
Rtr_926_9267 tree_926 tree_9267 0.8192
Cp_9267 tree_9267 0 2.592e-15
Rtr_926_9268 tree_926 tree_9268 0.8192
Cp_9268 tree_9268 0 2.592e-15
Rtr_926_9269 tree_926 tree_9269 0.8192
Cp_9269 tree_9269 0 2.592e-15
Rtr_926_9270 tree_926 tree_9270 0.8192
Cp_9270 tree_9270 0 2.592e-15
Rtr_927_9271 tree_927 tree_9271 0.8192
Cp_9271 tree_9271 0 2.592e-15
Rtr_927_9272 tree_927 tree_9272 0.8192
Cp_9272 tree_9272 0 2.592e-15
Rtr_927_9273 tree_927 tree_9273 0.8192
Cp_9273 tree_9273 0 2.592e-15
Rtr_927_9274 tree_927 tree_9274 0.8192
Cp_9274 tree_9274 0 2.592e-15
Rtr_927_9275 tree_927 tree_9275 0.8192
Cp_9275 tree_9275 0 2.592e-15
Rtr_927_9276 tree_927 tree_9276 0.8192
Cp_9276 tree_9276 0 2.592e-15
Rtr_927_9277 tree_927 tree_9277 0.8192
Cp_9277 tree_9277 0 2.592e-15
Rtr_927_9278 tree_927 tree_9278 0.8192
Cp_9278 tree_9278 0 2.592e-15
Rtr_927_9279 tree_927 tree_9279 0.8192
Cp_9279 tree_9279 0 2.592e-15
Rtr_927_9280 tree_927 tree_9280 0.8192
Cp_9280 tree_9280 0 2.592e-15
Rtr_928_9281 tree_928 tree_9281 0.8192
Cp_9281 tree_9281 0 2.592e-15
Rtr_928_9282 tree_928 tree_9282 0.8192
Cp_9282 tree_9282 0 2.592e-15
Rtr_928_9283 tree_928 tree_9283 0.8192
Cp_9283 tree_9283 0 2.592e-15
Rtr_928_9284 tree_928 tree_9284 0.8192
Cp_9284 tree_9284 0 2.592e-15
Rtr_928_9285 tree_928 tree_9285 0.8192
Cp_9285 tree_9285 0 2.592e-15
Rtr_928_9286 tree_928 tree_9286 0.8192
Cp_9286 tree_9286 0 2.592e-15
Rtr_928_9287 tree_928 tree_9287 0.8192
Cp_9287 tree_9287 0 2.592e-15
Rtr_928_9288 tree_928 tree_9288 0.8192
Cp_9288 tree_9288 0 2.592e-15
Rtr_928_9289 tree_928 tree_9289 0.8192
Cp_9289 tree_9289 0 2.592e-15
Rtr_928_9290 tree_928 tree_9290 0.8192
Cp_9290 tree_9290 0 2.592e-15
Rtr_929_9291 tree_929 tree_9291 0.8192
Cp_9291 tree_9291 0 2.592e-15
Rtr_929_9292 tree_929 tree_9292 0.8192
Cp_9292 tree_9292 0 2.592e-15
Rtr_929_9293 tree_929 tree_9293 0.8192
Cp_9293 tree_9293 0 2.592e-15
Rtr_929_9294 tree_929 tree_9294 0.8192
Cp_9294 tree_9294 0 2.592e-15
Rtr_929_9295 tree_929 tree_9295 0.8192
Cp_9295 tree_9295 0 2.592e-15
Rtr_929_9296 tree_929 tree_9296 0.8192
Cp_9296 tree_9296 0 2.592e-15
Rtr_929_9297 tree_929 tree_9297 0.8192
Cp_9297 tree_9297 0 2.592e-15
Rtr_929_9298 tree_929 tree_9298 0.8192
Cp_9298 tree_9298 0 2.592e-15
Rtr_929_9299 tree_929 tree_9299 0.8192
Cp_9299 tree_9299 0 2.592e-15
Rtr_929_9300 tree_929 tree_9300 0.8192
Cp_9300 tree_9300 0 2.592e-15
Rtr_930_9301 tree_930 tree_9301 0.8192
Cp_9301 tree_9301 0 2.592e-15
Rtr_930_9302 tree_930 tree_9302 0.8192
Cp_9302 tree_9302 0 2.592e-15
Rtr_930_9303 tree_930 tree_9303 0.8192
Cp_9303 tree_9303 0 2.592e-15
Rtr_930_9304 tree_930 tree_9304 0.8192
Cp_9304 tree_9304 0 2.592e-15
Rtr_930_9305 tree_930 tree_9305 0.8192
Cp_9305 tree_9305 0 2.592e-15
Rtr_930_9306 tree_930 tree_9306 0.8192
Cp_9306 tree_9306 0 2.592e-15
Rtr_930_9307 tree_930 tree_9307 0.8192
Cp_9307 tree_9307 0 2.592e-15
Rtr_930_9308 tree_930 tree_9308 0.8192
Cp_9308 tree_9308 0 2.592e-15
Rtr_930_9309 tree_930 tree_9309 0.8192
Cp_9309 tree_9309 0 2.592e-15
Rtr_930_9310 tree_930 tree_9310 0.8192
Cp_9310 tree_9310 0 2.592e-15
Rtr_931_9311 tree_931 tree_9311 0.8192
Cp_9311 tree_9311 0 2.592e-15
Rtr_931_9312 tree_931 tree_9312 0.8192
Cp_9312 tree_9312 0 2.592e-15
Rtr_931_9313 tree_931 tree_9313 0.8192
Cp_9313 tree_9313 0 2.592e-15
Rtr_931_9314 tree_931 tree_9314 0.8192
Cp_9314 tree_9314 0 2.592e-15
Rtr_931_9315 tree_931 tree_9315 0.8192
Cp_9315 tree_9315 0 2.592e-15
Rtr_931_9316 tree_931 tree_9316 0.8192
Cp_9316 tree_9316 0 2.592e-15
Rtr_931_9317 tree_931 tree_9317 0.8192
Cp_9317 tree_9317 0 2.592e-15
Rtr_931_9318 tree_931 tree_9318 0.8192
Cp_9318 tree_9318 0 2.592e-15
Rtr_931_9319 tree_931 tree_9319 0.8192
Cp_9319 tree_9319 0 2.592e-15
Rtr_931_9320 tree_931 tree_9320 0.8192
Cp_9320 tree_9320 0 2.592e-15
Rtr_932_9321 tree_932 tree_9321 0.8192
Cp_9321 tree_9321 0 2.592e-15
Rtr_932_9322 tree_932 tree_9322 0.8192
Cp_9322 tree_9322 0 2.592e-15
Rtr_932_9323 tree_932 tree_9323 0.8192
Cp_9323 tree_9323 0 2.592e-15
Rtr_932_9324 tree_932 tree_9324 0.8192
Cp_9324 tree_9324 0 2.592e-15
Rtr_932_9325 tree_932 tree_9325 0.8192
Cp_9325 tree_9325 0 2.592e-15
Rtr_932_9326 tree_932 tree_9326 0.8192
Cp_9326 tree_9326 0 2.592e-15
Rtr_932_9327 tree_932 tree_9327 0.8192
Cp_9327 tree_9327 0 2.592e-15
Rtr_932_9328 tree_932 tree_9328 0.8192
Cp_9328 tree_9328 0 2.592e-15
Rtr_932_9329 tree_932 tree_9329 0.8192
Cp_9329 tree_9329 0 2.592e-15
Rtr_932_9330 tree_932 tree_9330 0.8192
Cp_9330 tree_9330 0 2.592e-15
Rtr_933_9331 tree_933 tree_9331 0.8192
Cp_9331 tree_9331 0 2.592e-15
Rtr_933_9332 tree_933 tree_9332 0.8192
Cp_9332 tree_9332 0 2.592e-15
Rtr_933_9333 tree_933 tree_9333 0.8192
Cp_9333 tree_9333 0 2.592e-15
Rtr_933_9334 tree_933 tree_9334 0.8192
Cp_9334 tree_9334 0 2.592e-15
Rtr_933_9335 tree_933 tree_9335 0.8192
Cp_9335 tree_9335 0 2.592e-15
Rtr_933_9336 tree_933 tree_9336 0.8192
Cp_9336 tree_9336 0 2.592e-15
Rtr_933_9337 tree_933 tree_9337 0.8192
Cp_9337 tree_9337 0 2.592e-15
Rtr_933_9338 tree_933 tree_9338 0.8192
Cp_9338 tree_9338 0 2.592e-15
Rtr_933_9339 tree_933 tree_9339 0.8192
Cp_9339 tree_9339 0 2.592e-15
Rtr_933_9340 tree_933 tree_9340 0.8192
Cp_9340 tree_9340 0 2.592e-15
Rtr_934_9341 tree_934 tree_9341 0.8192
Cp_9341 tree_9341 0 2.592e-15
Rtr_934_9342 tree_934 tree_9342 0.8192
Cp_9342 tree_9342 0 2.592e-15
Rtr_934_9343 tree_934 tree_9343 0.8192
Cp_9343 tree_9343 0 2.592e-15
Rtr_934_9344 tree_934 tree_9344 0.8192
Cp_9344 tree_9344 0 2.592e-15
Rtr_934_9345 tree_934 tree_9345 0.8192
Cp_9345 tree_9345 0 2.592e-15
Rtr_934_9346 tree_934 tree_9346 0.8192
Cp_9346 tree_9346 0 2.592e-15
Rtr_934_9347 tree_934 tree_9347 0.8192
Cp_9347 tree_9347 0 2.592e-15
Rtr_934_9348 tree_934 tree_9348 0.8192
Cp_9348 tree_9348 0 2.592e-15
Rtr_934_9349 tree_934 tree_9349 0.8192
Cp_9349 tree_9349 0 2.592e-15
Rtr_934_9350 tree_934 tree_9350 0.8192
Cp_9350 tree_9350 0 2.592e-15
Rtr_935_9351 tree_935 tree_9351 0.8192
Cp_9351 tree_9351 0 2.592e-15
Rtr_935_9352 tree_935 tree_9352 0.8192
Cp_9352 tree_9352 0 2.592e-15
Rtr_935_9353 tree_935 tree_9353 0.8192
Cp_9353 tree_9353 0 2.592e-15
Rtr_935_9354 tree_935 tree_9354 0.8192
Cp_9354 tree_9354 0 2.592e-15
Rtr_935_9355 tree_935 tree_9355 0.8192
Cp_9355 tree_9355 0 2.592e-15
Rtr_935_9356 tree_935 tree_9356 0.8192
Cp_9356 tree_9356 0 2.592e-15
Rtr_935_9357 tree_935 tree_9357 0.8192
Cp_9357 tree_9357 0 2.592e-15
Rtr_935_9358 tree_935 tree_9358 0.8192
Cp_9358 tree_9358 0 2.592e-15
Rtr_935_9359 tree_935 tree_9359 0.8192
Cp_9359 tree_9359 0 2.592e-15
Rtr_935_9360 tree_935 tree_9360 0.8192
Cp_9360 tree_9360 0 2.592e-15
Rtr_936_9361 tree_936 tree_9361 0.8192
Cp_9361 tree_9361 0 2.592e-15
Rtr_936_9362 tree_936 tree_9362 0.8192
Cp_9362 tree_9362 0 2.592e-15
Rtr_936_9363 tree_936 tree_9363 0.8192
Cp_9363 tree_9363 0 2.592e-15
Rtr_936_9364 tree_936 tree_9364 0.8192
Cp_9364 tree_9364 0 2.592e-15
Rtr_936_9365 tree_936 tree_9365 0.8192
Cp_9365 tree_9365 0 2.592e-15
Rtr_936_9366 tree_936 tree_9366 0.8192
Cp_9366 tree_9366 0 2.592e-15
Rtr_936_9367 tree_936 tree_9367 0.8192
Cp_9367 tree_9367 0 2.592e-15
Rtr_936_9368 tree_936 tree_9368 0.8192
Cp_9368 tree_9368 0 2.592e-15
Rtr_936_9369 tree_936 tree_9369 0.8192
Cp_9369 tree_9369 0 2.592e-15
Rtr_936_9370 tree_936 tree_9370 0.8192
Cp_9370 tree_9370 0 2.592e-15
Rtr_937_9371 tree_937 tree_9371 0.8192
Cp_9371 tree_9371 0 2.592e-15
Rtr_937_9372 tree_937 tree_9372 0.8192
Cp_9372 tree_9372 0 2.592e-15
Rtr_937_9373 tree_937 tree_9373 0.8192
Cp_9373 tree_9373 0 2.592e-15
Rtr_937_9374 tree_937 tree_9374 0.8192
Cp_9374 tree_9374 0 2.592e-15
Rtr_937_9375 tree_937 tree_9375 0.8192
Cp_9375 tree_9375 0 2.592e-15
Rtr_937_9376 tree_937 tree_9376 0.8192
Cp_9376 tree_9376 0 2.592e-15
Rtr_937_9377 tree_937 tree_9377 0.8192
Cp_9377 tree_9377 0 2.592e-15
Rtr_937_9378 tree_937 tree_9378 0.8192
Cp_9378 tree_9378 0 2.592e-15
Rtr_937_9379 tree_937 tree_9379 0.8192
Cp_9379 tree_9379 0 2.592e-15
Rtr_937_9380 tree_937 tree_9380 0.8192
Cp_9380 tree_9380 0 2.592e-15
Rtr_938_9381 tree_938 tree_9381 0.8192
Cp_9381 tree_9381 0 2.592e-15
Rtr_938_9382 tree_938 tree_9382 0.8192
Cp_9382 tree_9382 0 2.592e-15
Rtr_938_9383 tree_938 tree_9383 0.8192
Cp_9383 tree_9383 0 2.592e-15
Rtr_938_9384 tree_938 tree_9384 0.8192
Cp_9384 tree_9384 0 2.592e-15
Rtr_938_9385 tree_938 tree_9385 0.8192
Cp_9385 tree_9385 0 2.592e-15
Rtr_938_9386 tree_938 tree_9386 0.8192
Cp_9386 tree_9386 0 2.592e-15
Rtr_938_9387 tree_938 tree_9387 0.8192
Cp_9387 tree_9387 0 2.592e-15
Rtr_938_9388 tree_938 tree_9388 0.8192
Cp_9388 tree_9388 0 2.592e-15
Rtr_938_9389 tree_938 tree_9389 0.8192
Cp_9389 tree_9389 0 2.592e-15
Rtr_938_9390 tree_938 tree_9390 0.8192
Cp_9390 tree_9390 0 2.592e-15
Rtr_939_9391 tree_939 tree_9391 0.8192
Cp_9391 tree_9391 0 2.592e-15
Rtr_939_9392 tree_939 tree_9392 0.8192
Cp_9392 tree_9392 0 2.592e-15
Rtr_939_9393 tree_939 tree_9393 0.8192
Cp_9393 tree_9393 0 2.592e-15
Rtr_939_9394 tree_939 tree_9394 0.8192
Cp_9394 tree_9394 0 2.592e-15
Rtr_939_9395 tree_939 tree_9395 0.8192
Cp_9395 tree_9395 0 2.592e-15
Rtr_939_9396 tree_939 tree_9396 0.8192
Cp_9396 tree_9396 0 2.592e-15
Rtr_939_9397 tree_939 tree_9397 0.8192
Cp_9397 tree_9397 0 2.592e-15
Rtr_939_9398 tree_939 tree_9398 0.8192
Cp_9398 tree_9398 0 2.592e-15
Rtr_939_9399 tree_939 tree_9399 0.8192
Cp_9399 tree_9399 0 2.592e-15
Rtr_939_9400 tree_939 tree_9400 0.8192
Cp_9400 tree_9400 0 2.592e-15
Rtr_940_9401 tree_940 tree_9401 0.8192
Cp_9401 tree_9401 0 2.592e-15
Rtr_940_9402 tree_940 tree_9402 0.8192
Cp_9402 tree_9402 0 2.592e-15
Rtr_940_9403 tree_940 tree_9403 0.8192
Cp_9403 tree_9403 0 2.592e-15
Rtr_940_9404 tree_940 tree_9404 0.8192
Cp_9404 tree_9404 0 2.592e-15
Rtr_940_9405 tree_940 tree_9405 0.8192
Cp_9405 tree_9405 0 2.592e-15
Rtr_940_9406 tree_940 tree_9406 0.8192
Cp_9406 tree_9406 0 2.592e-15
Rtr_940_9407 tree_940 tree_9407 0.8192
Cp_9407 tree_9407 0 2.592e-15
Rtr_940_9408 tree_940 tree_9408 0.8192
Cp_9408 tree_9408 0 2.592e-15
Rtr_940_9409 tree_940 tree_9409 0.8192
Cp_9409 tree_9409 0 2.592e-15
Rtr_940_9410 tree_940 tree_9410 0.8192
Cp_9410 tree_9410 0 2.592e-15
Rtr_941_9411 tree_941 tree_9411 0.8192
Cp_9411 tree_9411 0 2.592e-15
Rtr_941_9412 tree_941 tree_9412 0.8192
Cp_9412 tree_9412 0 2.592e-15
Rtr_941_9413 tree_941 tree_9413 0.8192
Cp_9413 tree_9413 0 2.592e-15
Rtr_941_9414 tree_941 tree_9414 0.8192
Cp_9414 tree_9414 0 2.592e-15
Rtr_941_9415 tree_941 tree_9415 0.8192
Cp_9415 tree_9415 0 2.592e-15
Rtr_941_9416 tree_941 tree_9416 0.8192
Cp_9416 tree_9416 0 2.592e-15
Rtr_941_9417 tree_941 tree_9417 0.8192
Cp_9417 tree_9417 0 2.592e-15
Rtr_941_9418 tree_941 tree_9418 0.8192
Cp_9418 tree_9418 0 2.592e-15
Rtr_941_9419 tree_941 tree_9419 0.8192
Cp_9419 tree_9419 0 2.592e-15
Rtr_941_9420 tree_941 tree_9420 0.8192
Cp_9420 tree_9420 0 2.592e-15
Rtr_942_9421 tree_942 tree_9421 0.8192
Cp_9421 tree_9421 0 2.592e-15
Rtr_942_9422 tree_942 tree_9422 0.8192
Cp_9422 tree_9422 0 2.592e-15
Rtr_942_9423 tree_942 tree_9423 0.8192
Cp_9423 tree_9423 0 2.592e-15
Rtr_942_9424 tree_942 tree_9424 0.8192
Cp_9424 tree_9424 0 2.592e-15
Rtr_942_9425 tree_942 tree_9425 0.8192
Cp_9425 tree_9425 0 2.592e-15
Rtr_942_9426 tree_942 tree_9426 0.8192
Cp_9426 tree_9426 0 2.592e-15
Rtr_942_9427 tree_942 tree_9427 0.8192
Cp_9427 tree_9427 0 2.592e-15
Rtr_942_9428 tree_942 tree_9428 0.8192
Cp_9428 tree_9428 0 2.592e-15
Rtr_942_9429 tree_942 tree_9429 0.8192
Cp_9429 tree_9429 0 2.592e-15
Rtr_942_9430 tree_942 tree_9430 0.8192
Cp_9430 tree_9430 0 2.592e-15
Rtr_943_9431 tree_943 tree_9431 0.8192
Cp_9431 tree_9431 0 2.592e-15
Rtr_943_9432 tree_943 tree_9432 0.8192
Cp_9432 tree_9432 0 2.592e-15
Rtr_943_9433 tree_943 tree_9433 0.8192
Cp_9433 tree_9433 0 2.592e-15
Rtr_943_9434 tree_943 tree_9434 0.8192
Cp_9434 tree_9434 0 2.592e-15
Rtr_943_9435 tree_943 tree_9435 0.8192
Cp_9435 tree_9435 0 2.592e-15
Rtr_943_9436 tree_943 tree_9436 0.8192
Cp_9436 tree_9436 0 2.592e-15
Rtr_943_9437 tree_943 tree_9437 0.8192
Cp_9437 tree_9437 0 2.592e-15
Rtr_943_9438 tree_943 tree_9438 0.8192
Cp_9438 tree_9438 0 2.592e-15
Rtr_943_9439 tree_943 tree_9439 0.8192
Cp_9439 tree_9439 0 2.592e-15
Rtr_943_9440 tree_943 tree_9440 0.8192
Cp_9440 tree_9440 0 2.592e-15
Rtr_944_9441 tree_944 tree_9441 0.8192
Cp_9441 tree_9441 0 2.592e-15
Rtr_944_9442 tree_944 tree_9442 0.8192
Cp_9442 tree_9442 0 2.592e-15
Rtr_944_9443 tree_944 tree_9443 0.8192
Cp_9443 tree_9443 0 2.592e-15
Rtr_944_9444 tree_944 tree_9444 0.8192
Cp_9444 tree_9444 0 2.592e-15
Rtr_944_9445 tree_944 tree_9445 0.8192
Cp_9445 tree_9445 0 2.592e-15
Rtr_944_9446 tree_944 tree_9446 0.8192
Cp_9446 tree_9446 0 2.592e-15
Rtr_944_9447 tree_944 tree_9447 0.8192
Cp_9447 tree_9447 0 2.592e-15
Rtr_944_9448 tree_944 tree_9448 0.8192
Cp_9448 tree_9448 0 2.592e-15
Rtr_944_9449 tree_944 tree_9449 0.8192
Cp_9449 tree_9449 0 2.592e-15
Rtr_944_9450 tree_944 tree_9450 0.8192
Cp_9450 tree_9450 0 2.592e-15
Rtr_945_9451 tree_945 tree_9451 0.8192
Cp_9451 tree_9451 0 2.592e-15
Rtr_945_9452 tree_945 tree_9452 0.8192
Cp_9452 tree_9452 0 2.592e-15
Rtr_945_9453 tree_945 tree_9453 0.8192
Cp_9453 tree_9453 0 2.592e-15
Rtr_945_9454 tree_945 tree_9454 0.8192
Cp_9454 tree_9454 0 2.592e-15
Rtr_945_9455 tree_945 tree_9455 0.8192
Cp_9455 tree_9455 0 2.592e-15
Rtr_945_9456 tree_945 tree_9456 0.8192
Cp_9456 tree_9456 0 2.592e-15
Rtr_945_9457 tree_945 tree_9457 0.8192
Cp_9457 tree_9457 0 2.592e-15
Rtr_945_9458 tree_945 tree_9458 0.8192
Cp_9458 tree_9458 0 2.592e-15
Rtr_945_9459 tree_945 tree_9459 0.8192
Cp_9459 tree_9459 0 2.592e-15
Rtr_945_9460 tree_945 tree_9460 0.8192
Cp_9460 tree_9460 0 2.592e-15
Rtr_946_9461 tree_946 tree_9461 0.8192
Cp_9461 tree_9461 0 2.592e-15
Rtr_946_9462 tree_946 tree_9462 0.8192
Cp_9462 tree_9462 0 2.592e-15
Rtr_946_9463 tree_946 tree_9463 0.8192
Cp_9463 tree_9463 0 2.592e-15
Rtr_946_9464 tree_946 tree_9464 0.8192
Cp_9464 tree_9464 0 2.592e-15
Rtr_946_9465 tree_946 tree_9465 0.8192
Cp_9465 tree_9465 0 2.592e-15
Rtr_946_9466 tree_946 tree_9466 0.8192
Cp_9466 tree_9466 0 2.592e-15
Rtr_946_9467 tree_946 tree_9467 0.8192
Cp_9467 tree_9467 0 2.592e-15
Rtr_946_9468 tree_946 tree_9468 0.8192
Cp_9468 tree_9468 0 2.592e-15
Rtr_946_9469 tree_946 tree_9469 0.8192
Cp_9469 tree_9469 0 2.592e-15
Rtr_946_9470 tree_946 tree_9470 0.8192
Cp_9470 tree_9470 0 2.592e-15
Rtr_947_9471 tree_947 tree_9471 0.8192
Cp_9471 tree_9471 0 2.592e-15
Rtr_947_9472 tree_947 tree_9472 0.8192
Cp_9472 tree_9472 0 2.592e-15
Rtr_947_9473 tree_947 tree_9473 0.8192
Cp_9473 tree_9473 0 2.592e-15
Rtr_947_9474 tree_947 tree_9474 0.8192
Cp_9474 tree_9474 0 2.592e-15
Rtr_947_9475 tree_947 tree_9475 0.8192
Cp_9475 tree_9475 0 2.592e-15
Rtr_947_9476 tree_947 tree_9476 0.8192
Cp_9476 tree_9476 0 2.592e-15
Rtr_947_9477 tree_947 tree_9477 0.8192
Cp_9477 tree_9477 0 2.592e-15
Rtr_947_9478 tree_947 tree_9478 0.8192
Cp_9478 tree_9478 0 2.592e-15
Rtr_947_9479 tree_947 tree_9479 0.8192
Cp_9479 tree_9479 0 2.592e-15
Rtr_947_9480 tree_947 tree_9480 0.8192
Cp_9480 tree_9480 0 2.592e-15
Rtr_948_9481 tree_948 tree_9481 0.8192
Cp_9481 tree_9481 0 2.592e-15
Rtr_948_9482 tree_948 tree_9482 0.8192
Cp_9482 tree_9482 0 2.592e-15
Rtr_948_9483 tree_948 tree_9483 0.8192
Cp_9483 tree_9483 0 2.592e-15
Rtr_948_9484 tree_948 tree_9484 0.8192
Cp_9484 tree_9484 0 2.592e-15
Rtr_948_9485 tree_948 tree_9485 0.8192
Cp_9485 tree_9485 0 2.592e-15
Rtr_948_9486 tree_948 tree_9486 0.8192
Cp_9486 tree_9486 0 2.592e-15
Rtr_948_9487 tree_948 tree_9487 0.8192
Cp_9487 tree_9487 0 2.592e-15
Rtr_948_9488 tree_948 tree_9488 0.8192
Cp_9488 tree_9488 0 2.592e-15
Rtr_948_9489 tree_948 tree_9489 0.8192
Cp_9489 tree_9489 0 2.592e-15
Rtr_948_9490 tree_948 tree_9490 0.8192
Cp_9490 tree_9490 0 2.592e-15
Rtr_949_9491 tree_949 tree_9491 0.8192
Cp_9491 tree_9491 0 2.592e-15
Rtr_949_9492 tree_949 tree_9492 0.8192
Cp_9492 tree_9492 0 2.592e-15
Rtr_949_9493 tree_949 tree_9493 0.8192
Cp_9493 tree_9493 0 2.592e-15
Rtr_949_9494 tree_949 tree_9494 0.8192
Cp_9494 tree_9494 0 2.592e-15
Rtr_949_9495 tree_949 tree_9495 0.8192
Cp_9495 tree_9495 0 2.592e-15
Rtr_949_9496 tree_949 tree_9496 0.8192
Cp_9496 tree_9496 0 2.592e-15
Rtr_949_9497 tree_949 tree_9497 0.8192
Cp_9497 tree_9497 0 2.592e-15
Rtr_949_9498 tree_949 tree_9498 0.8192
Cp_9498 tree_9498 0 2.592e-15
Rtr_949_9499 tree_949 tree_9499 0.8192
Cp_9499 tree_9499 0 2.592e-15
Rtr_949_9500 tree_949 tree_9500 0.8192
Cp_9500 tree_9500 0 2.592e-15
Rtr_950_9501 tree_950 tree_9501 0.8192
Cp_9501 tree_9501 0 2.592e-15
Rtr_950_9502 tree_950 tree_9502 0.8192
Cp_9502 tree_9502 0 2.592e-15
Rtr_950_9503 tree_950 tree_9503 0.8192
Cp_9503 tree_9503 0 2.592e-15
Rtr_950_9504 tree_950 tree_9504 0.8192
Cp_9504 tree_9504 0 2.592e-15
Rtr_950_9505 tree_950 tree_9505 0.8192
Cp_9505 tree_9505 0 2.592e-15
Rtr_950_9506 tree_950 tree_9506 0.8192
Cp_9506 tree_9506 0 2.592e-15
Rtr_950_9507 tree_950 tree_9507 0.8192
Cp_9507 tree_9507 0 2.592e-15
Rtr_950_9508 tree_950 tree_9508 0.8192
Cp_9508 tree_9508 0 2.592e-15
Rtr_950_9509 tree_950 tree_9509 0.8192
Cp_9509 tree_9509 0 2.592e-15
Rtr_950_9510 tree_950 tree_9510 0.8192
Cp_9510 tree_9510 0 2.592e-15
Rtr_951_9511 tree_951 tree_9511 0.8192
Cp_9511 tree_9511 0 2.592e-15
Rtr_951_9512 tree_951 tree_9512 0.8192
Cp_9512 tree_9512 0 2.592e-15
Rtr_951_9513 tree_951 tree_9513 0.8192
Cp_9513 tree_9513 0 2.592e-15
Rtr_951_9514 tree_951 tree_9514 0.8192
Cp_9514 tree_9514 0 2.592e-15
Rtr_951_9515 tree_951 tree_9515 0.8192
Cp_9515 tree_9515 0 2.592e-15
Rtr_951_9516 tree_951 tree_9516 0.8192
Cp_9516 tree_9516 0 2.592e-15
Rtr_951_9517 tree_951 tree_9517 0.8192
Cp_9517 tree_9517 0 2.592e-15
Rtr_951_9518 tree_951 tree_9518 0.8192
Cp_9518 tree_9518 0 2.592e-15
Rtr_951_9519 tree_951 tree_9519 0.8192
Cp_9519 tree_9519 0 2.592e-15
Rtr_951_9520 tree_951 tree_9520 0.8192
Cp_9520 tree_9520 0 2.592e-15
Rtr_952_9521 tree_952 tree_9521 0.8192
Cp_9521 tree_9521 0 2.592e-15
Rtr_952_9522 tree_952 tree_9522 0.8192
Cp_9522 tree_9522 0 2.592e-15
Rtr_952_9523 tree_952 tree_9523 0.8192
Cp_9523 tree_9523 0 2.592e-15
Rtr_952_9524 tree_952 tree_9524 0.8192
Cp_9524 tree_9524 0 2.592e-15
Rtr_952_9525 tree_952 tree_9525 0.8192
Cp_9525 tree_9525 0 2.592e-15
Rtr_952_9526 tree_952 tree_9526 0.8192
Cp_9526 tree_9526 0 2.592e-15
Rtr_952_9527 tree_952 tree_9527 0.8192
Cp_9527 tree_9527 0 2.592e-15
Rtr_952_9528 tree_952 tree_9528 0.8192
Cp_9528 tree_9528 0 2.592e-15
Rtr_952_9529 tree_952 tree_9529 0.8192
Cp_9529 tree_9529 0 2.592e-15
Rtr_952_9530 tree_952 tree_9530 0.8192
Cp_9530 tree_9530 0 2.592e-15
Rtr_953_9531 tree_953 tree_9531 0.8192
Cp_9531 tree_9531 0 2.592e-15
Rtr_953_9532 tree_953 tree_9532 0.8192
Cp_9532 tree_9532 0 2.592e-15
Rtr_953_9533 tree_953 tree_9533 0.8192
Cp_9533 tree_9533 0 2.592e-15
Rtr_953_9534 tree_953 tree_9534 0.8192
Cp_9534 tree_9534 0 2.592e-15
Rtr_953_9535 tree_953 tree_9535 0.8192
Cp_9535 tree_9535 0 2.592e-15
Rtr_953_9536 tree_953 tree_9536 0.8192
Cp_9536 tree_9536 0 2.592e-15
Rtr_953_9537 tree_953 tree_9537 0.8192
Cp_9537 tree_9537 0 2.592e-15
Rtr_953_9538 tree_953 tree_9538 0.8192
Cp_9538 tree_9538 0 2.592e-15
Rtr_953_9539 tree_953 tree_9539 0.8192
Cp_9539 tree_9539 0 2.592e-15
Rtr_953_9540 tree_953 tree_9540 0.8192
Cp_9540 tree_9540 0 2.592e-15
Rtr_954_9541 tree_954 tree_9541 0.8192
Cp_9541 tree_9541 0 2.592e-15
Rtr_954_9542 tree_954 tree_9542 0.8192
Cp_9542 tree_9542 0 2.592e-15
Rtr_954_9543 tree_954 tree_9543 0.8192
Cp_9543 tree_9543 0 2.592e-15
Rtr_954_9544 tree_954 tree_9544 0.8192
Cp_9544 tree_9544 0 2.592e-15
Rtr_954_9545 tree_954 tree_9545 0.8192
Cp_9545 tree_9545 0 2.592e-15
Rtr_954_9546 tree_954 tree_9546 0.8192
Cp_9546 tree_9546 0 2.592e-15
Rtr_954_9547 tree_954 tree_9547 0.8192
Cp_9547 tree_9547 0 2.592e-15
Rtr_954_9548 tree_954 tree_9548 0.8192
Cp_9548 tree_9548 0 2.592e-15
Rtr_954_9549 tree_954 tree_9549 0.8192
Cp_9549 tree_9549 0 2.592e-15
Rtr_954_9550 tree_954 tree_9550 0.8192
Cp_9550 tree_9550 0 2.592e-15
Rtr_955_9551 tree_955 tree_9551 0.8192
Cp_9551 tree_9551 0 2.592e-15
Rtr_955_9552 tree_955 tree_9552 0.8192
Cp_9552 tree_9552 0 2.592e-15
Rtr_955_9553 tree_955 tree_9553 0.8192
Cp_9553 tree_9553 0 2.592e-15
Rtr_955_9554 tree_955 tree_9554 0.8192
Cp_9554 tree_9554 0 2.592e-15
Rtr_955_9555 tree_955 tree_9555 0.8192
Cp_9555 tree_9555 0 2.592e-15
Rtr_955_9556 tree_955 tree_9556 0.8192
Cp_9556 tree_9556 0 2.592e-15
Rtr_955_9557 tree_955 tree_9557 0.8192
Cp_9557 tree_9557 0 2.592e-15
Rtr_955_9558 tree_955 tree_9558 0.8192
Cp_9558 tree_9558 0 2.592e-15
Rtr_955_9559 tree_955 tree_9559 0.8192
Cp_9559 tree_9559 0 2.592e-15
Rtr_955_9560 tree_955 tree_9560 0.8192
Cp_9560 tree_9560 0 2.592e-15
Rtr_956_9561 tree_956 tree_9561 0.8192
Cp_9561 tree_9561 0 2.592e-15
Rtr_956_9562 tree_956 tree_9562 0.8192
Cp_9562 tree_9562 0 2.592e-15
Rtr_956_9563 tree_956 tree_9563 0.8192
Cp_9563 tree_9563 0 2.592e-15
Rtr_956_9564 tree_956 tree_9564 0.8192
Cp_9564 tree_9564 0 2.592e-15
Rtr_956_9565 tree_956 tree_9565 0.8192
Cp_9565 tree_9565 0 2.592e-15
Rtr_956_9566 tree_956 tree_9566 0.8192
Cp_9566 tree_9566 0 2.592e-15
Rtr_956_9567 tree_956 tree_9567 0.8192
Cp_9567 tree_9567 0 2.592e-15
Rtr_956_9568 tree_956 tree_9568 0.8192
Cp_9568 tree_9568 0 2.592e-15
Rtr_956_9569 tree_956 tree_9569 0.8192
Cp_9569 tree_9569 0 2.592e-15
Rtr_956_9570 tree_956 tree_9570 0.8192
Cp_9570 tree_9570 0 2.592e-15
Rtr_957_9571 tree_957 tree_9571 0.8192
Cp_9571 tree_9571 0 2.592e-15
Rtr_957_9572 tree_957 tree_9572 0.8192
Cp_9572 tree_9572 0 2.592e-15
Rtr_957_9573 tree_957 tree_9573 0.8192
Cp_9573 tree_9573 0 2.592e-15
Rtr_957_9574 tree_957 tree_9574 0.8192
Cp_9574 tree_9574 0 2.592e-15
Rtr_957_9575 tree_957 tree_9575 0.8192
Cp_9575 tree_9575 0 2.592e-15
Rtr_957_9576 tree_957 tree_9576 0.8192
Cp_9576 tree_9576 0 2.592e-15
Rtr_957_9577 tree_957 tree_9577 0.8192
Cp_9577 tree_9577 0 2.592e-15
Rtr_957_9578 tree_957 tree_9578 0.8192
Cp_9578 tree_9578 0 2.592e-15
Rtr_957_9579 tree_957 tree_9579 0.8192
Cp_9579 tree_9579 0 2.592e-15
Rtr_957_9580 tree_957 tree_9580 0.8192
Cp_9580 tree_9580 0 2.592e-15
Rtr_958_9581 tree_958 tree_9581 0.8192
Cp_9581 tree_9581 0 2.592e-15
Rtr_958_9582 tree_958 tree_9582 0.8192
Cp_9582 tree_9582 0 2.592e-15
Rtr_958_9583 tree_958 tree_9583 0.8192
Cp_9583 tree_9583 0 2.592e-15
Rtr_958_9584 tree_958 tree_9584 0.8192
Cp_9584 tree_9584 0 2.592e-15
Rtr_958_9585 tree_958 tree_9585 0.8192
Cp_9585 tree_9585 0 2.592e-15
Rtr_958_9586 tree_958 tree_9586 0.8192
Cp_9586 tree_9586 0 2.592e-15
Rtr_958_9587 tree_958 tree_9587 0.8192
Cp_9587 tree_9587 0 2.592e-15
Rtr_958_9588 tree_958 tree_9588 0.8192
Cp_9588 tree_9588 0 2.592e-15
Rtr_958_9589 tree_958 tree_9589 0.8192
Cp_9589 tree_9589 0 2.592e-15
Rtr_958_9590 tree_958 tree_9590 0.8192
Cp_9590 tree_9590 0 2.592e-15
Rtr_959_9591 tree_959 tree_9591 0.8192
Cp_9591 tree_9591 0 2.592e-15
Rtr_959_9592 tree_959 tree_9592 0.8192
Cp_9592 tree_9592 0 2.592e-15
Rtr_959_9593 tree_959 tree_9593 0.8192
Cp_9593 tree_9593 0 2.592e-15
Rtr_959_9594 tree_959 tree_9594 0.8192
Cp_9594 tree_9594 0 2.592e-15
Rtr_959_9595 tree_959 tree_9595 0.8192
Cp_9595 tree_9595 0 2.592e-15
Rtr_959_9596 tree_959 tree_9596 0.8192
Cp_9596 tree_9596 0 2.592e-15
Rtr_959_9597 tree_959 tree_9597 0.8192
Cp_9597 tree_9597 0 2.592e-15
Rtr_959_9598 tree_959 tree_9598 0.8192
Cp_9598 tree_9598 0 2.592e-15
Rtr_959_9599 tree_959 tree_9599 0.8192
Cp_9599 tree_9599 0 2.592e-15
Rtr_959_9600 tree_959 tree_9600 0.8192
Cp_9600 tree_9600 0 2.592e-15
Rtr_960_9601 tree_960 tree_9601 0.8192
Cp_9601 tree_9601 0 2.592e-15
Rtr_960_9602 tree_960 tree_9602 0.8192
Cp_9602 tree_9602 0 2.592e-15
Rtr_960_9603 tree_960 tree_9603 0.8192
Cp_9603 tree_9603 0 2.592e-15
Rtr_960_9604 tree_960 tree_9604 0.8192
Cp_9604 tree_9604 0 2.592e-15
Rtr_960_9605 tree_960 tree_9605 0.8192
Cp_9605 tree_9605 0 2.592e-15
Rtr_960_9606 tree_960 tree_9606 0.8192
Cp_9606 tree_9606 0 2.592e-15
Rtr_960_9607 tree_960 tree_9607 0.8192
Cp_9607 tree_9607 0 2.592e-15
Rtr_960_9608 tree_960 tree_9608 0.8192
Cp_9608 tree_9608 0 2.592e-15
Rtr_960_9609 tree_960 tree_9609 0.8192
Cp_9609 tree_9609 0 2.592e-15
Rtr_960_9610 tree_960 tree_9610 0.8192
Cp_9610 tree_9610 0 2.592e-15
Rtr_961_9611 tree_961 tree_9611 0.8192
Cp_9611 tree_9611 0 2.592e-15
Rtr_961_9612 tree_961 tree_9612 0.8192
Cp_9612 tree_9612 0 2.592e-15
Rtr_961_9613 tree_961 tree_9613 0.8192
Cp_9613 tree_9613 0 2.592e-15
Rtr_961_9614 tree_961 tree_9614 0.8192
Cp_9614 tree_9614 0 2.592e-15
Rtr_961_9615 tree_961 tree_9615 0.8192
Cp_9615 tree_9615 0 2.592e-15
Rtr_961_9616 tree_961 tree_9616 0.8192
Cp_9616 tree_9616 0 2.592e-15
Rtr_961_9617 tree_961 tree_9617 0.8192
Cp_9617 tree_9617 0 2.592e-15
Rtr_961_9618 tree_961 tree_9618 0.8192
Cp_9618 tree_9618 0 2.592e-15
Rtr_961_9619 tree_961 tree_9619 0.8192
Cp_9619 tree_9619 0 2.592e-15
Rtr_961_9620 tree_961 tree_9620 0.8192
Cp_9620 tree_9620 0 2.592e-15
Rtr_962_9621 tree_962 tree_9621 0.8192
Cp_9621 tree_9621 0 2.592e-15
Rtr_962_9622 tree_962 tree_9622 0.8192
Cp_9622 tree_9622 0 2.592e-15
Rtr_962_9623 tree_962 tree_9623 0.8192
Cp_9623 tree_9623 0 2.592e-15
Rtr_962_9624 tree_962 tree_9624 0.8192
Cp_9624 tree_9624 0 2.592e-15
Rtr_962_9625 tree_962 tree_9625 0.8192
Cp_9625 tree_9625 0 2.592e-15
Rtr_962_9626 tree_962 tree_9626 0.8192
Cp_9626 tree_9626 0 2.592e-15
Rtr_962_9627 tree_962 tree_9627 0.8192
Cp_9627 tree_9627 0 2.592e-15
Rtr_962_9628 tree_962 tree_9628 0.8192
Cp_9628 tree_9628 0 2.592e-15
Rtr_962_9629 tree_962 tree_9629 0.8192
Cp_9629 tree_9629 0 2.592e-15
Rtr_962_9630 tree_962 tree_9630 0.8192
Cp_9630 tree_9630 0 2.592e-15
Rtr_963_9631 tree_963 tree_9631 0.8192
Cp_9631 tree_9631 0 2.592e-15
Rtr_963_9632 tree_963 tree_9632 0.8192
Cp_9632 tree_9632 0 2.592e-15
Rtr_963_9633 tree_963 tree_9633 0.8192
Cp_9633 tree_9633 0 2.592e-15
Rtr_963_9634 tree_963 tree_9634 0.8192
Cp_9634 tree_9634 0 2.592e-15
Rtr_963_9635 tree_963 tree_9635 0.8192
Cp_9635 tree_9635 0 2.592e-15
Rtr_963_9636 tree_963 tree_9636 0.8192
Cp_9636 tree_9636 0 2.592e-15
Rtr_963_9637 tree_963 tree_9637 0.8192
Cp_9637 tree_9637 0 2.592e-15
Rtr_963_9638 tree_963 tree_9638 0.8192
Cp_9638 tree_9638 0 2.592e-15
Rtr_963_9639 tree_963 tree_9639 0.8192
Cp_9639 tree_9639 0 2.592e-15
Rtr_963_9640 tree_963 tree_9640 0.8192
Cp_9640 tree_9640 0 2.592e-15
Rtr_964_9641 tree_964 tree_9641 0.8192
Cp_9641 tree_9641 0 2.592e-15
Rtr_964_9642 tree_964 tree_9642 0.8192
Cp_9642 tree_9642 0 2.592e-15
Rtr_964_9643 tree_964 tree_9643 0.8192
Cp_9643 tree_9643 0 2.592e-15
Rtr_964_9644 tree_964 tree_9644 0.8192
Cp_9644 tree_9644 0 2.592e-15
Rtr_964_9645 tree_964 tree_9645 0.8192
Cp_9645 tree_9645 0 2.592e-15
Rtr_964_9646 tree_964 tree_9646 0.8192
Cp_9646 tree_9646 0 2.592e-15
Rtr_964_9647 tree_964 tree_9647 0.8192
Cp_9647 tree_9647 0 2.592e-15
Rtr_964_9648 tree_964 tree_9648 0.8192
Cp_9648 tree_9648 0 2.592e-15
Rtr_964_9649 tree_964 tree_9649 0.8192
Cp_9649 tree_9649 0 2.592e-15
Rtr_964_9650 tree_964 tree_9650 0.8192
Cp_9650 tree_9650 0 2.592e-15
Rtr_965_9651 tree_965 tree_9651 0.8192
Cp_9651 tree_9651 0 2.592e-15
Rtr_965_9652 tree_965 tree_9652 0.8192
Cp_9652 tree_9652 0 2.592e-15
Rtr_965_9653 tree_965 tree_9653 0.8192
Cp_9653 tree_9653 0 2.592e-15
Rtr_965_9654 tree_965 tree_9654 0.8192
Cp_9654 tree_9654 0 2.592e-15
Rtr_965_9655 tree_965 tree_9655 0.8192
Cp_9655 tree_9655 0 2.592e-15
Rtr_965_9656 tree_965 tree_9656 0.8192
Cp_9656 tree_9656 0 2.592e-15
Rtr_965_9657 tree_965 tree_9657 0.8192
Cp_9657 tree_9657 0 2.592e-15
Rtr_965_9658 tree_965 tree_9658 0.8192
Cp_9658 tree_9658 0 2.592e-15
Rtr_965_9659 tree_965 tree_9659 0.8192
Cp_9659 tree_9659 0 2.592e-15
Rtr_965_9660 tree_965 tree_9660 0.8192
Cp_9660 tree_9660 0 2.592e-15
Rtr_966_9661 tree_966 tree_9661 0.8192
Cp_9661 tree_9661 0 2.592e-15
Rtr_966_9662 tree_966 tree_9662 0.8192
Cp_9662 tree_9662 0 2.592e-15
Rtr_966_9663 tree_966 tree_9663 0.8192
Cp_9663 tree_9663 0 2.592e-15
Rtr_966_9664 tree_966 tree_9664 0.8192
Cp_9664 tree_9664 0 2.592e-15
Rtr_966_9665 tree_966 tree_9665 0.8192
Cp_9665 tree_9665 0 2.592e-15
Rtr_966_9666 tree_966 tree_9666 0.8192
Cp_9666 tree_9666 0 2.592e-15
Rtr_966_9667 tree_966 tree_9667 0.8192
Cp_9667 tree_9667 0 2.592e-15
Rtr_966_9668 tree_966 tree_9668 0.8192
Cp_9668 tree_9668 0 2.592e-15
Rtr_966_9669 tree_966 tree_9669 0.8192
Cp_9669 tree_9669 0 2.592e-15
Rtr_966_9670 tree_966 tree_9670 0.8192
Cp_9670 tree_9670 0 2.592e-15
Rtr_967_9671 tree_967 tree_9671 0.8192
Cp_9671 tree_9671 0 2.592e-15
Rtr_967_9672 tree_967 tree_9672 0.8192
Cp_9672 tree_9672 0 2.592e-15
Rtr_967_9673 tree_967 tree_9673 0.8192
Cp_9673 tree_9673 0 2.592e-15
Rtr_967_9674 tree_967 tree_9674 0.8192
Cp_9674 tree_9674 0 2.592e-15
Rtr_967_9675 tree_967 tree_9675 0.8192
Cp_9675 tree_9675 0 2.592e-15
Rtr_967_9676 tree_967 tree_9676 0.8192
Cp_9676 tree_9676 0 2.592e-15
Rtr_967_9677 tree_967 tree_9677 0.8192
Cp_9677 tree_9677 0 2.592e-15
Rtr_967_9678 tree_967 tree_9678 0.8192
Cp_9678 tree_9678 0 2.592e-15
Rtr_967_9679 tree_967 tree_9679 0.8192
Cp_9679 tree_9679 0 2.592e-15
Rtr_967_9680 tree_967 tree_9680 0.8192
Cp_9680 tree_9680 0 2.592e-15
Rtr_968_9681 tree_968 tree_9681 0.8192
Cp_9681 tree_9681 0 2.592e-15
Rtr_968_9682 tree_968 tree_9682 0.8192
Cp_9682 tree_9682 0 2.592e-15
Rtr_968_9683 tree_968 tree_9683 0.8192
Cp_9683 tree_9683 0 2.592e-15
Rtr_968_9684 tree_968 tree_9684 0.8192
Cp_9684 tree_9684 0 2.592e-15
Rtr_968_9685 tree_968 tree_9685 0.8192
Cp_9685 tree_9685 0 2.592e-15
Rtr_968_9686 tree_968 tree_9686 0.8192
Cp_9686 tree_9686 0 2.592e-15
Rtr_968_9687 tree_968 tree_9687 0.8192
Cp_9687 tree_9687 0 2.592e-15
Rtr_968_9688 tree_968 tree_9688 0.8192
Cp_9688 tree_9688 0 2.592e-15
Rtr_968_9689 tree_968 tree_9689 0.8192
Cp_9689 tree_9689 0 2.592e-15
Rtr_968_9690 tree_968 tree_9690 0.8192
Cp_9690 tree_9690 0 2.592e-15
Rtr_969_9691 tree_969 tree_9691 0.8192
Cp_9691 tree_9691 0 2.592e-15
Rtr_969_9692 tree_969 tree_9692 0.8192
Cp_9692 tree_9692 0 2.592e-15
Rtr_969_9693 tree_969 tree_9693 0.8192
Cp_9693 tree_9693 0 2.592e-15
Rtr_969_9694 tree_969 tree_9694 0.8192
Cp_9694 tree_9694 0 2.592e-15
Rtr_969_9695 tree_969 tree_9695 0.8192
Cp_9695 tree_9695 0 2.592e-15
Rtr_969_9696 tree_969 tree_9696 0.8192
Cp_9696 tree_9696 0 2.592e-15
Rtr_969_9697 tree_969 tree_9697 0.8192
Cp_9697 tree_9697 0 2.592e-15
Rtr_969_9698 tree_969 tree_9698 0.8192
Cp_9698 tree_9698 0 2.592e-15
Rtr_969_9699 tree_969 tree_9699 0.8192
Cp_9699 tree_9699 0 2.592e-15
Rtr_969_9700 tree_969 tree_9700 0.8192
Cp_9700 tree_9700 0 2.592e-15
Rtr_970_9701 tree_970 tree_9701 0.8192
Cp_9701 tree_9701 0 2.592e-15
Rtr_970_9702 tree_970 tree_9702 0.8192
Cp_9702 tree_9702 0 2.592e-15
Rtr_970_9703 tree_970 tree_9703 0.8192
Cp_9703 tree_9703 0 2.592e-15
Rtr_970_9704 tree_970 tree_9704 0.8192
Cp_9704 tree_9704 0 2.592e-15
Rtr_970_9705 tree_970 tree_9705 0.8192
Cp_9705 tree_9705 0 2.592e-15
Rtr_970_9706 tree_970 tree_9706 0.8192
Cp_9706 tree_9706 0 2.592e-15
Rtr_970_9707 tree_970 tree_9707 0.8192
Cp_9707 tree_9707 0 2.592e-15
Rtr_970_9708 tree_970 tree_9708 0.8192
Cp_9708 tree_9708 0 2.592e-15
Rtr_970_9709 tree_970 tree_9709 0.8192
Cp_9709 tree_9709 0 2.592e-15
Rtr_970_9710 tree_970 tree_9710 0.8192
Cp_9710 tree_9710 0 2.592e-15
Rtr_971_9711 tree_971 tree_9711 0.8192
Cp_9711 tree_9711 0 2.592e-15
Rtr_971_9712 tree_971 tree_9712 0.8192
Cp_9712 tree_9712 0 2.592e-15
Rtr_971_9713 tree_971 tree_9713 0.8192
Cp_9713 tree_9713 0 2.592e-15
Rtr_971_9714 tree_971 tree_9714 0.8192
Cp_9714 tree_9714 0 2.592e-15
Rtr_971_9715 tree_971 tree_9715 0.8192
Cp_9715 tree_9715 0 2.592e-15
Rtr_971_9716 tree_971 tree_9716 0.8192
Cp_9716 tree_9716 0 2.592e-15
Rtr_971_9717 tree_971 tree_9717 0.8192
Cp_9717 tree_9717 0 2.592e-15
Rtr_971_9718 tree_971 tree_9718 0.8192
Cp_9718 tree_9718 0 2.592e-15
Rtr_971_9719 tree_971 tree_9719 0.8192
Cp_9719 tree_9719 0 2.592e-15
Rtr_971_9720 tree_971 tree_9720 0.8192
Cp_9720 tree_9720 0 2.592e-15
Rtr_972_9721 tree_972 tree_9721 0.8192
Cp_9721 tree_9721 0 2.592e-15
Rtr_972_9722 tree_972 tree_9722 0.8192
Cp_9722 tree_9722 0 2.592e-15
Rtr_972_9723 tree_972 tree_9723 0.8192
Cp_9723 tree_9723 0 2.592e-15
Rtr_972_9724 tree_972 tree_9724 0.8192
Cp_9724 tree_9724 0 2.592e-15
Rtr_972_9725 tree_972 tree_9725 0.8192
Cp_9725 tree_9725 0 2.592e-15
Rtr_972_9726 tree_972 tree_9726 0.8192
Cp_9726 tree_9726 0 2.592e-15
Rtr_972_9727 tree_972 tree_9727 0.8192
Cp_9727 tree_9727 0 2.592e-15
Rtr_972_9728 tree_972 tree_9728 0.8192
Cp_9728 tree_9728 0 2.592e-15
Rtr_972_9729 tree_972 tree_9729 0.8192
Cp_9729 tree_9729 0 2.592e-15
Rtr_972_9730 tree_972 tree_9730 0.8192
Cp_9730 tree_9730 0 2.592e-15
Rtr_973_9731 tree_973 tree_9731 0.8192
Cp_9731 tree_9731 0 2.592e-15
Rtr_973_9732 tree_973 tree_9732 0.8192
Cp_9732 tree_9732 0 2.592e-15
Rtr_973_9733 tree_973 tree_9733 0.8192
Cp_9733 tree_9733 0 2.592e-15
Rtr_973_9734 tree_973 tree_9734 0.8192
Cp_9734 tree_9734 0 2.592e-15
Rtr_973_9735 tree_973 tree_9735 0.8192
Cp_9735 tree_9735 0 2.592e-15
Rtr_973_9736 tree_973 tree_9736 0.8192
Cp_9736 tree_9736 0 2.592e-15
Rtr_973_9737 tree_973 tree_9737 0.8192
Cp_9737 tree_9737 0 2.592e-15
Rtr_973_9738 tree_973 tree_9738 0.8192
Cp_9738 tree_9738 0 2.592e-15
Rtr_973_9739 tree_973 tree_9739 0.8192
Cp_9739 tree_9739 0 2.592e-15
Rtr_973_9740 tree_973 tree_9740 0.8192
Cp_9740 tree_9740 0 2.592e-15
Rtr_974_9741 tree_974 tree_9741 0.8192
Cp_9741 tree_9741 0 2.592e-15
Rtr_974_9742 tree_974 tree_9742 0.8192
Cp_9742 tree_9742 0 2.592e-15
Rtr_974_9743 tree_974 tree_9743 0.8192
Cp_9743 tree_9743 0 2.592e-15
Rtr_974_9744 tree_974 tree_9744 0.8192
Cp_9744 tree_9744 0 2.592e-15
Rtr_974_9745 tree_974 tree_9745 0.8192
Cp_9745 tree_9745 0 2.592e-15
Rtr_974_9746 tree_974 tree_9746 0.8192
Cp_9746 tree_9746 0 2.592e-15
Rtr_974_9747 tree_974 tree_9747 0.8192
Cp_9747 tree_9747 0 2.592e-15
Rtr_974_9748 tree_974 tree_9748 0.8192
Cp_9748 tree_9748 0 2.592e-15
Rtr_974_9749 tree_974 tree_9749 0.8192
Cp_9749 tree_9749 0 2.592e-15
Rtr_974_9750 tree_974 tree_9750 0.8192
Cp_9750 tree_9750 0 2.592e-15
Rtr_975_9751 tree_975 tree_9751 0.8192
Cp_9751 tree_9751 0 2.592e-15
Rtr_975_9752 tree_975 tree_9752 0.8192
Cp_9752 tree_9752 0 2.592e-15
Rtr_975_9753 tree_975 tree_9753 0.8192
Cp_9753 tree_9753 0 2.592e-15
Rtr_975_9754 tree_975 tree_9754 0.8192
Cp_9754 tree_9754 0 2.592e-15
Rtr_975_9755 tree_975 tree_9755 0.8192
Cp_9755 tree_9755 0 2.592e-15
Rtr_975_9756 tree_975 tree_9756 0.8192
Cp_9756 tree_9756 0 2.592e-15
Rtr_975_9757 tree_975 tree_9757 0.8192
Cp_9757 tree_9757 0 2.592e-15
Rtr_975_9758 tree_975 tree_9758 0.8192
Cp_9758 tree_9758 0 2.592e-15
Rtr_975_9759 tree_975 tree_9759 0.8192
Cp_9759 tree_9759 0 2.592e-15
Rtr_975_9760 tree_975 tree_9760 0.8192
Cp_9760 tree_9760 0 2.592e-15
Rtr_976_9761 tree_976 tree_9761 0.8192
Cp_9761 tree_9761 0 2.592e-15
Rtr_976_9762 tree_976 tree_9762 0.8192
Cp_9762 tree_9762 0 2.592e-15
Rtr_976_9763 tree_976 tree_9763 0.8192
Cp_9763 tree_9763 0 2.592e-15
Rtr_976_9764 tree_976 tree_9764 0.8192
Cp_9764 tree_9764 0 2.592e-15
Rtr_976_9765 tree_976 tree_9765 0.8192
Cp_9765 tree_9765 0 2.592e-15
Rtr_976_9766 tree_976 tree_9766 0.8192
Cp_9766 tree_9766 0 2.592e-15
Rtr_976_9767 tree_976 tree_9767 0.8192
Cp_9767 tree_9767 0 2.592e-15
Rtr_976_9768 tree_976 tree_9768 0.8192
Cp_9768 tree_9768 0 2.592e-15
Rtr_976_9769 tree_976 tree_9769 0.8192
Cp_9769 tree_9769 0 2.592e-15
Rtr_976_9770 tree_976 tree_9770 0.8192
Cp_9770 tree_9770 0 2.592e-15
Rtr_977_9771 tree_977 tree_9771 0.8192
Cp_9771 tree_9771 0 2.592e-15
Rtr_977_9772 tree_977 tree_9772 0.8192
Cp_9772 tree_9772 0 2.592e-15
Rtr_977_9773 tree_977 tree_9773 0.8192
Cp_9773 tree_9773 0 2.592e-15
Rtr_977_9774 tree_977 tree_9774 0.8192
Cp_9774 tree_9774 0 2.592e-15
Rtr_977_9775 tree_977 tree_9775 0.8192
Cp_9775 tree_9775 0 2.592e-15
Rtr_977_9776 tree_977 tree_9776 0.8192
Cp_9776 tree_9776 0 2.592e-15
Rtr_977_9777 tree_977 tree_9777 0.8192
Cp_9777 tree_9777 0 2.592e-15
Rtr_977_9778 tree_977 tree_9778 0.8192
Cp_9778 tree_9778 0 2.592e-15
Rtr_977_9779 tree_977 tree_9779 0.8192
Cp_9779 tree_9779 0 2.592e-15
Rtr_977_9780 tree_977 tree_9780 0.8192
Cp_9780 tree_9780 0 2.592e-15
Rtr_978_9781 tree_978 tree_9781 0.8192
Cp_9781 tree_9781 0 2.592e-15
Rtr_978_9782 tree_978 tree_9782 0.8192
Cp_9782 tree_9782 0 2.592e-15
Rtr_978_9783 tree_978 tree_9783 0.8192
Cp_9783 tree_9783 0 2.592e-15
Rtr_978_9784 tree_978 tree_9784 0.8192
Cp_9784 tree_9784 0 2.592e-15
Rtr_978_9785 tree_978 tree_9785 0.8192
Cp_9785 tree_9785 0 2.592e-15
Rtr_978_9786 tree_978 tree_9786 0.8192
Cp_9786 tree_9786 0 2.592e-15
Rtr_978_9787 tree_978 tree_9787 0.8192
Cp_9787 tree_9787 0 2.592e-15
Rtr_978_9788 tree_978 tree_9788 0.8192
Cp_9788 tree_9788 0 2.592e-15
Rtr_978_9789 tree_978 tree_9789 0.8192
Cp_9789 tree_9789 0 2.592e-15
Rtr_978_9790 tree_978 tree_9790 0.8192
Cp_9790 tree_9790 0 2.592e-15
Rtr_979_9791 tree_979 tree_9791 0.8192
Cp_9791 tree_9791 0 2.592e-15
Rtr_979_9792 tree_979 tree_9792 0.8192
Cp_9792 tree_9792 0 2.592e-15
Rtr_979_9793 tree_979 tree_9793 0.8192
Cp_9793 tree_9793 0 2.592e-15
Rtr_979_9794 tree_979 tree_9794 0.8192
Cp_9794 tree_9794 0 2.592e-15
Rtr_979_9795 tree_979 tree_9795 0.8192
Cp_9795 tree_9795 0 2.592e-15
Rtr_979_9796 tree_979 tree_9796 0.8192
Cp_9796 tree_9796 0 2.592e-15
Rtr_979_9797 tree_979 tree_9797 0.8192
Cp_9797 tree_9797 0 2.592e-15
Rtr_979_9798 tree_979 tree_9798 0.8192
Cp_9798 tree_9798 0 2.592e-15
Rtr_979_9799 tree_979 tree_9799 0.8192
Cp_9799 tree_9799 0 2.592e-15
Rtr_979_9800 tree_979 tree_9800 0.8192
Cp_9800 tree_9800 0 2.592e-15
Rtr_980_9801 tree_980 tree_9801 0.8192
Cp_9801 tree_9801 0 2.592e-15
Rtr_980_9802 tree_980 tree_9802 0.8192
Cp_9802 tree_9802 0 2.592e-15
Rtr_980_9803 tree_980 tree_9803 0.8192
Cp_9803 tree_9803 0 2.592e-15
Rtr_980_9804 tree_980 tree_9804 0.8192
Cp_9804 tree_9804 0 2.592e-15
Rtr_980_9805 tree_980 tree_9805 0.8192
Cp_9805 tree_9805 0 2.592e-15
Rtr_980_9806 tree_980 tree_9806 0.8192
Cp_9806 tree_9806 0 2.592e-15
Rtr_980_9807 tree_980 tree_9807 0.8192
Cp_9807 tree_9807 0 2.592e-15
Rtr_980_9808 tree_980 tree_9808 0.8192
Cp_9808 tree_9808 0 2.592e-15
Rtr_980_9809 tree_980 tree_9809 0.8192
Cp_9809 tree_9809 0 2.592e-15
Rtr_980_9810 tree_980 tree_9810 0.8192
Cp_9810 tree_9810 0 2.592e-15
Rtr_981_9811 tree_981 tree_9811 0.8192
Cp_9811 tree_9811 0 2.592e-15
Rtr_981_9812 tree_981 tree_9812 0.8192
Cp_9812 tree_9812 0 2.592e-15
Rtr_981_9813 tree_981 tree_9813 0.8192
Cp_9813 tree_9813 0 2.592e-15
Rtr_981_9814 tree_981 tree_9814 0.8192
Cp_9814 tree_9814 0 2.592e-15
Rtr_981_9815 tree_981 tree_9815 0.8192
Cp_9815 tree_9815 0 2.592e-15
Rtr_981_9816 tree_981 tree_9816 0.8192
Cp_9816 tree_9816 0 2.592e-15
Rtr_981_9817 tree_981 tree_9817 0.8192
Cp_9817 tree_9817 0 2.592e-15
Rtr_981_9818 tree_981 tree_9818 0.8192
Cp_9818 tree_9818 0 2.592e-15
Rtr_981_9819 tree_981 tree_9819 0.8192
Cp_9819 tree_9819 0 2.592e-15
Rtr_981_9820 tree_981 tree_9820 0.8192
Cp_9820 tree_9820 0 2.592e-15
Rtr_982_9821 tree_982 tree_9821 0.8192
Cp_9821 tree_9821 0 2.592e-15
Rtr_982_9822 tree_982 tree_9822 0.8192
Cp_9822 tree_9822 0 2.592e-15
Rtr_982_9823 tree_982 tree_9823 0.8192
Cp_9823 tree_9823 0 2.592e-15
Rtr_982_9824 tree_982 tree_9824 0.8192
Cp_9824 tree_9824 0 2.592e-15
Rtr_982_9825 tree_982 tree_9825 0.8192
Cp_9825 tree_9825 0 2.592e-15
Rtr_982_9826 tree_982 tree_9826 0.8192
Cp_9826 tree_9826 0 2.592e-15
Rtr_982_9827 tree_982 tree_9827 0.8192
Cp_9827 tree_9827 0 2.592e-15
Rtr_982_9828 tree_982 tree_9828 0.8192
Cp_9828 tree_9828 0 2.592e-15
Rtr_982_9829 tree_982 tree_9829 0.8192
Cp_9829 tree_9829 0 2.592e-15
Rtr_982_9830 tree_982 tree_9830 0.8192
Cp_9830 tree_9830 0 2.592e-15
Rtr_983_9831 tree_983 tree_9831 0.8192
Cp_9831 tree_9831 0 2.592e-15
Rtr_983_9832 tree_983 tree_9832 0.8192
Cp_9832 tree_9832 0 2.592e-15
Rtr_983_9833 tree_983 tree_9833 0.8192
Cp_9833 tree_9833 0 2.592e-15
Rtr_983_9834 tree_983 tree_9834 0.8192
Cp_9834 tree_9834 0 2.592e-15
Rtr_983_9835 tree_983 tree_9835 0.8192
Cp_9835 tree_9835 0 2.592e-15
Rtr_983_9836 tree_983 tree_9836 0.8192
Cp_9836 tree_9836 0 2.592e-15
Rtr_983_9837 tree_983 tree_9837 0.8192
Cp_9837 tree_9837 0 2.592e-15
Rtr_983_9838 tree_983 tree_9838 0.8192
Cp_9838 tree_9838 0 2.592e-15
Rtr_983_9839 tree_983 tree_9839 0.8192
Cp_9839 tree_9839 0 2.592e-15
Rtr_983_9840 tree_983 tree_9840 0.8192
Cp_9840 tree_9840 0 2.592e-15
Rtr_984_9841 tree_984 tree_9841 0.8192
Cp_9841 tree_9841 0 2.592e-15
Rtr_984_9842 tree_984 tree_9842 0.8192
Cp_9842 tree_9842 0 2.592e-15
Rtr_984_9843 tree_984 tree_9843 0.8192
Cp_9843 tree_9843 0 2.592e-15
Rtr_984_9844 tree_984 tree_9844 0.8192
Cp_9844 tree_9844 0 2.592e-15
Rtr_984_9845 tree_984 tree_9845 0.8192
Cp_9845 tree_9845 0 2.592e-15
Rtr_984_9846 tree_984 tree_9846 0.8192
Cp_9846 tree_9846 0 2.592e-15
Rtr_984_9847 tree_984 tree_9847 0.8192
Cp_9847 tree_9847 0 2.592e-15
Rtr_984_9848 tree_984 tree_9848 0.8192
Cp_9848 tree_9848 0 2.592e-15
Rtr_984_9849 tree_984 tree_9849 0.8192
Cp_9849 tree_9849 0 2.592e-15
Rtr_984_9850 tree_984 tree_9850 0.8192
Cp_9850 tree_9850 0 2.592e-15
Rtr_985_9851 tree_985 tree_9851 0.8192
Cp_9851 tree_9851 0 2.592e-15
Rtr_985_9852 tree_985 tree_9852 0.8192
Cp_9852 tree_9852 0 2.592e-15
Rtr_985_9853 tree_985 tree_9853 0.8192
Cp_9853 tree_9853 0 2.592e-15
Rtr_985_9854 tree_985 tree_9854 0.8192
Cp_9854 tree_9854 0 2.592e-15
Rtr_985_9855 tree_985 tree_9855 0.8192
Cp_9855 tree_9855 0 2.592e-15
Rtr_985_9856 tree_985 tree_9856 0.8192
Cp_9856 tree_9856 0 2.592e-15
Rtr_985_9857 tree_985 tree_9857 0.8192
Cp_9857 tree_9857 0 2.592e-15
Rtr_985_9858 tree_985 tree_9858 0.8192
Cp_9858 tree_9858 0 2.592e-15
Rtr_985_9859 tree_985 tree_9859 0.8192
Cp_9859 tree_9859 0 2.592e-15
Rtr_985_9860 tree_985 tree_9860 0.8192
Cp_9860 tree_9860 0 2.592e-15
Rtr_986_9861 tree_986 tree_9861 0.8192
Cp_9861 tree_9861 0 2.592e-15
Rtr_986_9862 tree_986 tree_9862 0.8192
Cp_9862 tree_9862 0 2.592e-15
Rtr_986_9863 tree_986 tree_9863 0.8192
Cp_9863 tree_9863 0 2.592e-15
Rtr_986_9864 tree_986 tree_9864 0.8192
Cp_9864 tree_9864 0 2.592e-15
Rtr_986_9865 tree_986 tree_9865 0.8192
Cp_9865 tree_9865 0 2.592e-15
Rtr_986_9866 tree_986 tree_9866 0.8192
Cp_9866 tree_9866 0 2.592e-15
Rtr_986_9867 tree_986 tree_9867 0.8192
Cp_9867 tree_9867 0 2.592e-15
Rtr_986_9868 tree_986 tree_9868 0.8192
Cp_9868 tree_9868 0 2.592e-15
Rtr_986_9869 tree_986 tree_9869 0.8192
Cp_9869 tree_9869 0 2.592e-15
Rtr_986_9870 tree_986 tree_9870 0.8192
Cp_9870 tree_9870 0 2.592e-15
Rtr_987_9871 tree_987 tree_9871 0.8192
Cp_9871 tree_9871 0 2.592e-15
Rtr_987_9872 tree_987 tree_9872 0.8192
Cp_9872 tree_9872 0 2.592e-15
Rtr_987_9873 tree_987 tree_9873 0.8192
Cp_9873 tree_9873 0 2.592e-15
Rtr_987_9874 tree_987 tree_9874 0.8192
Cp_9874 tree_9874 0 2.592e-15
Rtr_987_9875 tree_987 tree_9875 0.8192
Cp_9875 tree_9875 0 2.592e-15
Rtr_987_9876 tree_987 tree_9876 0.8192
Cp_9876 tree_9876 0 2.592e-15
Rtr_987_9877 tree_987 tree_9877 0.8192
Cp_9877 tree_9877 0 2.592e-15
Rtr_987_9878 tree_987 tree_9878 0.8192
Cp_9878 tree_9878 0 2.592e-15
Rtr_987_9879 tree_987 tree_9879 0.8192
Cp_9879 tree_9879 0 2.592e-15
Rtr_987_9880 tree_987 tree_9880 0.8192
Cp_9880 tree_9880 0 2.592e-15
Rtr_988_9881 tree_988 tree_9881 0.8192
Cp_9881 tree_9881 0 2.592e-15
Rtr_988_9882 tree_988 tree_9882 0.8192
Cp_9882 tree_9882 0 2.592e-15
Rtr_988_9883 tree_988 tree_9883 0.8192
Cp_9883 tree_9883 0 2.592e-15
Rtr_988_9884 tree_988 tree_9884 0.8192
Cp_9884 tree_9884 0 2.592e-15
Rtr_988_9885 tree_988 tree_9885 0.8192
Cp_9885 tree_9885 0 2.592e-15
Rtr_988_9886 tree_988 tree_9886 0.8192
Cp_9886 tree_9886 0 2.592e-15
Rtr_988_9887 tree_988 tree_9887 0.8192
Cp_9887 tree_9887 0 2.592e-15
Rtr_988_9888 tree_988 tree_9888 0.8192
Cp_9888 tree_9888 0 2.592e-15
Rtr_988_9889 tree_988 tree_9889 0.8192
Cp_9889 tree_9889 0 2.592e-15
Rtr_988_9890 tree_988 tree_9890 0.8192
Cp_9890 tree_9890 0 2.592e-15
Rtr_989_9891 tree_989 tree_9891 0.8192
Cp_9891 tree_9891 0 2.592e-15
Rtr_989_9892 tree_989 tree_9892 0.8192
Cp_9892 tree_9892 0 2.592e-15
Rtr_989_9893 tree_989 tree_9893 0.8192
Cp_9893 tree_9893 0 2.592e-15
Rtr_989_9894 tree_989 tree_9894 0.8192
Cp_9894 tree_9894 0 2.592e-15
Rtr_989_9895 tree_989 tree_9895 0.8192
Cp_9895 tree_9895 0 2.592e-15
Rtr_989_9896 tree_989 tree_9896 0.8192
Cp_9896 tree_9896 0 2.592e-15
Rtr_989_9897 tree_989 tree_9897 0.8192
Cp_9897 tree_9897 0 2.592e-15
Rtr_989_9898 tree_989 tree_9898 0.8192
Cp_9898 tree_9898 0 2.592e-15
Rtr_989_9899 tree_989 tree_9899 0.8192
Cp_9899 tree_9899 0 2.592e-15
Rtr_989_9900 tree_989 tree_9900 0.8192
Cp_9900 tree_9900 0 2.592e-15
Rtr_990_9901 tree_990 tree_9901 0.8192
Cp_9901 tree_9901 0 2.592e-15
Rtr_990_9902 tree_990 tree_9902 0.8192
Cp_9902 tree_9902 0 2.592e-15
Rtr_990_9903 tree_990 tree_9903 0.8192
Cp_9903 tree_9903 0 2.592e-15
Rtr_990_9904 tree_990 tree_9904 0.8192
Cp_9904 tree_9904 0 2.592e-15
Rtr_990_9905 tree_990 tree_9905 0.8192
Cp_9905 tree_9905 0 2.592e-15
Rtr_990_9906 tree_990 tree_9906 0.8192
Cp_9906 tree_9906 0 2.592e-15
Rtr_990_9907 tree_990 tree_9907 0.8192
Cp_9907 tree_9907 0 2.592e-15
Rtr_990_9908 tree_990 tree_9908 0.8192
Cp_9908 tree_9908 0 2.592e-15
Rtr_990_9909 tree_990 tree_9909 0.8192
Cp_9909 tree_9909 0 2.592e-15
Rtr_990_9910 tree_990 tree_9910 0.8192
Cp_9910 tree_9910 0 2.592e-15
Rtr_991_9911 tree_991 tree_9911 0.8192
Cp_9911 tree_9911 0 2.592e-15
Rtr_991_9912 tree_991 tree_9912 0.8192
Cp_9912 tree_9912 0 2.592e-15
Rtr_991_9913 tree_991 tree_9913 0.8192
Cp_9913 tree_9913 0 2.592e-15
Rtr_991_9914 tree_991 tree_9914 0.8192
Cp_9914 tree_9914 0 2.592e-15
Rtr_991_9915 tree_991 tree_9915 0.8192
Cp_9915 tree_9915 0 2.592e-15
Rtr_991_9916 tree_991 tree_9916 0.8192
Cp_9916 tree_9916 0 2.592e-15
Rtr_991_9917 tree_991 tree_9917 0.8192
Cp_9917 tree_9917 0 2.592e-15
Rtr_991_9918 tree_991 tree_9918 0.8192
Cp_9918 tree_9918 0 2.592e-15
Rtr_991_9919 tree_991 tree_9919 0.8192
Cp_9919 tree_9919 0 2.592e-15
Rtr_991_9920 tree_991 tree_9920 0.8192
Cp_9920 tree_9920 0 2.592e-15
Rtr_992_9921 tree_992 tree_9921 0.8192
Cp_9921 tree_9921 0 2.592e-15
Rtr_992_9922 tree_992 tree_9922 0.8192
Cp_9922 tree_9922 0 2.592e-15
Rtr_992_9923 tree_992 tree_9923 0.8192
Cp_9923 tree_9923 0 2.592e-15
Rtr_992_9924 tree_992 tree_9924 0.8192
Cp_9924 tree_9924 0 2.592e-15
Rtr_992_9925 tree_992 tree_9925 0.8192
Cp_9925 tree_9925 0 2.592e-15
Rtr_992_9926 tree_992 tree_9926 0.8192
Cp_9926 tree_9926 0 2.592e-15
Rtr_992_9927 tree_992 tree_9927 0.8192
Cp_9927 tree_9927 0 2.592e-15
Rtr_992_9928 tree_992 tree_9928 0.8192
Cp_9928 tree_9928 0 2.592e-15
Rtr_992_9929 tree_992 tree_9929 0.8192
Cp_9929 tree_9929 0 2.592e-15
Rtr_992_9930 tree_992 tree_9930 0.8192
Cp_9930 tree_9930 0 2.592e-15
Rtr_993_9931 tree_993 tree_9931 0.8192
Cp_9931 tree_9931 0 2.592e-15
Rtr_993_9932 tree_993 tree_9932 0.8192
Cp_9932 tree_9932 0 2.592e-15
Rtr_993_9933 tree_993 tree_9933 0.8192
Cp_9933 tree_9933 0 2.592e-15
Rtr_993_9934 tree_993 tree_9934 0.8192
Cp_9934 tree_9934 0 2.592e-15
Rtr_993_9935 tree_993 tree_9935 0.8192
Cp_9935 tree_9935 0 2.592e-15
Rtr_993_9936 tree_993 tree_9936 0.8192
Cp_9936 tree_9936 0 2.592e-15
Rtr_993_9937 tree_993 tree_9937 0.8192
Cp_9937 tree_9937 0 2.592e-15
Rtr_993_9938 tree_993 tree_9938 0.8192
Cp_9938 tree_9938 0 2.592e-15
Rtr_993_9939 tree_993 tree_9939 0.8192
Cp_9939 tree_9939 0 2.592e-15
Rtr_993_9940 tree_993 tree_9940 0.8192
Cp_9940 tree_9940 0 2.592e-15
Rtr_994_9941 tree_994 tree_9941 0.8192
Cp_9941 tree_9941 0 2.592e-15
Rtr_994_9942 tree_994 tree_9942 0.8192
Cp_9942 tree_9942 0 2.592e-15
Rtr_994_9943 tree_994 tree_9943 0.8192
Cp_9943 tree_9943 0 2.592e-15
Rtr_994_9944 tree_994 tree_9944 0.8192
Cp_9944 tree_9944 0 2.592e-15
Rtr_994_9945 tree_994 tree_9945 0.8192
Cp_9945 tree_9945 0 2.592e-15
Rtr_994_9946 tree_994 tree_9946 0.8192
Cp_9946 tree_9946 0 2.592e-15
Rtr_994_9947 tree_994 tree_9947 0.8192
Cp_9947 tree_9947 0 2.592e-15
Rtr_994_9948 tree_994 tree_9948 0.8192
Cp_9948 tree_9948 0 2.592e-15
Rtr_994_9949 tree_994 tree_9949 0.8192
Cp_9949 tree_9949 0 2.592e-15
Rtr_994_9950 tree_994 tree_9950 0.8192
Cp_9950 tree_9950 0 2.592e-15
Rtr_995_9951 tree_995 tree_9951 0.8192
Cp_9951 tree_9951 0 2.592e-15
Rtr_995_9952 tree_995 tree_9952 0.8192
Cp_9952 tree_9952 0 2.592e-15
Rtr_995_9953 tree_995 tree_9953 0.8192
Cp_9953 tree_9953 0 2.592e-15
Rtr_995_9954 tree_995 tree_9954 0.8192
Cp_9954 tree_9954 0 2.592e-15
Rtr_995_9955 tree_995 tree_9955 0.8192
Cp_9955 tree_9955 0 2.592e-15
Rtr_995_9956 tree_995 tree_9956 0.8192
Cp_9956 tree_9956 0 2.592e-15
Rtr_995_9957 tree_995 tree_9957 0.8192
Cp_9957 tree_9957 0 2.592e-15
Rtr_995_9958 tree_995 tree_9958 0.8192
Cp_9958 tree_9958 0 2.592e-15
Rtr_995_9959 tree_995 tree_9959 0.8192
Cp_9959 tree_9959 0 2.592e-15
Rtr_995_9960 tree_995 tree_9960 0.8192
Cp_9960 tree_9960 0 2.592e-15
Rtr_996_9961 tree_996 tree_9961 0.8192
Cp_9961 tree_9961 0 2.592e-15
Rtr_996_9962 tree_996 tree_9962 0.8192
Cp_9962 tree_9962 0 2.592e-15
Rtr_996_9963 tree_996 tree_9963 0.8192
Cp_9963 tree_9963 0 2.592e-15
Rtr_996_9964 tree_996 tree_9964 0.8192
Cp_9964 tree_9964 0 2.592e-15
Rtr_996_9965 tree_996 tree_9965 0.8192
Cp_9965 tree_9965 0 2.592e-15
Rtr_996_9966 tree_996 tree_9966 0.8192
Cp_9966 tree_9966 0 2.592e-15
Rtr_996_9967 tree_996 tree_9967 0.8192
Cp_9967 tree_9967 0 2.592e-15
Rtr_996_9968 tree_996 tree_9968 0.8192
Cp_9968 tree_9968 0 2.592e-15
Rtr_996_9969 tree_996 tree_9969 0.8192
Cp_9969 tree_9969 0 2.592e-15
Rtr_996_9970 tree_996 tree_9970 0.8192
Cp_9970 tree_9970 0 2.592e-15
Rtr_997_9971 tree_997 tree_9971 0.8192
Cp_9971 tree_9971 0 2.592e-15
Rtr_997_9972 tree_997 tree_9972 0.8192
Cp_9972 tree_9972 0 2.592e-15
Rtr_997_9973 tree_997 tree_9973 0.8192
Cp_9973 tree_9973 0 2.592e-15
Rtr_997_9974 tree_997 tree_9974 0.8192
Cp_9974 tree_9974 0 2.592e-15
Rtr_997_9975 tree_997 tree_9975 0.8192
Cp_9975 tree_9975 0 2.592e-15
Rtr_997_9976 tree_997 tree_9976 0.8192
Cp_9976 tree_9976 0 2.592e-15
Rtr_997_9977 tree_997 tree_9977 0.8192
Cp_9977 tree_9977 0 2.592e-15
Rtr_997_9978 tree_997 tree_9978 0.8192
Cp_9978 tree_9978 0 2.592e-15
Rtr_997_9979 tree_997 tree_9979 0.8192
Cp_9979 tree_9979 0 2.592e-15
Rtr_997_9980 tree_997 tree_9980 0.8192
Cp_9980 tree_9980 0 2.592e-15
Rtr_998_9981 tree_998 tree_9981 0.8192
Cp_9981 tree_9981 0 2.592e-15
Rtr_998_9982 tree_998 tree_9982 0.8192
Cp_9982 tree_9982 0 2.592e-15
Rtr_998_9983 tree_998 tree_9983 0.8192
Cp_9983 tree_9983 0 2.592e-15
Rtr_998_9984 tree_998 tree_9984 0.8192
Cp_9984 tree_9984 0 2.592e-15
Rtr_998_9985 tree_998 tree_9985 0.8192
Cp_9985 tree_9985 0 2.592e-15
Rtr_998_9986 tree_998 tree_9986 0.8192
Cp_9986 tree_9986 0 2.592e-15
Rtr_998_9987 tree_998 tree_9987 0.8192
Cp_9987 tree_9987 0 2.592e-15
Rtr_998_9988 tree_998 tree_9988 0.8192
Cp_9988 tree_9988 0 2.592e-15
Rtr_998_9989 tree_998 tree_9989 0.8192
Cp_9989 tree_9989 0 2.592e-15
Rtr_998_9990 tree_998 tree_9990 0.8192
Cp_9990 tree_9990 0 2.592e-15
Rtr_999_9991 tree_999 tree_9991 0.8192
Cp_9991 tree_9991 0 2.592e-15
Rtr_999_9992 tree_999 tree_9992 0.8192
Cp_9992 tree_9992 0 2.592e-15
Rtr_999_9993 tree_999 tree_9993 0.8192
Cp_9993 tree_9993 0 2.592e-15
Rtr_999_9994 tree_999 tree_9994 0.8192
Cp_9994 tree_9994 0 2.592e-15
Rtr_999_9995 tree_999 tree_9995 0.8192
Cp_9995 tree_9995 0 2.592e-15
Rtr_999_9996 tree_999 tree_9996 0.8192
Cp_9996 tree_9996 0 2.592e-15
Rtr_999_9997 tree_999 tree_9997 0.8192
Cp_9997 tree_9997 0 2.592e-15
Rtr_999_9998 tree_999 tree_9998 0.8192
Cp_9998 tree_9998 0 2.592e-15
Rtr_999_9999 tree_999 tree_9999 0.8192
Cp_9999 tree_9999 0 2.592e-15
Rtr_999_10000 tree_999 tree_10000 0.8192
Cp_10000 tree_10000 0 2.592e-15
Rtr_1000_10001 tree_1000 tree_10001 0.8192
Cp_10001 tree_10001 0 2.592e-15
Rtr_1000_10002 tree_1000 tree_10002 0.8192
Cp_10002 tree_10002 0 2.592e-15
Rtr_1000_10003 tree_1000 tree_10003 0.8192
Cp_10003 tree_10003 0 2.592e-15
Rtr_1000_10004 tree_1000 tree_10004 0.8192
Cp_10004 tree_10004 0 2.592e-15
Rtr_1000_10005 tree_1000 tree_10005 0.8192
Cp_10005 tree_10005 0 2.592e-15
Rtr_1000_10006 tree_1000 tree_10006 0.8192
Cp_10006 tree_10006 0 2.592e-15
Rtr_1000_10007 tree_1000 tree_10007 0.8192
Cp_10007 tree_10007 0 2.592e-15
Rtr_1000_10008 tree_1000 tree_10008 0.8192
Cp_10008 tree_10008 0 2.592e-15
Rtr_1000_10009 tree_1000 tree_10009 0.8192
Cp_10009 tree_10009 0 2.592e-15
Rtr_1000_10010 tree_1000 tree_10010 0.8192
Cp_10010 tree_10010 0 2.592e-15
Rtr_1001_10011 tree_1001 tree_10011 0.8192
Cp_10011 tree_10011 0 2.592e-15
Rtr_1001_10012 tree_1001 tree_10012 0.8192
Cp_10012 tree_10012 0 2.592e-15
Rtr_1001_10013 tree_1001 tree_10013 0.8192
Cp_10013 tree_10013 0 2.592e-15
Rtr_1001_10014 tree_1001 tree_10014 0.8192
Cp_10014 tree_10014 0 2.592e-15
Rtr_1001_10015 tree_1001 tree_10015 0.8192
Cp_10015 tree_10015 0 2.592e-15
Rtr_1001_10016 tree_1001 tree_10016 0.8192
Cp_10016 tree_10016 0 2.592e-15
Rtr_1001_10017 tree_1001 tree_10017 0.8192
Cp_10017 tree_10017 0 2.592e-15
Rtr_1001_10018 tree_1001 tree_10018 0.8192
Cp_10018 tree_10018 0 2.592e-15
Rtr_1001_10019 tree_1001 tree_10019 0.8192
Cp_10019 tree_10019 0 2.592e-15
Rtr_1001_10020 tree_1001 tree_10020 0.8192
Cp_10020 tree_10020 0 2.592e-15
Rtr_1002_10021 tree_1002 tree_10021 0.8192
Cp_10021 tree_10021 0 2.592e-15
Rtr_1002_10022 tree_1002 tree_10022 0.8192
Cp_10022 tree_10022 0 2.592e-15
Rtr_1002_10023 tree_1002 tree_10023 0.8192
Cp_10023 tree_10023 0 2.592e-15
Rtr_1002_10024 tree_1002 tree_10024 0.8192
Cp_10024 tree_10024 0 2.592e-15
Rtr_1002_10025 tree_1002 tree_10025 0.8192
Cp_10025 tree_10025 0 2.592e-15
Rtr_1002_10026 tree_1002 tree_10026 0.8192
Cp_10026 tree_10026 0 2.592e-15
Rtr_1002_10027 tree_1002 tree_10027 0.8192
Cp_10027 tree_10027 0 2.592e-15
Rtr_1002_10028 tree_1002 tree_10028 0.8192
Cp_10028 tree_10028 0 2.592e-15
Rtr_1002_10029 tree_1002 tree_10029 0.8192
Cp_10029 tree_10029 0 2.592e-15
Rtr_1002_10030 tree_1002 tree_10030 0.8192
Cp_10030 tree_10030 0 2.592e-15
Rtr_1003_10031 tree_1003 tree_10031 0.8192
Cp_10031 tree_10031 0 2.592e-15
Rtr_1003_10032 tree_1003 tree_10032 0.8192
Cp_10032 tree_10032 0 2.592e-15
Rtr_1003_10033 tree_1003 tree_10033 0.8192
Cp_10033 tree_10033 0 2.592e-15
Rtr_1003_10034 tree_1003 tree_10034 0.8192
Cp_10034 tree_10034 0 2.592e-15
Rtr_1003_10035 tree_1003 tree_10035 0.8192
Cp_10035 tree_10035 0 2.592e-15
Rtr_1003_10036 tree_1003 tree_10036 0.8192
Cp_10036 tree_10036 0 2.592e-15
Rtr_1003_10037 tree_1003 tree_10037 0.8192
Cp_10037 tree_10037 0 2.592e-15
Rtr_1003_10038 tree_1003 tree_10038 0.8192
Cp_10038 tree_10038 0 2.592e-15
Rtr_1003_10039 tree_1003 tree_10039 0.8192
Cp_10039 tree_10039 0 2.592e-15
Rtr_1003_10040 tree_1003 tree_10040 0.8192
Cp_10040 tree_10040 0 2.592e-15
Rtr_1004_10041 tree_1004 tree_10041 0.8192
Cp_10041 tree_10041 0 2.592e-15
Rtr_1004_10042 tree_1004 tree_10042 0.8192
Cp_10042 tree_10042 0 2.592e-15
Rtr_1004_10043 tree_1004 tree_10043 0.8192
Cp_10043 tree_10043 0 2.592e-15
Rtr_1004_10044 tree_1004 tree_10044 0.8192
Cp_10044 tree_10044 0 2.592e-15
Rtr_1004_10045 tree_1004 tree_10045 0.8192
Cp_10045 tree_10045 0 2.592e-15
Rtr_1004_10046 tree_1004 tree_10046 0.8192
Cp_10046 tree_10046 0 2.592e-15
Rtr_1004_10047 tree_1004 tree_10047 0.8192
Cp_10047 tree_10047 0 2.592e-15
Rtr_1004_10048 tree_1004 tree_10048 0.8192
Cp_10048 tree_10048 0 2.592e-15
Rtr_1004_10049 tree_1004 tree_10049 0.8192
Cp_10049 tree_10049 0 2.592e-15
Rtr_1004_10050 tree_1004 tree_10050 0.8192
Cp_10050 tree_10050 0 2.592e-15
Rtr_1005_10051 tree_1005 tree_10051 0.8192
Cp_10051 tree_10051 0 2.592e-15
Rtr_1005_10052 tree_1005 tree_10052 0.8192
Cp_10052 tree_10052 0 2.592e-15
Rtr_1005_10053 tree_1005 tree_10053 0.8192
Cp_10053 tree_10053 0 2.592e-15
Rtr_1005_10054 tree_1005 tree_10054 0.8192
Cp_10054 tree_10054 0 2.592e-15
Rtr_1005_10055 tree_1005 tree_10055 0.8192
Cp_10055 tree_10055 0 2.592e-15
Rtr_1005_10056 tree_1005 tree_10056 0.8192
Cp_10056 tree_10056 0 2.592e-15
Rtr_1005_10057 tree_1005 tree_10057 0.8192
Cp_10057 tree_10057 0 2.592e-15
Rtr_1005_10058 tree_1005 tree_10058 0.8192
Cp_10058 tree_10058 0 2.592e-15
Rtr_1005_10059 tree_1005 tree_10059 0.8192
Cp_10059 tree_10059 0 2.592e-15
Rtr_1005_10060 tree_1005 tree_10060 0.8192
Cp_10060 tree_10060 0 2.592e-15
Rtr_1006_10061 tree_1006 tree_10061 0.8192
Cp_10061 tree_10061 0 2.592e-15
Rtr_1006_10062 tree_1006 tree_10062 0.8192
Cp_10062 tree_10062 0 2.592e-15
Rtr_1006_10063 tree_1006 tree_10063 0.8192
Cp_10063 tree_10063 0 2.592e-15
Rtr_1006_10064 tree_1006 tree_10064 0.8192
Cp_10064 tree_10064 0 2.592e-15
Rtr_1006_10065 tree_1006 tree_10065 0.8192
Cp_10065 tree_10065 0 2.592e-15
Rtr_1006_10066 tree_1006 tree_10066 0.8192
Cp_10066 tree_10066 0 2.592e-15
Rtr_1006_10067 tree_1006 tree_10067 0.8192
Cp_10067 tree_10067 0 2.592e-15
Rtr_1006_10068 tree_1006 tree_10068 0.8192
Cp_10068 tree_10068 0 2.592e-15
Rtr_1006_10069 tree_1006 tree_10069 0.8192
Cp_10069 tree_10069 0 2.592e-15
Rtr_1006_10070 tree_1006 tree_10070 0.8192
Cp_10070 tree_10070 0 2.592e-15
Rtr_1007_10071 tree_1007 tree_10071 0.8192
Cp_10071 tree_10071 0 2.592e-15
Rtr_1007_10072 tree_1007 tree_10072 0.8192
Cp_10072 tree_10072 0 2.592e-15
Rtr_1007_10073 tree_1007 tree_10073 0.8192
Cp_10073 tree_10073 0 2.592e-15
Rtr_1007_10074 tree_1007 tree_10074 0.8192
Cp_10074 tree_10074 0 2.592e-15
Rtr_1007_10075 tree_1007 tree_10075 0.8192
Cp_10075 tree_10075 0 2.592e-15
Rtr_1007_10076 tree_1007 tree_10076 0.8192
Cp_10076 tree_10076 0 2.592e-15
Rtr_1007_10077 tree_1007 tree_10077 0.8192
Cp_10077 tree_10077 0 2.592e-15
Rtr_1007_10078 tree_1007 tree_10078 0.8192
Cp_10078 tree_10078 0 2.592e-15
Rtr_1007_10079 tree_1007 tree_10079 0.8192
Cp_10079 tree_10079 0 2.592e-15
Rtr_1007_10080 tree_1007 tree_10080 0.8192
Cp_10080 tree_10080 0 2.592e-15
Rtr_1008_10081 tree_1008 tree_10081 0.8192
Cp_10081 tree_10081 0 2.592e-15
Rtr_1008_10082 tree_1008 tree_10082 0.8192
Cp_10082 tree_10082 0 2.592e-15
Rtr_1008_10083 tree_1008 tree_10083 0.8192
Cp_10083 tree_10083 0 2.592e-15
Rtr_1008_10084 tree_1008 tree_10084 0.8192
Cp_10084 tree_10084 0 2.592e-15
Rtr_1008_10085 tree_1008 tree_10085 0.8192
Cp_10085 tree_10085 0 2.592e-15
Rtr_1008_10086 tree_1008 tree_10086 0.8192
Cp_10086 tree_10086 0 2.592e-15
Rtr_1008_10087 tree_1008 tree_10087 0.8192
Cp_10087 tree_10087 0 2.592e-15
Rtr_1008_10088 tree_1008 tree_10088 0.8192
Cp_10088 tree_10088 0 2.592e-15
Rtr_1008_10089 tree_1008 tree_10089 0.8192
Cp_10089 tree_10089 0 2.592e-15
Rtr_1008_10090 tree_1008 tree_10090 0.8192
Cp_10090 tree_10090 0 2.592e-15
Rtr_1009_10091 tree_1009 tree_10091 0.8192
Cp_10091 tree_10091 0 2.592e-15
Rtr_1009_10092 tree_1009 tree_10092 0.8192
Cp_10092 tree_10092 0 2.592e-15
Rtr_1009_10093 tree_1009 tree_10093 0.8192
Cp_10093 tree_10093 0 2.592e-15
Rtr_1009_10094 tree_1009 tree_10094 0.8192
Cp_10094 tree_10094 0 2.592e-15
Rtr_1009_10095 tree_1009 tree_10095 0.8192
Cp_10095 tree_10095 0 2.592e-15
Rtr_1009_10096 tree_1009 tree_10096 0.8192
Cp_10096 tree_10096 0 2.592e-15
Rtr_1009_10097 tree_1009 tree_10097 0.8192
Cp_10097 tree_10097 0 2.592e-15
Rtr_1009_10098 tree_1009 tree_10098 0.8192
Cp_10098 tree_10098 0 2.592e-15
Rtr_1009_10099 tree_1009 tree_10099 0.8192
Cp_10099 tree_10099 0 2.592e-15
Rtr_1009_10100 tree_1009 tree_10100 0.8192
Cp_10100 tree_10100 0 2.592e-15
Rtr_1010_10101 tree_1010 tree_10101 0.8192
Cp_10101 tree_10101 0 2.592e-15
Rtr_1010_10102 tree_1010 tree_10102 0.8192
Cp_10102 tree_10102 0 2.592e-15
Rtr_1010_10103 tree_1010 tree_10103 0.8192
Cp_10103 tree_10103 0 2.592e-15
Rtr_1010_10104 tree_1010 tree_10104 0.8192
Cp_10104 tree_10104 0 2.592e-15
Rtr_1010_10105 tree_1010 tree_10105 0.8192
Cp_10105 tree_10105 0 2.592e-15
Rtr_1010_10106 tree_1010 tree_10106 0.8192
Cp_10106 tree_10106 0 2.592e-15
Rtr_1010_10107 tree_1010 tree_10107 0.8192
Cp_10107 tree_10107 0 2.592e-15
Rtr_1010_10108 tree_1010 tree_10108 0.8192
Cp_10108 tree_10108 0 2.592e-15
Rtr_1010_10109 tree_1010 tree_10109 0.8192
Cp_10109 tree_10109 0 2.592e-15
Rtr_1010_10110 tree_1010 tree_10110 0.8192
Cp_10110 tree_10110 0 2.592e-15
Rtr_1011_10111 tree_1011 tree_10111 0.8192
Cp_10111 tree_10111 0 2.592e-15
Rtr_1011_10112 tree_1011 tree_10112 0.8192
Cp_10112 tree_10112 0 2.592e-15
Rtr_1011_10113 tree_1011 tree_10113 0.8192
Cp_10113 tree_10113 0 2.592e-15
Rtr_1011_10114 tree_1011 tree_10114 0.8192
Cp_10114 tree_10114 0 2.592e-15
Rtr_1011_10115 tree_1011 tree_10115 0.8192
Cp_10115 tree_10115 0 2.592e-15
Rtr_1011_10116 tree_1011 tree_10116 0.8192
Cp_10116 tree_10116 0 2.592e-15
Rtr_1011_10117 tree_1011 tree_10117 0.8192
Cp_10117 tree_10117 0 2.592e-15
Rtr_1011_10118 tree_1011 tree_10118 0.8192
Cp_10118 tree_10118 0 2.592e-15
Rtr_1011_10119 tree_1011 tree_10119 0.8192
Cp_10119 tree_10119 0 2.592e-15
Rtr_1011_10120 tree_1011 tree_10120 0.8192
Cp_10120 tree_10120 0 2.592e-15
Rtr_1012_10121 tree_1012 tree_10121 0.8192
Cp_10121 tree_10121 0 2.592e-15
Rtr_1012_10122 tree_1012 tree_10122 0.8192
Cp_10122 tree_10122 0 2.592e-15
Rtr_1012_10123 tree_1012 tree_10123 0.8192
Cp_10123 tree_10123 0 2.592e-15
Rtr_1012_10124 tree_1012 tree_10124 0.8192
Cp_10124 tree_10124 0 2.592e-15
Rtr_1012_10125 tree_1012 tree_10125 0.8192
Cp_10125 tree_10125 0 2.592e-15
Rtr_1012_10126 tree_1012 tree_10126 0.8192
Cp_10126 tree_10126 0 2.592e-15
Rtr_1012_10127 tree_1012 tree_10127 0.8192
Cp_10127 tree_10127 0 2.592e-15
Rtr_1012_10128 tree_1012 tree_10128 0.8192
Cp_10128 tree_10128 0 2.592e-15
Rtr_1012_10129 tree_1012 tree_10129 0.8192
Cp_10129 tree_10129 0 2.592e-15
Rtr_1012_10130 tree_1012 tree_10130 0.8192
Cp_10130 tree_10130 0 2.592e-15
Rtr_1013_10131 tree_1013 tree_10131 0.8192
Cp_10131 tree_10131 0 2.592e-15
Rtr_1013_10132 tree_1013 tree_10132 0.8192
Cp_10132 tree_10132 0 2.592e-15
Rtr_1013_10133 tree_1013 tree_10133 0.8192
Cp_10133 tree_10133 0 2.592e-15
Rtr_1013_10134 tree_1013 tree_10134 0.8192
Cp_10134 tree_10134 0 2.592e-15
Rtr_1013_10135 tree_1013 tree_10135 0.8192
Cp_10135 tree_10135 0 2.592e-15
Rtr_1013_10136 tree_1013 tree_10136 0.8192
Cp_10136 tree_10136 0 2.592e-15
Rtr_1013_10137 tree_1013 tree_10137 0.8192
Cp_10137 tree_10137 0 2.592e-15
Rtr_1013_10138 tree_1013 tree_10138 0.8192
Cp_10138 tree_10138 0 2.592e-15
Rtr_1013_10139 tree_1013 tree_10139 0.8192
Cp_10139 tree_10139 0 2.592e-15
Rtr_1013_10140 tree_1013 tree_10140 0.8192
Cp_10140 tree_10140 0 2.592e-15
Rtr_1014_10141 tree_1014 tree_10141 0.8192
Cp_10141 tree_10141 0 2.592e-15
Rtr_1014_10142 tree_1014 tree_10142 0.8192
Cp_10142 tree_10142 0 2.592e-15
Rtr_1014_10143 tree_1014 tree_10143 0.8192
Cp_10143 tree_10143 0 2.592e-15
Rtr_1014_10144 tree_1014 tree_10144 0.8192
Cp_10144 tree_10144 0 2.592e-15
Rtr_1014_10145 tree_1014 tree_10145 0.8192
Cp_10145 tree_10145 0 2.592e-15
Rtr_1014_10146 tree_1014 tree_10146 0.8192
Cp_10146 tree_10146 0 2.592e-15
Rtr_1014_10147 tree_1014 tree_10147 0.8192
Cp_10147 tree_10147 0 2.592e-15
Rtr_1014_10148 tree_1014 tree_10148 0.8192
Cp_10148 tree_10148 0 2.592e-15
Rtr_1014_10149 tree_1014 tree_10149 0.8192
Cp_10149 tree_10149 0 2.592e-15
Rtr_1014_10150 tree_1014 tree_10150 0.8192
Cp_10150 tree_10150 0 2.592e-15
Rtr_1015_10151 tree_1015 tree_10151 0.8192
Cp_10151 tree_10151 0 2.592e-15
Rtr_1015_10152 tree_1015 tree_10152 0.8192
Cp_10152 tree_10152 0 2.592e-15
Rtr_1015_10153 tree_1015 tree_10153 0.8192
Cp_10153 tree_10153 0 2.592e-15
Rtr_1015_10154 tree_1015 tree_10154 0.8192
Cp_10154 tree_10154 0 2.592e-15
Rtr_1015_10155 tree_1015 tree_10155 0.8192
Cp_10155 tree_10155 0 2.592e-15
Rtr_1015_10156 tree_1015 tree_10156 0.8192
Cp_10156 tree_10156 0 2.592e-15
Rtr_1015_10157 tree_1015 tree_10157 0.8192
Cp_10157 tree_10157 0 2.592e-15
Rtr_1015_10158 tree_1015 tree_10158 0.8192
Cp_10158 tree_10158 0 2.592e-15
Rtr_1015_10159 tree_1015 tree_10159 0.8192
Cp_10159 tree_10159 0 2.592e-15
Rtr_1015_10160 tree_1015 tree_10160 0.8192
Cp_10160 tree_10160 0 2.592e-15
Rtr_1016_10161 tree_1016 tree_10161 0.8192
Cp_10161 tree_10161 0 2.592e-15
Rtr_1016_10162 tree_1016 tree_10162 0.8192
Cp_10162 tree_10162 0 2.592e-15
Rtr_1016_10163 tree_1016 tree_10163 0.8192
Cp_10163 tree_10163 0 2.592e-15
Rtr_1016_10164 tree_1016 tree_10164 0.8192
Cp_10164 tree_10164 0 2.592e-15
Rtr_1016_10165 tree_1016 tree_10165 0.8192
Cp_10165 tree_10165 0 2.592e-15
Rtr_1016_10166 tree_1016 tree_10166 0.8192
Cp_10166 tree_10166 0 2.592e-15
Rtr_1016_10167 tree_1016 tree_10167 0.8192
Cp_10167 tree_10167 0 2.592e-15
Rtr_1016_10168 tree_1016 tree_10168 0.8192
Cp_10168 tree_10168 0 2.592e-15
Rtr_1016_10169 tree_1016 tree_10169 0.8192
Cp_10169 tree_10169 0 2.592e-15
Rtr_1016_10170 tree_1016 tree_10170 0.8192
Cp_10170 tree_10170 0 2.592e-15
Rtr_1017_10171 tree_1017 tree_10171 0.8192
Cp_10171 tree_10171 0 2.592e-15
Rtr_1017_10172 tree_1017 tree_10172 0.8192
Cp_10172 tree_10172 0 2.592e-15
Rtr_1017_10173 tree_1017 tree_10173 0.8192
Cp_10173 tree_10173 0 2.592e-15
Rtr_1017_10174 tree_1017 tree_10174 0.8192
Cp_10174 tree_10174 0 2.592e-15
Rtr_1017_10175 tree_1017 tree_10175 0.8192
Cp_10175 tree_10175 0 2.592e-15
Rtr_1017_10176 tree_1017 tree_10176 0.8192
Cp_10176 tree_10176 0 2.592e-15
Rtr_1017_10177 tree_1017 tree_10177 0.8192
Cp_10177 tree_10177 0 2.592e-15
Rtr_1017_10178 tree_1017 tree_10178 0.8192
Cp_10178 tree_10178 0 2.592e-15
Rtr_1017_10179 tree_1017 tree_10179 0.8192
Cp_10179 tree_10179 0 2.592e-15
Rtr_1017_10180 tree_1017 tree_10180 0.8192
Cp_10180 tree_10180 0 2.592e-15
Rtr_1018_10181 tree_1018 tree_10181 0.8192
Cp_10181 tree_10181 0 2.592e-15
Rtr_1018_10182 tree_1018 tree_10182 0.8192
Cp_10182 tree_10182 0 2.592e-15
Rtr_1018_10183 tree_1018 tree_10183 0.8192
Cp_10183 tree_10183 0 2.592e-15
Rtr_1018_10184 tree_1018 tree_10184 0.8192
Cp_10184 tree_10184 0 2.592e-15
Rtr_1018_10185 tree_1018 tree_10185 0.8192
Cp_10185 tree_10185 0 2.592e-15
Rtr_1018_10186 tree_1018 tree_10186 0.8192
Cp_10186 tree_10186 0 2.592e-15
Rtr_1018_10187 tree_1018 tree_10187 0.8192
Cp_10187 tree_10187 0 2.592e-15
Rtr_1018_10188 tree_1018 tree_10188 0.8192
Cp_10188 tree_10188 0 2.592e-15
Rtr_1018_10189 tree_1018 tree_10189 0.8192
Cp_10189 tree_10189 0 2.592e-15
Rtr_1018_10190 tree_1018 tree_10190 0.8192
Cp_10190 tree_10190 0 2.592e-15
Rtr_1019_10191 tree_1019 tree_10191 0.8192
Cp_10191 tree_10191 0 2.592e-15
Rtr_1019_10192 tree_1019 tree_10192 0.8192
Cp_10192 tree_10192 0 2.592e-15
Rtr_1019_10193 tree_1019 tree_10193 0.8192
Cp_10193 tree_10193 0 2.592e-15
Rtr_1019_10194 tree_1019 tree_10194 0.8192
Cp_10194 tree_10194 0 2.592e-15
Rtr_1019_10195 tree_1019 tree_10195 0.8192
Cp_10195 tree_10195 0 2.592e-15
Rtr_1019_10196 tree_1019 tree_10196 0.8192
Cp_10196 tree_10196 0 2.592e-15
Rtr_1019_10197 tree_1019 tree_10197 0.8192
Cp_10197 tree_10197 0 2.592e-15
Rtr_1019_10198 tree_1019 tree_10198 0.8192
Cp_10198 tree_10198 0 2.592e-15
Rtr_1019_10199 tree_1019 tree_10199 0.8192
Cp_10199 tree_10199 0 2.592e-15
Rtr_1019_10200 tree_1019 tree_10200 0.8192
Cp_10200 tree_10200 0 2.592e-15
Rtr_1020_10201 tree_1020 tree_10201 0.8192
Cp_10201 tree_10201 0 2.592e-15
Rtr_1020_10202 tree_1020 tree_10202 0.8192
Cp_10202 tree_10202 0 2.592e-15
Rtr_1020_10203 tree_1020 tree_10203 0.8192
Cp_10203 tree_10203 0 2.592e-15
Rtr_1020_10204 tree_1020 tree_10204 0.8192
Cp_10204 tree_10204 0 2.592e-15
Rtr_1020_10205 tree_1020 tree_10205 0.8192
Cp_10205 tree_10205 0 2.592e-15
Rtr_1020_10206 tree_1020 tree_10206 0.8192
Cp_10206 tree_10206 0 2.592e-15
Rtr_1020_10207 tree_1020 tree_10207 0.8192
Cp_10207 tree_10207 0 2.592e-15
Rtr_1020_10208 tree_1020 tree_10208 0.8192
Cp_10208 tree_10208 0 2.592e-15
Rtr_1020_10209 tree_1020 tree_10209 0.8192
Cp_10209 tree_10209 0 2.592e-15
Rtr_1020_10210 tree_1020 tree_10210 0.8192
Cp_10210 tree_10210 0 2.592e-15
Rtr_1021_10211 tree_1021 tree_10211 0.8192
Cp_10211 tree_10211 0 2.592e-15
Rtr_1021_10212 tree_1021 tree_10212 0.8192
Cp_10212 tree_10212 0 2.592e-15
Rtr_1021_10213 tree_1021 tree_10213 0.8192
Cp_10213 tree_10213 0 2.592e-15
Rtr_1021_10214 tree_1021 tree_10214 0.8192
Cp_10214 tree_10214 0 2.592e-15
Rtr_1021_10215 tree_1021 tree_10215 0.8192
Cp_10215 tree_10215 0 2.592e-15
Rtr_1021_10216 tree_1021 tree_10216 0.8192
Cp_10216 tree_10216 0 2.592e-15
Rtr_1021_10217 tree_1021 tree_10217 0.8192
Cp_10217 tree_10217 0 2.592e-15
Rtr_1021_10218 tree_1021 tree_10218 0.8192
Cp_10218 tree_10218 0 2.592e-15
Rtr_1021_10219 tree_1021 tree_10219 0.8192
Cp_10219 tree_10219 0 2.592e-15
Rtr_1021_10220 tree_1021 tree_10220 0.8192
Cp_10220 tree_10220 0 2.592e-15
Rtr_1022_10221 tree_1022 tree_10221 0.8192
Cp_10221 tree_10221 0 2.592e-15
Rtr_1022_10222 tree_1022 tree_10222 0.8192
Cp_10222 tree_10222 0 2.592e-15
Rtr_1022_10223 tree_1022 tree_10223 0.8192
Cp_10223 tree_10223 0 2.592e-15
Rtr_1022_10224 tree_1022 tree_10224 0.8192
Cp_10224 tree_10224 0 2.592e-15
Rtr_1022_10225 tree_1022 tree_10225 0.8192
Cp_10225 tree_10225 0 2.592e-15
Rtr_1022_10226 tree_1022 tree_10226 0.8192
Cp_10226 tree_10226 0 2.592e-15
Rtr_1022_10227 tree_1022 tree_10227 0.8192
Cp_10227 tree_10227 0 2.592e-15
Rtr_1022_10228 tree_1022 tree_10228 0.8192
Cp_10228 tree_10228 0 2.592e-15
Rtr_1022_10229 tree_1022 tree_10229 0.8192
Cp_10229 tree_10229 0 2.592e-15
Rtr_1022_10230 tree_1022 tree_10230 0.8192
Cp_10230 tree_10230 0 2.592e-15
Rtr_1023_10231 tree_1023 tree_10231 0.8192
Cp_10231 tree_10231 0 2.592e-15
Rtr_1023_10232 tree_1023 tree_10232 0.8192
Cp_10232 tree_10232 0 2.592e-15
Rtr_1023_10233 tree_1023 tree_10233 0.8192
Cp_10233 tree_10233 0 2.592e-15
Rtr_1023_10234 tree_1023 tree_10234 0.8192
Cp_10234 tree_10234 0 2.592e-15
Rtr_1023_10235 tree_1023 tree_10235 0.8192
Cp_10235 tree_10235 0 2.592e-15
Rtr_1023_10236 tree_1023 tree_10236 0.8192
Cp_10236 tree_10236 0 2.592e-15
Rtr_1023_10237 tree_1023 tree_10237 0.8192
Cp_10237 tree_10237 0 2.592e-15
Rtr_1023_10238 tree_1023 tree_10238 0.8192
Cp_10238 tree_10238 0 2.592e-15
Rtr_1023_10239 tree_1023 tree_10239 0.8192
Cp_10239 tree_10239 0 2.592e-15
Rtr_1023_10240 tree_1023 tree_10240 0.8192
Cp_10240 tree_10240 0 2.592e-15
Rtr_1024_10241 tree_1024 tree_10241 0.8192
Cp_10241 tree_10241 0 2.592e-15
Rtr_1024_10242 tree_1024 tree_10242 0.8192
Cp_10242 tree_10242 0 2.592e-15
Rtr_1024_10243 tree_1024 tree_10243 0.8192
Cp_10243 tree_10243 0 2.592e-15
Rtr_1024_10244 tree_1024 tree_10244 0.8192
Cp_10244 tree_10244 0 2.592e-15
Rtr_1024_10245 tree_1024 tree_10245 0.8192
Cp_10245 tree_10245 0 2.592e-15
Rtr_1024_10246 tree_1024 tree_10246 0.8192
Cp_10246 tree_10246 0 2.592e-15
Rtr_1024_10247 tree_1024 tree_10247 0.8192
Cp_10247 tree_10247 0 2.592e-15
Rtr_1024_10248 tree_1024 tree_10248 0.8192
Cp_10248 tree_10248 0 2.592e-15
Rtr_1024_10249 tree_1024 tree_10249 0.8192
Cp_10249 tree_10249 0 2.592e-15
Rtr_1024_10250 tree_1024 tree_10250 0.8192
Cp_10250 tree_10250 0 2.592e-15
Rtr_1025_10251 tree_1025 tree_10251 0.8192
Cp_10251 tree_10251 0 2.592e-15
Rtr_1025_10252 tree_1025 tree_10252 0.8192
Cp_10252 tree_10252 0 2.592e-15
Rtr_1025_10253 tree_1025 tree_10253 0.8192
Cp_10253 tree_10253 0 2.592e-15
Rtr_1025_10254 tree_1025 tree_10254 0.8192
Cp_10254 tree_10254 0 2.592e-15
Rtr_1025_10255 tree_1025 tree_10255 0.8192
Cp_10255 tree_10255 0 2.592e-15
Rtr_1025_10256 tree_1025 tree_10256 0.8192
Cp_10256 tree_10256 0 2.592e-15
Rtr_1025_10257 tree_1025 tree_10257 0.8192
Cp_10257 tree_10257 0 2.592e-15
Rtr_1025_10258 tree_1025 tree_10258 0.8192
Cp_10258 tree_10258 0 2.592e-15
Rtr_1025_10259 tree_1025 tree_10259 0.8192
Cp_10259 tree_10259 0 2.592e-15
Rtr_1025_10260 tree_1025 tree_10260 0.8192
Cp_10260 tree_10260 0 2.592e-15
Rtr_1026_10261 tree_1026 tree_10261 0.8192
Cp_10261 tree_10261 0 2.592e-15
Rtr_1026_10262 tree_1026 tree_10262 0.8192
Cp_10262 tree_10262 0 2.592e-15
Rtr_1026_10263 tree_1026 tree_10263 0.8192
Cp_10263 tree_10263 0 2.592e-15
Rtr_1026_10264 tree_1026 tree_10264 0.8192
Cp_10264 tree_10264 0 2.592e-15
Rtr_1026_10265 tree_1026 tree_10265 0.8192
Cp_10265 tree_10265 0 2.592e-15
Rtr_1026_10266 tree_1026 tree_10266 0.8192
Cp_10266 tree_10266 0 2.592e-15
Rtr_1026_10267 tree_1026 tree_10267 0.8192
Cp_10267 tree_10267 0 2.592e-15
Rtr_1026_10268 tree_1026 tree_10268 0.8192
Cp_10268 tree_10268 0 2.592e-15
Rtr_1026_10269 tree_1026 tree_10269 0.8192
Cp_10269 tree_10269 0 2.592e-15
Rtr_1026_10270 tree_1026 tree_10270 0.8192
Cp_10270 tree_10270 0 2.592e-15
Rtr_1027_10271 tree_1027 tree_10271 0.8192
Cp_10271 tree_10271 0 2.592e-15
Rtr_1027_10272 tree_1027 tree_10272 0.8192
Cp_10272 tree_10272 0 2.592e-15
Rtr_1027_10273 tree_1027 tree_10273 0.8192
Cp_10273 tree_10273 0 2.592e-15
Rtr_1027_10274 tree_1027 tree_10274 0.8192
Cp_10274 tree_10274 0 2.592e-15
Rtr_1027_10275 tree_1027 tree_10275 0.8192
Cp_10275 tree_10275 0 2.592e-15
Rtr_1027_10276 tree_1027 tree_10276 0.8192
Cp_10276 tree_10276 0 2.592e-15
Rtr_1027_10277 tree_1027 tree_10277 0.8192
Cp_10277 tree_10277 0 2.592e-15
Rtr_1027_10278 tree_1027 tree_10278 0.8192
Cp_10278 tree_10278 0 2.592e-15
Rtr_1027_10279 tree_1027 tree_10279 0.8192
Cp_10279 tree_10279 0 2.592e-15
Rtr_1027_10280 tree_1027 tree_10280 0.8192
Cp_10280 tree_10280 0 2.592e-15
Rtr_1028_10281 tree_1028 tree_10281 0.8192
Cp_10281 tree_10281 0 2.592e-15
Rtr_1028_10282 tree_1028 tree_10282 0.8192
Cp_10282 tree_10282 0 2.592e-15
Rtr_1028_10283 tree_1028 tree_10283 0.8192
Cp_10283 tree_10283 0 2.592e-15
Rtr_1028_10284 tree_1028 tree_10284 0.8192
Cp_10284 tree_10284 0 2.592e-15
Rtr_1028_10285 tree_1028 tree_10285 0.8192
Cp_10285 tree_10285 0 2.592e-15
Rtr_1028_10286 tree_1028 tree_10286 0.8192
Cp_10286 tree_10286 0 2.592e-15
Rtr_1028_10287 tree_1028 tree_10287 0.8192
Cp_10287 tree_10287 0 2.592e-15
Rtr_1028_10288 tree_1028 tree_10288 0.8192
Cp_10288 tree_10288 0 2.592e-15
Rtr_1028_10289 tree_1028 tree_10289 0.8192
Cp_10289 tree_10289 0 2.592e-15
Rtr_1028_10290 tree_1028 tree_10290 0.8192
Cp_10290 tree_10290 0 2.592e-15
Rtr_1029_10291 tree_1029 tree_10291 0.8192
Cp_10291 tree_10291 0 2.592e-15
Rtr_1029_10292 tree_1029 tree_10292 0.8192
Cp_10292 tree_10292 0 2.592e-15
Rtr_1029_10293 tree_1029 tree_10293 0.8192
Cp_10293 tree_10293 0 2.592e-15
Rtr_1029_10294 tree_1029 tree_10294 0.8192
Cp_10294 tree_10294 0 2.592e-15
Rtr_1029_10295 tree_1029 tree_10295 0.8192
Cp_10295 tree_10295 0 2.592e-15
Rtr_1029_10296 tree_1029 tree_10296 0.8192
Cp_10296 tree_10296 0 2.592e-15
Rtr_1029_10297 tree_1029 tree_10297 0.8192
Cp_10297 tree_10297 0 2.592e-15
Rtr_1029_10298 tree_1029 tree_10298 0.8192
Cp_10298 tree_10298 0 2.592e-15
Rtr_1029_10299 tree_1029 tree_10299 0.8192
Cp_10299 tree_10299 0 2.592e-15
Rtr_1029_10300 tree_1029 tree_10300 0.8192
Cp_10300 tree_10300 0 2.592e-15
Rtr_1030_10301 tree_1030 tree_10301 0.8192
Cp_10301 tree_10301 0 2.592e-15
Rtr_1030_10302 tree_1030 tree_10302 0.8192
Cp_10302 tree_10302 0 2.592e-15
Rtr_1030_10303 tree_1030 tree_10303 0.8192
Cp_10303 tree_10303 0 2.592e-15
Rtr_1030_10304 tree_1030 tree_10304 0.8192
Cp_10304 tree_10304 0 2.592e-15
Rtr_1030_10305 tree_1030 tree_10305 0.8192
Cp_10305 tree_10305 0 2.592e-15
Rtr_1030_10306 tree_1030 tree_10306 0.8192
Cp_10306 tree_10306 0 2.592e-15
Rtr_1030_10307 tree_1030 tree_10307 0.8192
Cp_10307 tree_10307 0 2.592e-15
Rtr_1030_10308 tree_1030 tree_10308 0.8192
Cp_10308 tree_10308 0 2.592e-15
Rtr_1030_10309 tree_1030 tree_10309 0.8192
Cp_10309 tree_10309 0 2.592e-15
Rtr_1030_10310 tree_1030 tree_10310 0.8192
Cp_10310 tree_10310 0 2.592e-15
Rtr_1031_10311 tree_1031 tree_10311 0.8192
Cp_10311 tree_10311 0 2.592e-15
Rtr_1031_10312 tree_1031 tree_10312 0.8192
Cp_10312 tree_10312 0 2.592e-15
Rtr_1031_10313 tree_1031 tree_10313 0.8192
Cp_10313 tree_10313 0 2.592e-15
Rtr_1031_10314 tree_1031 tree_10314 0.8192
Cp_10314 tree_10314 0 2.592e-15
Rtr_1031_10315 tree_1031 tree_10315 0.8192
Cp_10315 tree_10315 0 2.592e-15
Rtr_1031_10316 tree_1031 tree_10316 0.8192
Cp_10316 tree_10316 0 2.592e-15
Rtr_1031_10317 tree_1031 tree_10317 0.8192
Cp_10317 tree_10317 0 2.592e-15
Rtr_1031_10318 tree_1031 tree_10318 0.8192
Cp_10318 tree_10318 0 2.592e-15
Rtr_1031_10319 tree_1031 tree_10319 0.8192
Cp_10319 tree_10319 0 2.592e-15
Rtr_1031_10320 tree_1031 tree_10320 0.8192
Cp_10320 tree_10320 0 2.592e-15
Rtr_1032_10321 tree_1032 tree_10321 0.8192
Cp_10321 tree_10321 0 2.592e-15
Rtr_1032_10322 tree_1032 tree_10322 0.8192
Cp_10322 tree_10322 0 2.592e-15
Rtr_1032_10323 tree_1032 tree_10323 0.8192
Cp_10323 tree_10323 0 2.592e-15
Rtr_1032_10324 tree_1032 tree_10324 0.8192
Cp_10324 tree_10324 0 2.592e-15
Rtr_1032_10325 tree_1032 tree_10325 0.8192
Cp_10325 tree_10325 0 2.592e-15
Rtr_1032_10326 tree_1032 tree_10326 0.8192
Cp_10326 tree_10326 0 2.592e-15
Rtr_1032_10327 tree_1032 tree_10327 0.8192
Cp_10327 tree_10327 0 2.592e-15
Rtr_1032_10328 tree_1032 tree_10328 0.8192
Cp_10328 tree_10328 0 2.592e-15
Rtr_1032_10329 tree_1032 tree_10329 0.8192
Cp_10329 tree_10329 0 2.592e-15
Rtr_1032_10330 tree_1032 tree_10330 0.8192
Cp_10330 tree_10330 0 2.592e-15
Rtr_1033_10331 tree_1033 tree_10331 0.8192
Cp_10331 tree_10331 0 2.592e-15
Rtr_1033_10332 tree_1033 tree_10332 0.8192
Cp_10332 tree_10332 0 2.592e-15
Rtr_1033_10333 tree_1033 tree_10333 0.8192
Cp_10333 tree_10333 0 2.592e-15
Rtr_1033_10334 tree_1033 tree_10334 0.8192
Cp_10334 tree_10334 0 2.592e-15
Rtr_1033_10335 tree_1033 tree_10335 0.8192
Cp_10335 tree_10335 0 2.592e-15
Rtr_1033_10336 tree_1033 tree_10336 0.8192
Cp_10336 tree_10336 0 2.592e-15
Rtr_1033_10337 tree_1033 tree_10337 0.8192
Cp_10337 tree_10337 0 2.592e-15
Rtr_1033_10338 tree_1033 tree_10338 0.8192
Cp_10338 tree_10338 0 2.592e-15
Rtr_1033_10339 tree_1033 tree_10339 0.8192
Cp_10339 tree_10339 0 2.592e-15
Rtr_1033_10340 tree_1033 tree_10340 0.8192
Cp_10340 tree_10340 0 2.592e-15
Rtr_1034_10341 tree_1034 tree_10341 0.8192
Cp_10341 tree_10341 0 2.592e-15
Rtr_1034_10342 tree_1034 tree_10342 0.8192
Cp_10342 tree_10342 0 2.592e-15
Rtr_1034_10343 tree_1034 tree_10343 0.8192
Cp_10343 tree_10343 0 2.592e-15
Rtr_1034_10344 tree_1034 tree_10344 0.8192
Cp_10344 tree_10344 0 2.592e-15
Rtr_1034_10345 tree_1034 tree_10345 0.8192
Cp_10345 tree_10345 0 2.592e-15
Rtr_1034_10346 tree_1034 tree_10346 0.8192
Cp_10346 tree_10346 0 2.592e-15
Rtr_1034_10347 tree_1034 tree_10347 0.8192
Cp_10347 tree_10347 0 2.592e-15
Rtr_1034_10348 tree_1034 tree_10348 0.8192
Cp_10348 tree_10348 0 2.592e-15
Rtr_1034_10349 tree_1034 tree_10349 0.8192
Cp_10349 tree_10349 0 2.592e-15
Rtr_1034_10350 tree_1034 tree_10350 0.8192
Cp_10350 tree_10350 0 2.592e-15
Rtr_1035_10351 tree_1035 tree_10351 0.8192
Cp_10351 tree_10351 0 2.592e-15
Rtr_1035_10352 tree_1035 tree_10352 0.8192
Cp_10352 tree_10352 0 2.592e-15
Rtr_1035_10353 tree_1035 tree_10353 0.8192
Cp_10353 tree_10353 0 2.592e-15
Rtr_1035_10354 tree_1035 tree_10354 0.8192
Cp_10354 tree_10354 0 2.592e-15
Rtr_1035_10355 tree_1035 tree_10355 0.8192
Cp_10355 tree_10355 0 2.592e-15
Rtr_1035_10356 tree_1035 tree_10356 0.8192
Cp_10356 tree_10356 0 2.592e-15
Rtr_1035_10357 tree_1035 tree_10357 0.8192
Cp_10357 tree_10357 0 2.592e-15
Rtr_1035_10358 tree_1035 tree_10358 0.8192
Cp_10358 tree_10358 0 2.592e-15
Rtr_1035_10359 tree_1035 tree_10359 0.8192
Cp_10359 tree_10359 0 2.592e-15
Rtr_1035_10360 tree_1035 tree_10360 0.8192
Cp_10360 tree_10360 0 2.592e-15
Rtr_1036_10361 tree_1036 tree_10361 0.8192
Cp_10361 tree_10361 0 2.592e-15
Rtr_1036_10362 tree_1036 tree_10362 0.8192
Cp_10362 tree_10362 0 2.592e-15
Rtr_1036_10363 tree_1036 tree_10363 0.8192
Cp_10363 tree_10363 0 2.592e-15
Rtr_1036_10364 tree_1036 tree_10364 0.8192
Cp_10364 tree_10364 0 2.592e-15
Rtr_1036_10365 tree_1036 tree_10365 0.8192
Cp_10365 tree_10365 0 2.592e-15
Rtr_1036_10366 tree_1036 tree_10366 0.8192
Cp_10366 tree_10366 0 2.592e-15
Rtr_1036_10367 tree_1036 tree_10367 0.8192
Cp_10367 tree_10367 0 2.592e-15
Rtr_1036_10368 tree_1036 tree_10368 0.8192
Cp_10368 tree_10368 0 2.592e-15
Rtr_1036_10369 tree_1036 tree_10369 0.8192
Cp_10369 tree_10369 0 2.592e-15
Rtr_1036_10370 tree_1036 tree_10370 0.8192
Cp_10370 tree_10370 0 2.592e-15
Rtr_1037_10371 tree_1037 tree_10371 0.8192
Cp_10371 tree_10371 0 2.592e-15
Rtr_1037_10372 tree_1037 tree_10372 0.8192
Cp_10372 tree_10372 0 2.592e-15
Rtr_1037_10373 tree_1037 tree_10373 0.8192
Cp_10373 tree_10373 0 2.592e-15
Rtr_1037_10374 tree_1037 tree_10374 0.8192
Cp_10374 tree_10374 0 2.592e-15
Rtr_1037_10375 tree_1037 tree_10375 0.8192
Cp_10375 tree_10375 0 2.592e-15
Rtr_1037_10376 tree_1037 tree_10376 0.8192
Cp_10376 tree_10376 0 2.592e-15
Rtr_1037_10377 tree_1037 tree_10377 0.8192
Cp_10377 tree_10377 0 2.592e-15
Rtr_1037_10378 tree_1037 tree_10378 0.8192
Cp_10378 tree_10378 0 2.592e-15
Rtr_1037_10379 tree_1037 tree_10379 0.8192
Cp_10379 tree_10379 0 2.592e-15
Rtr_1037_10380 tree_1037 tree_10380 0.8192
Cp_10380 tree_10380 0 2.592e-15
Rtr_1038_10381 tree_1038 tree_10381 0.8192
Cp_10381 tree_10381 0 2.592e-15
Rtr_1038_10382 tree_1038 tree_10382 0.8192
Cp_10382 tree_10382 0 2.592e-15
Rtr_1038_10383 tree_1038 tree_10383 0.8192
Cp_10383 tree_10383 0 2.592e-15
Rtr_1038_10384 tree_1038 tree_10384 0.8192
Cp_10384 tree_10384 0 2.592e-15
Rtr_1038_10385 tree_1038 tree_10385 0.8192
Cp_10385 tree_10385 0 2.592e-15
Rtr_1038_10386 tree_1038 tree_10386 0.8192
Cp_10386 tree_10386 0 2.592e-15
Rtr_1038_10387 tree_1038 tree_10387 0.8192
Cp_10387 tree_10387 0 2.592e-15
Rtr_1038_10388 tree_1038 tree_10388 0.8192
Cp_10388 tree_10388 0 2.592e-15
Rtr_1038_10389 tree_1038 tree_10389 0.8192
Cp_10389 tree_10389 0 2.592e-15
Rtr_1038_10390 tree_1038 tree_10390 0.8192
Cp_10390 tree_10390 0 2.592e-15
Rtr_1039_10391 tree_1039 tree_10391 0.8192
Cp_10391 tree_10391 0 2.592e-15
Rtr_1039_10392 tree_1039 tree_10392 0.8192
Cp_10392 tree_10392 0 2.592e-15
Rtr_1039_10393 tree_1039 tree_10393 0.8192
Cp_10393 tree_10393 0 2.592e-15
Rtr_1039_10394 tree_1039 tree_10394 0.8192
Cp_10394 tree_10394 0 2.592e-15
Rtr_1039_10395 tree_1039 tree_10395 0.8192
Cp_10395 tree_10395 0 2.592e-15
Rtr_1039_10396 tree_1039 tree_10396 0.8192
Cp_10396 tree_10396 0 2.592e-15
Rtr_1039_10397 tree_1039 tree_10397 0.8192
Cp_10397 tree_10397 0 2.592e-15
Rtr_1039_10398 tree_1039 tree_10398 0.8192
Cp_10398 tree_10398 0 2.592e-15
Rtr_1039_10399 tree_1039 tree_10399 0.8192
Cp_10399 tree_10399 0 2.592e-15
Rtr_1039_10400 tree_1039 tree_10400 0.8192
Cp_10400 tree_10400 0 2.592e-15
Rtr_1040_10401 tree_1040 tree_10401 0.8192
Cp_10401 tree_10401 0 2.592e-15
Rtr_1040_10402 tree_1040 tree_10402 0.8192
Cp_10402 tree_10402 0 2.592e-15
Rtr_1040_10403 tree_1040 tree_10403 0.8192
Cp_10403 tree_10403 0 2.592e-15
Rtr_1040_10404 tree_1040 tree_10404 0.8192
Cp_10404 tree_10404 0 2.592e-15
Rtr_1040_10405 tree_1040 tree_10405 0.8192
Cp_10405 tree_10405 0 2.592e-15
Rtr_1040_10406 tree_1040 tree_10406 0.8192
Cp_10406 tree_10406 0 2.592e-15
Rtr_1040_10407 tree_1040 tree_10407 0.8192
Cp_10407 tree_10407 0 2.592e-15
Rtr_1040_10408 tree_1040 tree_10408 0.8192
Cp_10408 tree_10408 0 2.592e-15
Rtr_1040_10409 tree_1040 tree_10409 0.8192
Cp_10409 tree_10409 0 2.592e-15
Rtr_1040_10410 tree_1040 tree_10410 0.8192
Cp_10410 tree_10410 0 2.592e-15
Rtr_1041_10411 tree_1041 tree_10411 0.8192
Cp_10411 tree_10411 0 2.592e-15
Rtr_1041_10412 tree_1041 tree_10412 0.8192
Cp_10412 tree_10412 0 2.592e-15
Rtr_1041_10413 tree_1041 tree_10413 0.8192
Cp_10413 tree_10413 0 2.592e-15
Rtr_1041_10414 tree_1041 tree_10414 0.8192
Cp_10414 tree_10414 0 2.592e-15
Rtr_1041_10415 tree_1041 tree_10415 0.8192
Cp_10415 tree_10415 0 2.592e-15
Rtr_1041_10416 tree_1041 tree_10416 0.8192
Cp_10416 tree_10416 0 2.592e-15
Rtr_1041_10417 tree_1041 tree_10417 0.8192
Cp_10417 tree_10417 0 2.592e-15
Rtr_1041_10418 tree_1041 tree_10418 0.8192
Cp_10418 tree_10418 0 2.592e-15
Rtr_1041_10419 tree_1041 tree_10419 0.8192
Cp_10419 tree_10419 0 2.592e-15
Rtr_1041_10420 tree_1041 tree_10420 0.8192
Cp_10420 tree_10420 0 2.592e-15
Rtr_1042_10421 tree_1042 tree_10421 0.8192
Cp_10421 tree_10421 0 2.592e-15
Rtr_1042_10422 tree_1042 tree_10422 0.8192
Cp_10422 tree_10422 0 2.592e-15
Rtr_1042_10423 tree_1042 tree_10423 0.8192
Cp_10423 tree_10423 0 2.592e-15
Rtr_1042_10424 tree_1042 tree_10424 0.8192
Cp_10424 tree_10424 0 2.592e-15
Rtr_1042_10425 tree_1042 tree_10425 0.8192
Cp_10425 tree_10425 0 2.592e-15
Rtr_1042_10426 tree_1042 tree_10426 0.8192
Cp_10426 tree_10426 0 2.592e-15
Rtr_1042_10427 tree_1042 tree_10427 0.8192
Cp_10427 tree_10427 0 2.592e-15
Rtr_1042_10428 tree_1042 tree_10428 0.8192
Cp_10428 tree_10428 0 2.592e-15
Rtr_1042_10429 tree_1042 tree_10429 0.8192
Cp_10429 tree_10429 0 2.592e-15
Rtr_1042_10430 tree_1042 tree_10430 0.8192
Cp_10430 tree_10430 0 2.592e-15
Rtr_1043_10431 tree_1043 tree_10431 0.8192
Cp_10431 tree_10431 0 2.592e-15
Rtr_1043_10432 tree_1043 tree_10432 0.8192
Cp_10432 tree_10432 0 2.592e-15
Rtr_1043_10433 tree_1043 tree_10433 0.8192
Cp_10433 tree_10433 0 2.592e-15
Rtr_1043_10434 tree_1043 tree_10434 0.8192
Cp_10434 tree_10434 0 2.592e-15
Rtr_1043_10435 tree_1043 tree_10435 0.8192
Cp_10435 tree_10435 0 2.592e-15
Rtr_1043_10436 tree_1043 tree_10436 0.8192
Cp_10436 tree_10436 0 2.592e-15
Rtr_1043_10437 tree_1043 tree_10437 0.8192
Cp_10437 tree_10437 0 2.592e-15
Rtr_1043_10438 tree_1043 tree_10438 0.8192
Cp_10438 tree_10438 0 2.592e-15
Rtr_1043_10439 tree_1043 tree_10439 0.8192
Cp_10439 tree_10439 0 2.592e-15
Rtr_1043_10440 tree_1043 tree_10440 0.8192
Cp_10440 tree_10440 0 2.592e-15
Rtr_1044_10441 tree_1044 tree_10441 0.8192
Cp_10441 tree_10441 0 2.592e-15
Rtr_1044_10442 tree_1044 tree_10442 0.8192
Cp_10442 tree_10442 0 2.592e-15
Rtr_1044_10443 tree_1044 tree_10443 0.8192
Cp_10443 tree_10443 0 2.592e-15
Rtr_1044_10444 tree_1044 tree_10444 0.8192
Cp_10444 tree_10444 0 2.592e-15
Rtr_1044_10445 tree_1044 tree_10445 0.8192
Cp_10445 tree_10445 0 2.592e-15
Rtr_1044_10446 tree_1044 tree_10446 0.8192
Cp_10446 tree_10446 0 2.592e-15
Rtr_1044_10447 tree_1044 tree_10447 0.8192
Cp_10447 tree_10447 0 2.592e-15
Rtr_1044_10448 tree_1044 tree_10448 0.8192
Cp_10448 tree_10448 0 2.592e-15
Rtr_1044_10449 tree_1044 tree_10449 0.8192
Cp_10449 tree_10449 0 2.592e-15
Rtr_1044_10450 tree_1044 tree_10450 0.8192
Cp_10450 tree_10450 0 2.592e-15
Rtr_1045_10451 tree_1045 tree_10451 0.8192
Cp_10451 tree_10451 0 2.592e-15
Rtr_1045_10452 tree_1045 tree_10452 0.8192
Cp_10452 tree_10452 0 2.592e-15
Rtr_1045_10453 tree_1045 tree_10453 0.8192
Cp_10453 tree_10453 0 2.592e-15
Rtr_1045_10454 tree_1045 tree_10454 0.8192
Cp_10454 tree_10454 0 2.592e-15
Rtr_1045_10455 tree_1045 tree_10455 0.8192
Cp_10455 tree_10455 0 2.592e-15
Rtr_1045_10456 tree_1045 tree_10456 0.8192
Cp_10456 tree_10456 0 2.592e-15
Rtr_1045_10457 tree_1045 tree_10457 0.8192
Cp_10457 tree_10457 0 2.592e-15
Rtr_1045_10458 tree_1045 tree_10458 0.8192
Cp_10458 tree_10458 0 2.592e-15
Rtr_1045_10459 tree_1045 tree_10459 0.8192
Cp_10459 tree_10459 0 2.592e-15
Rtr_1045_10460 tree_1045 tree_10460 0.8192
Cp_10460 tree_10460 0 2.592e-15
Rtr_1046_10461 tree_1046 tree_10461 0.8192
Cp_10461 tree_10461 0 2.592e-15
Rtr_1046_10462 tree_1046 tree_10462 0.8192
Cp_10462 tree_10462 0 2.592e-15
Rtr_1046_10463 tree_1046 tree_10463 0.8192
Cp_10463 tree_10463 0 2.592e-15
Rtr_1046_10464 tree_1046 tree_10464 0.8192
Cp_10464 tree_10464 0 2.592e-15
Rtr_1046_10465 tree_1046 tree_10465 0.8192
Cp_10465 tree_10465 0 2.592e-15
Rtr_1046_10466 tree_1046 tree_10466 0.8192
Cp_10466 tree_10466 0 2.592e-15
Rtr_1046_10467 tree_1046 tree_10467 0.8192
Cp_10467 tree_10467 0 2.592e-15
Rtr_1046_10468 tree_1046 tree_10468 0.8192
Cp_10468 tree_10468 0 2.592e-15
Rtr_1046_10469 tree_1046 tree_10469 0.8192
Cp_10469 tree_10469 0 2.592e-15
Rtr_1046_10470 tree_1046 tree_10470 0.8192
Cp_10470 tree_10470 0 2.592e-15
Rtr_1047_10471 tree_1047 tree_10471 0.8192
Cp_10471 tree_10471 0 2.592e-15
Rtr_1047_10472 tree_1047 tree_10472 0.8192
Cp_10472 tree_10472 0 2.592e-15
Rtr_1047_10473 tree_1047 tree_10473 0.8192
Cp_10473 tree_10473 0 2.592e-15
Rtr_1047_10474 tree_1047 tree_10474 0.8192
Cp_10474 tree_10474 0 2.592e-15
Rtr_1047_10475 tree_1047 tree_10475 0.8192
Cp_10475 tree_10475 0 2.592e-15
Rtr_1047_10476 tree_1047 tree_10476 0.8192
Cp_10476 tree_10476 0 2.592e-15
Rtr_1047_10477 tree_1047 tree_10477 0.8192
Cp_10477 tree_10477 0 2.592e-15
Rtr_1047_10478 tree_1047 tree_10478 0.8192
Cp_10478 tree_10478 0 2.592e-15
Rtr_1047_10479 tree_1047 tree_10479 0.8192
Cp_10479 tree_10479 0 2.592e-15
Rtr_1047_10480 tree_1047 tree_10480 0.8192
Cp_10480 tree_10480 0 2.592e-15
Rtr_1048_10481 tree_1048 tree_10481 0.8192
Cp_10481 tree_10481 0 2.592e-15
Rtr_1048_10482 tree_1048 tree_10482 0.8192
Cp_10482 tree_10482 0 2.592e-15
Rtr_1048_10483 tree_1048 tree_10483 0.8192
Cp_10483 tree_10483 0 2.592e-15
Rtr_1048_10484 tree_1048 tree_10484 0.8192
Cp_10484 tree_10484 0 2.592e-15
Rtr_1048_10485 tree_1048 tree_10485 0.8192
Cp_10485 tree_10485 0 2.592e-15
Rtr_1048_10486 tree_1048 tree_10486 0.8192
Cp_10486 tree_10486 0 2.592e-15
Rtr_1048_10487 tree_1048 tree_10487 0.8192
Cp_10487 tree_10487 0 2.592e-15
Rtr_1048_10488 tree_1048 tree_10488 0.8192
Cp_10488 tree_10488 0 2.592e-15
Rtr_1048_10489 tree_1048 tree_10489 0.8192
Cp_10489 tree_10489 0 2.592e-15
Rtr_1048_10490 tree_1048 tree_10490 0.8192
Cp_10490 tree_10490 0 2.592e-15
Rtr_1049_10491 tree_1049 tree_10491 0.8192
Cp_10491 tree_10491 0 2.592e-15
Rtr_1049_10492 tree_1049 tree_10492 0.8192
Cp_10492 tree_10492 0 2.592e-15
Rtr_1049_10493 tree_1049 tree_10493 0.8192
Cp_10493 tree_10493 0 2.592e-15
Rtr_1049_10494 tree_1049 tree_10494 0.8192
Cp_10494 tree_10494 0 2.592e-15
Rtr_1049_10495 tree_1049 tree_10495 0.8192
Cp_10495 tree_10495 0 2.592e-15
Rtr_1049_10496 tree_1049 tree_10496 0.8192
Cp_10496 tree_10496 0 2.592e-15
Rtr_1049_10497 tree_1049 tree_10497 0.8192
Cp_10497 tree_10497 0 2.592e-15
Rtr_1049_10498 tree_1049 tree_10498 0.8192
Cp_10498 tree_10498 0 2.592e-15
Rtr_1049_10499 tree_1049 tree_10499 0.8192
Cp_10499 tree_10499 0 2.592e-15
Rtr_1049_10500 tree_1049 tree_10500 0.8192
Cp_10500 tree_10500 0 2.592e-15
Rtr_1050_10501 tree_1050 tree_10501 0.8192
Cp_10501 tree_10501 0 2.592e-15
Rtr_1050_10502 tree_1050 tree_10502 0.8192
Cp_10502 tree_10502 0 2.592e-15
Rtr_1050_10503 tree_1050 tree_10503 0.8192
Cp_10503 tree_10503 0 2.592e-15
Rtr_1050_10504 tree_1050 tree_10504 0.8192
Cp_10504 tree_10504 0 2.592e-15
Rtr_1050_10505 tree_1050 tree_10505 0.8192
Cp_10505 tree_10505 0 2.592e-15
Rtr_1050_10506 tree_1050 tree_10506 0.8192
Cp_10506 tree_10506 0 2.592e-15
Rtr_1050_10507 tree_1050 tree_10507 0.8192
Cp_10507 tree_10507 0 2.592e-15
Rtr_1050_10508 tree_1050 tree_10508 0.8192
Cp_10508 tree_10508 0 2.592e-15
Rtr_1050_10509 tree_1050 tree_10509 0.8192
Cp_10509 tree_10509 0 2.592e-15
Rtr_1050_10510 tree_1050 tree_10510 0.8192
Cp_10510 tree_10510 0 2.592e-15
Rtr_1051_10511 tree_1051 tree_10511 0.8192
Cp_10511 tree_10511 0 2.592e-15
Rtr_1051_10512 tree_1051 tree_10512 0.8192
Cp_10512 tree_10512 0 2.592e-15
Rtr_1051_10513 tree_1051 tree_10513 0.8192
Cp_10513 tree_10513 0 2.592e-15
Rtr_1051_10514 tree_1051 tree_10514 0.8192
Cp_10514 tree_10514 0 2.592e-15
Rtr_1051_10515 tree_1051 tree_10515 0.8192
Cp_10515 tree_10515 0 2.592e-15
Rtr_1051_10516 tree_1051 tree_10516 0.8192
Cp_10516 tree_10516 0 2.592e-15
Rtr_1051_10517 tree_1051 tree_10517 0.8192
Cp_10517 tree_10517 0 2.592e-15
Rtr_1051_10518 tree_1051 tree_10518 0.8192
Cp_10518 tree_10518 0 2.592e-15
Rtr_1051_10519 tree_1051 tree_10519 0.8192
Cp_10519 tree_10519 0 2.592e-15
Rtr_1051_10520 tree_1051 tree_10520 0.8192
Cp_10520 tree_10520 0 2.592e-15
Rtr_1052_10521 tree_1052 tree_10521 0.8192
Cp_10521 tree_10521 0 2.592e-15
Rtr_1052_10522 tree_1052 tree_10522 0.8192
Cp_10522 tree_10522 0 2.592e-15
Rtr_1052_10523 tree_1052 tree_10523 0.8192
Cp_10523 tree_10523 0 2.592e-15
Rtr_1052_10524 tree_1052 tree_10524 0.8192
Cp_10524 tree_10524 0 2.592e-15
Rtr_1052_10525 tree_1052 tree_10525 0.8192
Cp_10525 tree_10525 0 2.592e-15
Rtr_1052_10526 tree_1052 tree_10526 0.8192
Cp_10526 tree_10526 0 2.592e-15
Rtr_1052_10527 tree_1052 tree_10527 0.8192
Cp_10527 tree_10527 0 2.592e-15
Rtr_1052_10528 tree_1052 tree_10528 0.8192
Cp_10528 tree_10528 0 2.592e-15
Rtr_1052_10529 tree_1052 tree_10529 0.8192
Cp_10529 tree_10529 0 2.592e-15
Rtr_1052_10530 tree_1052 tree_10530 0.8192
Cp_10530 tree_10530 0 2.592e-15
Rtr_1053_10531 tree_1053 tree_10531 0.8192
Cp_10531 tree_10531 0 2.592e-15
Rtr_1053_10532 tree_1053 tree_10532 0.8192
Cp_10532 tree_10532 0 2.592e-15
Rtr_1053_10533 tree_1053 tree_10533 0.8192
Cp_10533 tree_10533 0 2.592e-15
Rtr_1053_10534 tree_1053 tree_10534 0.8192
Cp_10534 tree_10534 0 2.592e-15
Rtr_1053_10535 tree_1053 tree_10535 0.8192
Cp_10535 tree_10535 0 2.592e-15
Rtr_1053_10536 tree_1053 tree_10536 0.8192
Cp_10536 tree_10536 0 2.592e-15
Rtr_1053_10537 tree_1053 tree_10537 0.8192
Cp_10537 tree_10537 0 2.592e-15
Rtr_1053_10538 tree_1053 tree_10538 0.8192
Cp_10538 tree_10538 0 2.592e-15
Rtr_1053_10539 tree_1053 tree_10539 0.8192
Cp_10539 tree_10539 0 2.592e-15
Rtr_1053_10540 tree_1053 tree_10540 0.8192
Cp_10540 tree_10540 0 2.592e-15
Rtr_1054_10541 tree_1054 tree_10541 0.8192
Cp_10541 tree_10541 0 2.592e-15
Rtr_1054_10542 tree_1054 tree_10542 0.8192
Cp_10542 tree_10542 0 2.592e-15
Rtr_1054_10543 tree_1054 tree_10543 0.8192
Cp_10543 tree_10543 0 2.592e-15
Rtr_1054_10544 tree_1054 tree_10544 0.8192
Cp_10544 tree_10544 0 2.592e-15
Rtr_1054_10545 tree_1054 tree_10545 0.8192
Cp_10545 tree_10545 0 2.592e-15
Rtr_1054_10546 tree_1054 tree_10546 0.8192
Cp_10546 tree_10546 0 2.592e-15
Rtr_1054_10547 tree_1054 tree_10547 0.8192
Cp_10547 tree_10547 0 2.592e-15
Rtr_1054_10548 tree_1054 tree_10548 0.8192
Cp_10548 tree_10548 0 2.592e-15
Rtr_1054_10549 tree_1054 tree_10549 0.8192
Cp_10549 tree_10549 0 2.592e-15
Rtr_1054_10550 tree_1054 tree_10550 0.8192
Cp_10550 tree_10550 0 2.592e-15
Rtr_1055_10551 tree_1055 tree_10551 0.8192
Cp_10551 tree_10551 0 2.592e-15
Rtr_1055_10552 tree_1055 tree_10552 0.8192
Cp_10552 tree_10552 0 2.592e-15
Rtr_1055_10553 tree_1055 tree_10553 0.8192
Cp_10553 tree_10553 0 2.592e-15
Rtr_1055_10554 tree_1055 tree_10554 0.8192
Cp_10554 tree_10554 0 2.592e-15
Rtr_1055_10555 tree_1055 tree_10555 0.8192
Cp_10555 tree_10555 0 2.592e-15
Rtr_1055_10556 tree_1055 tree_10556 0.8192
Cp_10556 tree_10556 0 2.592e-15
Rtr_1055_10557 tree_1055 tree_10557 0.8192
Cp_10557 tree_10557 0 2.592e-15
Rtr_1055_10558 tree_1055 tree_10558 0.8192
Cp_10558 tree_10558 0 2.592e-15
Rtr_1055_10559 tree_1055 tree_10559 0.8192
Cp_10559 tree_10559 0 2.592e-15
Rtr_1055_10560 tree_1055 tree_10560 0.8192
Cp_10560 tree_10560 0 2.592e-15
Rtr_1056_10561 tree_1056 tree_10561 0.8192
Cp_10561 tree_10561 0 2.592e-15
Rtr_1056_10562 tree_1056 tree_10562 0.8192
Cp_10562 tree_10562 0 2.592e-15
Rtr_1056_10563 tree_1056 tree_10563 0.8192
Cp_10563 tree_10563 0 2.592e-15
Rtr_1056_10564 tree_1056 tree_10564 0.8192
Cp_10564 tree_10564 0 2.592e-15
Rtr_1056_10565 tree_1056 tree_10565 0.8192
Cp_10565 tree_10565 0 2.592e-15
Rtr_1056_10566 tree_1056 tree_10566 0.8192
Cp_10566 tree_10566 0 2.592e-15
Rtr_1056_10567 tree_1056 tree_10567 0.8192
Cp_10567 tree_10567 0 2.592e-15
Rtr_1056_10568 tree_1056 tree_10568 0.8192
Cp_10568 tree_10568 0 2.592e-15
Rtr_1056_10569 tree_1056 tree_10569 0.8192
Cp_10569 tree_10569 0 2.592e-15
Rtr_1056_10570 tree_1056 tree_10570 0.8192
Cp_10570 tree_10570 0 2.592e-15
Rtr_1057_10571 tree_1057 tree_10571 0.8192
Cp_10571 tree_10571 0 2.592e-15
Rtr_1057_10572 tree_1057 tree_10572 0.8192
Cp_10572 tree_10572 0 2.592e-15
Rtr_1057_10573 tree_1057 tree_10573 0.8192
Cp_10573 tree_10573 0 2.592e-15
Rtr_1057_10574 tree_1057 tree_10574 0.8192
Cp_10574 tree_10574 0 2.592e-15
Rtr_1057_10575 tree_1057 tree_10575 0.8192
Cp_10575 tree_10575 0 2.592e-15
Rtr_1057_10576 tree_1057 tree_10576 0.8192
Cp_10576 tree_10576 0 2.592e-15
Rtr_1057_10577 tree_1057 tree_10577 0.8192
Cp_10577 tree_10577 0 2.592e-15
Rtr_1057_10578 tree_1057 tree_10578 0.8192
Cp_10578 tree_10578 0 2.592e-15
Rtr_1057_10579 tree_1057 tree_10579 0.8192
Cp_10579 tree_10579 0 2.592e-15
Rtr_1057_10580 tree_1057 tree_10580 0.8192
Cp_10580 tree_10580 0 2.592e-15
Rtr_1058_10581 tree_1058 tree_10581 0.8192
Cp_10581 tree_10581 0 2.592e-15
Rtr_1058_10582 tree_1058 tree_10582 0.8192
Cp_10582 tree_10582 0 2.592e-15
Rtr_1058_10583 tree_1058 tree_10583 0.8192
Cp_10583 tree_10583 0 2.592e-15
Rtr_1058_10584 tree_1058 tree_10584 0.8192
Cp_10584 tree_10584 0 2.592e-15
Rtr_1058_10585 tree_1058 tree_10585 0.8192
Cp_10585 tree_10585 0 2.592e-15
Rtr_1058_10586 tree_1058 tree_10586 0.8192
Cp_10586 tree_10586 0 2.592e-15
Rtr_1058_10587 tree_1058 tree_10587 0.8192
Cp_10587 tree_10587 0 2.592e-15
Rtr_1058_10588 tree_1058 tree_10588 0.8192
Cp_10588 tree_10588 0 2.592e-15
Rtr_1058_10589 tree_1058 tree_10589 0.8192
Cp_10589 tree_10589 0 2.592e-15
Rtr_1058_10590 tree_1058 tree_10590 0.8192
Cp_10590 tree_10590 0 2.592e-15
Rtr_1059_10591 tree_1059 tree_10591 0.8192
Cp_10591 tree_10591 0 2.592e-15
Rtr_1059_10592 tree_1059 tree_10592 0.8192
Cp_10592 tree_10592 0 2.592e-15
Rtr_1059_10593 tree_1059 tree_10593 0.8192
Cp_10593 tree_10593 0 2.592e-15
Rtr_1059_10594 tree_1059 tree_10594 0.8192
Cp_10594 tree_10594 0 2.592e-15
Rtr_1059_10595 tree_1059 tree_10595 0.8192
Cp_10595 tree_10595 0 2.592e-15
Rtr_1059_10596 tree_1059 tree_10596 0.8192
Cp_10596 tree_10596 0 2.592e-15
Rtr_1059_10597 tree_1059 tree_10597 0.8192
Cp_10597 tree_10597 0 2.592e-15
Rtr_1059_10598 tree_1059 tree_10598 0.8192
Cp_10598 tree_10598 0 2.592e-15
Rtr_1059_10599 tree_1059 tree_10599 0.8192
Cp_10599 tree_10599 0 2.592e-15
Rtr_1059_10600 tree_1059 tree_10600 0.8192
Cp_10600 tree_10600 0 2.592e-15
Rtr_1060_10601 tree_1060 tree_10601 0.8192
Cp_10601 tree_10601 0 2.592e-15
Rtr_1060_10602 tree_1060 tree_10602 0.8192
Cp_10602 tree_10602 0 2.592e-15
Rtr_1060_10603 tree_1060 tree_10603 0.8192
Cp_10603 tree_10603 0 2.592e-15
Rtr_1060_10604 tree_1060 tree_10604 0.8192
Cp_10604 tree_10604 0 2.592e-15
Rtr_1060_10605 tree_1060 tree_10605 0.8192
Cp_10605 tree_10605 0 2.592e-15
Rtr_1060_10606 tree_1060 tree_10606 0.8192
Cp_10606 tree_10606 0 2.592e-15
Rtr_1060_10607 tree_1060 tree_10607 0.8192
Cp_10607 tree_10607 0 2.592e-15
Rtr_1060_10608 tree_1060 tree_10608 0.8192
Cp_10608 tree_10608 0 2.592e-15
Rtr_1060_10609 tree_1060 tree_10609 0.8192
Cp_10609 tree_10609 0 2.592e-15
Rtr_1060_10610 tree_1060 tree_10610 0.8192
Cp_10610 tree_10610 0 2.592e-15
Rtr_1061_10611 tree_1061 tree_10611 0.8192
Cp_10611 tree_10611 0 2.592e-15
Rtr_1061_10612 tree_1061 tree_10612 0.8192
Cp_10612 tree_10612 0 2.592e-15
Rtr_1061_10613 tree_1061 tree_10613 0.8192
Cp_10613 tree_10613 0 2.592e-15
Rtr_1061_10614 tree_1061 tree_10614 0.8192
Cp_10614 tree_10614 0 2.592e-15
Rtr_1061_10615 tree_1061 tree_10615 0.8192
Cp_10615 tree_10615 0 2.592e-15
Rtr_1061_10616 tree_1061 tree_10616 0.8192
Cp_10616 tree_10616 0 2.592e-15
Rtr_1061_10617 tree_1061 tree_10617 0.8192
Cp_10617 tree_10617 0 2.592e-15
Rtr_1061_10618 tree_1061 tree_10618 0.8192
Cp_10618 tree_10618 0 2.592e-15
Rtr_1061_10619 tree_1061 tree_10619 0.8192
Cp_10619 tree_10619 0 2.592e-15
Rtr_1061_10620 tree_1061 tree_10620 0.8192
Cp_10620 tree_10620 0 2.592e-15
Rtr_1062_10621 tree_1062 tree_10621 0.8192
Cp_10621 tree_10621 0 2.592e-15
Rtr_1062_10622 tree_1062 tree_10622 0.8192
Cp_10622 tree_10622 0 2.592e-15
Rtr_1062_10623 tree_1062 tree_10623 0.8192
Cp_10623 tree_10623 0 2.592e-15
Rtr_1062_10624 tree_1062 tree_10624 0.8192
Cp_10624 tree_10624 0 2.592e-15
Rtr_1062_10625 tree_1062 tree_10625 0.8192
Cp_10625 tree_10625 0 2.592e-15
Rtr_1062_10626 tree_1062 tree_10626 0.8192
Cp_10626 tree_10626 0 2.592e-15
Rtr_1062_10627 tree_1062 tree_10627 0.8192
Cp_10627 tree_10627 0 2.592e-15
Rtr_1062_10628 tree_1062 tree_10628 0.8192
Cp_10628 tree_10628 0 2.592e-15
Rtr_1062_10629 tree_1062 tree_10629 0.8192
Cp_10629 tree_10629 0 2.592e-15
Rtr_1062_10630 tree_1062 tree_10630 0.8192
Cp_10630 tree_10630 0 2.592e-15
Rtr_1063_10631 tree_1063 tree_10631 0.8192
Cp_10631 tree_10631 0 2.592e-15
Rtr_1063_10632 tree_1063 tree_10632 0.8192
Cp_10632 tree_10632 0 2.592e-15
Rtr_1063_10633 tree_1063 tree_10633 0.8192
Cp_10633 tree_10633 0 2.592e-15
Rtr_1063_10634 tree_1063 tree_10634 0.8192
Cp_10634 tree_10634 0 2.592e-15
Rtr_1063_10635 tree_1063 tree_10635 0.8192
Cp_10635 tree_10635 0 2.592e-15
Rtr_1063_10636 tree_1063 tree_10636 0.8192
Cp_10636 tree_10636 0 2.592e-15
Rtr_1063_10637 tree_1063 tree_10637 0.8192
Cp_10637 tree_10637 0 2.592e-15
Rtr_1063_10638 tree_1063 tree_10638 0.8192
Cp_10638 tree_10638 0 2.592e-15
Rtr_1063_10639 tree_1063 tree_10639 0.8192
Cp_10639 tree_10639 0 2.592e-15
Rtr_1063_10640 tree_1063 tree_10640 0.8192
Cp_10640 tree_10640 0 2.592e-15
Rtr_1064_10641 tree_1064 tree_10641 0.8192
Cp_10641 tree_10641 0 2.592e-15
Rtr_1064_10642 tree_1064 tree_10642 0.8192
Cp_10642 tree_10642 0 2.592e-15
Rtr_1064_10643 tree_1064 tree_10643 0.8192
Cp_10643 tree_10643 0 2.592e-15
Rtr_1064_10644 tree_1064 tree_10644 0.8192
Cp_10644 tree_10644 0 2.592e-15
Rtr_1064_10645 tree_1064 tree_10645 0.8192
Cp_10645 tree_10645 0 2.592e-15
Rtr_1064_10646 tree_1064 tree_10646 0.8192
Cp_10646 tree_10646 0 2.592e-15
Rtr_1064_10647 tree_1064 tree_10647 0.8192
Cp_10647 tree_10647 0 2.592e-15
Rtr_1064_10648 tree_1064 tree_10648 0.8192
Cp_10648 tree_10648 0 2.592e-15
Rtr_1064_10649 tree_1064 tree_10649 0.8192
Cp_10649 tree_10649 0 2.592e-15
Rtr_1064_10650 tree_1064 tree_10650 0.8192
Cp_10650 tree_10650 0 2.592e-15
Rtr_1065_10651 tree_1065 tree_10651 0.8192
Cp_10651 tree_10651 0 2.592e-15
Rtr_1065_10652 tree_1065 tree_10652 0.8192
Cp_10652 tree_10652 0 2.592e-15
Rtr_1065_10653 tree_1065 tree_10653 0.8192
Cp_10653 tree_10653 0 2.592e-15
Rtr_1065_10654 tree_1065 tree_10654 0.8192
Cp_10654 tree_10654 0 2.592e-15
Rtr_1065_10655 tree_1065 tree_10655 0.8192
Cp_10655 tree_10655 0 2.592e-15
Rtr_1065_10656 tree_1065 tree_10656 0.8192
Cp_10656 tree_10656 0 2.592e-15
Rtr_1065_10657 tree_1065 tree_10657 0.8192
Cp_10657 tree_10657 0 2.592e-15
Rtr_1065_10658 tree_1065 tree_10658 0.8192
Cp_10658 tree_10658 0 2.592e-15
Rtr_1065_10659 tree_1065 tree_10659 0.8192
Cp_10659 tree_10659 0 2.592e-15
Rtr_1065_10660 tree_1065 tree_10660 0.8192
Cp_10660 tree_10660 0 2.592e-15
Rtr_1066_10661 tree_1066 tree_10661 0.8192
Cp_10661 tree_10661 0 2.592e-15
Rtr_1066_10662 tree_1066 tree_10662 0.8192
Cp_10662 tree_10662 0 2.592e-15
Rtr_1066_10663 tree_1066 tree_10663 0.8192
Cp_10663 tree_10663 0 2.592e-15
Rtr_1066_10664 tree_1066 tree_10664 0.8192
Cp_10664 tree_10664 0 2.592e-15
Rtr_1066_10665 tree_1066 tree_10665 0.8192
Cp_10665 tree_10665 0 2.592e-15
Rtr_1066_10666 tree_1066 tree_10666 0.8192
Cp_10666 tree_10666 0 2.592e-15
Rtr_1066_10667 tree_1066 tree_10667 0.8192
Cp_10667 tree_10667 0 2.592e-15
Rtr_1066_10668 tree_1066 tree_10668 0.8192
Cp_10668 tree_10668 0 2.592e-15
Rtr_1066_10669 tree_1066 tree_10669 0.8192
Cp_10669 tree_10669 0 2.592e-15
Rtr_1066_10670 tree_1066 tree_10670 0.8192
Cp_10670 tree_10670 0 2.592e-15
Rtr_1067_10671 tree_1067 tree_10671 0.8192
Cp_10671 tree_10671 0 2.592e-15
Rtr_1067_10672 tree_1067 tree_10672 0.8192
Cp_10672 tree_10672 0 2.592e-15
Rtr_1067_10673 tree_1067 tree_10673 0.8192
Cp_10673 tree_10673 0 2.592e-15
Rtr_1067_10674 tree_1067 tree_10674 0.8192
Cp_10674 tree_10674 0 2.592e-15
Rtr_1067_10675 tree_1067 tree_10675 0.8192
Cp_10675 tree_10675 0 2.592e-15
Rtr_1067_10676 tree_1067 tree_10676 0.8192
Cp_10676 tree_10676 0 2.592e-15
Rtr_1067_10677 tree_1067 tree_10677 0.8192
Cp_10677 tree_10677 0 2.592e-15
Rtr_1067_10678 tree_1067 tree_10678 0.8192
Cp_10678 tree_10678 0 2.592e-15
Rtr_1067_10679 tree_1067 tree_10679 0.8192
Cp_10679 tree_10679 0 2.592e-15
Rtr_1067_10680 tree_1067 tree_10680 0.8192
Cp_10680 tree_10680 0 2.592e-15
Rtr_1068_10681 tree_1068 tree_10681 0.8192
Cp_10681 tree_10681 0 2.592e-15
Rtr_1068_10682 tree_1068 tree_10682 0.8192
Cp_10682 tree_10682 0 2.592e-15
Rtr_1068_10683 tree_1068 tree_10683 0.8192
Cp_10683 tree_10683 0 2.592e-15
Rtr_1068_10684 tree_1068 tree_10684 0.8192
Cp_10684 tree_10684 0 2.592e-15
Rtr_1068_10685 tree_1068 tree_10685 0.8192
Cp_10685 tree_10685 0 2.592e-15
Rtr_1068_10686 tree_1068 tree_10686 0.8192
Cp_10686 tree_10686 0 2.592e-15
Rtr_1068_10687 tree_1068 tree_10687 0.8192
Cp_10687 tree_10687 0 2.592e-15
Rtr_1068_10688 tree_1068 tree_10688 0.8192
Cp_10688 tree_10688 0 2.592e-15
Rtr_1068_10689 tree_1068 tree_10689 0.8192
Cp_10689 tree_10689 0 2.592e-15
Rtr_1068_10690 tree_1068 tree_10690 0.8192
Cp_10690 tree_10690 0 2.592e-15
Rtr_1069_10691 tree_1069 tree_10691 0.8192
Cp_10691 tree_10691 0 2.592e-15
Rtr_1069_10692 tree_1069 tree_10692 0.8192
Cp_10692 tree_10692 0 2.592e-15
Rtr_1069_10693 tree_1069 tree_10693 0.8192
Cp_10693 tree_10693 0 2.592e-15
Rtr_1069_10694 tree_1069 tree_10694 0.8192
Cp_10694 tree_10694 0 2.592e-15
Rtr_1069_10695 tree_1069 tree_10695 0.8192
Cp_10695 tree_10695 0 2.592e-15
Rtr_1069_10696 tree_1069 tree_10696 0.8192
Cp_10696 tree_10696 0 2.592e-15
Rtr_1069_10697 tree_1069 tree_10697 0.8192
Cp_10697 tree_10697 0 2.592e-15
Rtr_1069_10698 tree_1069 tree_10698 0.8192
Cp_10698 tree_10698 0 2.592e-15
Rtr_1069_10699 tree_1069 tree_10699 0.8192
Cp_10699 tree_10699 0 2.592e-15
Rtr_1069_10700 tree_1069 tree_10700 0.8192
Cp_10700 tree_10700 0 2.592e-15
Rtr_1070_10701 tree_1070 tree_10701 0.8192
Cp_10701 tree_10701 0 2.592e-15
Rtr_1070_10702 tree_1070 tree_10702 0.8192
Cp_10702 tree_10702 0 2.592e-15
Rtr_1070_10703 tree_1070 tree_10703 0.8192
Cp_10703 tree_10703 0 2.592e-15
Rtr_1070_10704 tree_1070 tree_10704 0.8192
Cp_10704 tree_10704 0 2.592e-15
Rtr_1070_10705 tree_1070 tree_10705 0.8192
Cp_10705 tree_10705 0 2.592e-15
Rtr_1070_10706 tree_1070 tree_10706 0.8192
Cp_10706 tree_10706 0 2.592e-15
Rtr_1070_10707 tree_1070 tree_10707 0.8192
Cp_10707 tree_10707 0 2.592e-15
Rtr_1070_10708 tree_1070 tree_10708 0.8192
Cp_10708 tree_10708 0 2.592e-15
Rtr_1070_10709 tree_1070 tree_10709 0.8192
Cp_10709 tree_10709 0 2.592e-15
Rtr_1070_10710 tree_1070 tree_10710 0.8192
Cp_10710 tree_10710 0 2.592e-15
Rtr_1071_10711 tree_1071 tree_10711 0.8192
Cp_10711 tree_10711 0 2.592e-15
Rtr_1071_10712 tree_1071 tree_10712 0.8192
Cp_10712 tree_10712 0 2.592e-15
Rtr_1071_10713 tree_1071 tree_10713 0.8192
Cp_10713 tree_10713 0 2.592e-15
Rtr_1071_10714 tree_1071 tree_10714 0.8192
Cp_10714 tree_10714 0 2.592e-15
Rtr_1071_10715 tree_1071 tree_10715 0.8192
Cp_10715 tree_10715 0 2.592e-15
Rtr_1071_10716 tree_1071 tree_10716 0.8192
Cp_10716 tree_10716 0 2.592e-15
Rtr_1071_10717 tree_1071 tree_10717 0.8192
Cp_10717 tree_10717 0 2.592e-15
Rtr_1071_10718 tree_1071 tree_10718 0.8192
Cp_10718 tree_10718 0 2.592e-15
Rtr_1071_10719 tree_1071 tree_10719 0.8192
Cp_10719 tree_10719 0 2.592e-15
Rtr_1071_10720 tree_1071 tree_10720 0.8192
Cp_10720 tree_10720 0 2.592e-15
Rtr_1072_10721 tree_1072 tree_10721 0.8192
Cp_10721 tree_10721 0 2.592e-15
Rtr_1072_10722 tree_1072 tree_10722 0.8192
Cp_10722 tree_10722 0 2.592e-15
Rtr_1072_10723 tree_1072 tree_10723 0.8192
Cp_10723 tree_10723 0 2.592e-15
Rtr_1072_10724 tree_1072 tree_10724 0.8192
Cp_10724 tree_10724 0 2.592e-15
Rtr_1072_10725 tree_1072 tree_10725 0.8192
Cp_10725 tree_10725 0 2.592e-15
Rtr_1072_10726 tree_1072 tree_10726 0.8192
Cp_10726 tree_10726 0 2.592e-15
Rtr_1072_10727 tree_1072 tree_10727 0.8192
Cp_10727 tree_10727 0 2.592e-15
Rtr_1072_10728 tree_1072 tree_10728 0.8192
Cp_10728 tree_10728 0 2.592e-15
Rtr_1072_10729 tree_1072 tree_10729 0.8192
Cp_10729 tree_10729 0 2.592e-15
Rtr_1072_10730 tree_1072 tree_10730 0.8192
Cp_10730 tree_10730 0 2.592e-15
Rtr_1073_10731 tree_1073 tree_10731 0.8192
Cp_10731 tree_10731 0 2.592e-15
Rtr_1073_10732 tree_1073 tree_10732 0.8192
Cp_10732 tree_10732 0 2.592e-15
Rtr_1073_10733 tree_1073 tree_10733 0.8192
Cp_10733 tree_10733 0 2.592e-15
Rtr_1073_10734 tree_1073 tree_10734 0.8192
Cp_10734 tree_10734 0 2.592e-15
Rtr_1073_10735 tree_1073 tree_10735 0.8192
Cp_10735 tree_10735 0 2.592e-15
Rtr_1073_10736 tree_1073 tree_10736 0.8192
Cp_10736 tree_10736 0 2.592e-15
Rtr_1073_10737 tree_1073 tree_10737 0.8192
Cp_10737 tree_10737 0 2.592e-15
Rtr_1073_10738 tree_1073 tree_10738 0.8192
Cp_10738 tree_10738 0 2.592e-15
Rtr_1073_10739 tree_1073 tree_10739 0.8192
Cp_10739 tree_10739 0 2.592e-15
Rtr_1073_10740 tree_1073 tree_10740 0.8192
Cp_10740 tree_10740 0 2.592e-15
Rtr_1074_10741 tree_1074 tree_10741 0.8192
Cp_10741 tree_10741 0 2.592e-15
Rtr_1074_10742 tree_1074 tree_10742 0.8192
Cp_10742 tree_10742 0 2.592e-15
Rtr_1074_10743 tree_1074 tree_10743 0.8192
Cp_10743 tree_10743 0 2.592e-15
Rtr_1074_10744 tree_1074 tree_10744 0.8192
Cp_10744 tree_10744 0 2.592e-15
Rtr_1074_10745 tree_1074 tree_10745 0.8192
Cp_10745 tree_10745 0 2.592e-15
Rtr_1074_10746 tree_1074 tree_10746 0.8192
Cp_10746 tree_10746 0 2.592e-15
Rtr_1074_10747 tree_1074 tree_10747 0.8192
Cp_10747 tree_10747 0 2.592e-15
Rtr_1074_10748 tree_1074 tree_10748 0.8192
Cp_10748 tree_10748 0 2.592e-15
Rtr_1074_10749 tree_1074 tree_10749 0.8192
Cp_10749 tree_10749 0 2.592e-15
Rtr_1074_10750 tree_1074 tree_10750 0.8192
Cp_10750 tree_10750 0 2.592e-15
Rtr_1075_10751 tree_1075 tree_10751 0.8192
Cp_10751 tree_10751 0 2.592e-15
Rtr_1075_10752 tree_1075 tree_10752 0.8192
Cp_10752 tree_10752 0 2.592e-15
Rtr_1075_10753 tree_1075 tree_10753 0.8192
Cp_10753 tree_10753 0 2.592e-15
Rtr_1075_10754 tree_1075 tree_10754 0.8192
Cp_10754 tree_10754 0 2.592e-15
Rtr_1075_10755 tree_1075 tree_10755 0.8192
Cp_10755 tree_10755 0 2.592e-15
Rtr_1075_10756 tree_1075 tree_10756 0.8192
Cp_10756 tree_10756 0 2.592e-15
Rtr_1075_10757 tree_1075 tree_10757 0.8192
Cp_10757 tree_10757 0 2.592e-15
Rtr_1075_10758 tree_1075 tree_10758 0.8192
Cp_10758 tree_10758 0 2.592e-15
Rtr_1075_10759 tree_1075 tree_10759 0.8192
Cp_10759 tree_10759 0 2.592e-15
Rtr_1075_10760 tree_1075 tree_10760 0.8192
Cp_10760 tree_10760 0 2.592e-15
Rtr_1076_10761 tree_1076 tree_10761 0.8192
Cp_10761 tree_10761 0 2.592e-15
Rtr_1076_10762 tree_1076 tree_10762 0.8192
Cp_10762 tree_10762 0 2.592e-15
Rtr_1076_10763 tree_1076 tree_10763 0.8192
Cp_10763 tree_10763 0 2.592e-15
Rtr_1076_10764 tree_1076 tree_10764 0.8192
Cp_10764 tree_10764 0 2.592e-15
Rtr_1076_10765 tree_1076 tree_10765 0.8192
Cp_10765 tree_10765 0 2.592e-15
Rtr_1076_10766 tree_1076 tree_10766 0.8192
Cp_10766 tree_10766 0 2.592e-15
Rtr_1076_10767 tree_1076 tree_10767 0.8192
Cp_10767 tree_10767 0 2.592e-15
Rtr_1076_10768 tree_1076 tree_10768 0.8192
Cp_10768 tree_10768 0 2.592e-15
Rtr_1076_10769 tree_1076 tree_10769 0.8192
Cp_10769 tree_10769 0 2.592e-15
Rtr_1076_10770 tree_1076 tree_10770 0.8192
Cp_10770 tree_10770 0 2.592e-15
Rtr_1077_10771 tree_1077 tree_10771 0.8192
Cp_10771 tree_10771 0 2.592e-15
Rtr_1077_10772 tree_1077 tree_10772 0.8192
Cp_10772 tree_10772 0 2.592e-15
Rtr_1077_10773 tree_1077 tree_10773 0.8192
Cp_10773 tree_10773 0 2.592e-15
Rtr_1077_10774 tree_1077 tree_10774 0.8192
Cp_10774 tree_10774 0 2.592e-15
Rtr_1077_10775 tree_1077 tree_10775 0.8192
Cp_10775 tree_10775 0 2.592e-15
Rtr_1077_10776 tree_1077 tree_10776 0.8192
Cp_10776 tree_10776 0 2.592e-15
Rtr_1077_10777 tree_1077 tree_10777 0.8192
Cp_10777 tree_10777 0 2.592e-15
Rtr_1077_10778 tree_1077 tree_10778 0.8192
Cp_10778 tree_10778 0 2.592e-15
Rtr_1077_10779 tree_1077 tree_10779 0.8192
Cp_10779 tree_10779 0 2.592e-15
Rtr_1077_10780 tree_1077 tree_10780 0.8192
Cp_10780 tree_10780 0 2.592e-15
Rtr_1078_10781 tree_1078 tree_10781 0.8192
Cp_10781 tree_10781 0 2.592e-15
Rtr_1078_10782 tree_1078 tree_10782 0.8192
Cp_10782 tree_10782 0 2.592e-15
Rtr_1078_10783 tree_1078 tree_10783 0.8192
Cp_10783 tree_10783 0 2.592e-15
Rtr_1078_10784 tree_1078 tree_10784 0.8192
Cp_10784 tree_10784 0 2.592e-15
Rtr_1078_10785 tree_1078 tree_10785 0.8192
Cp_10785 tree_10785 0 2.592e-15
Rtr_1078_10786 tree_1078 tree_10786 0.8192
Cp_10786 tree_10786 0 2.592e-15
Rtr_1078_10787 tree_1078 tree_10787 0.8192
Cp_10787 tree_10787 0 2.592e-15
Rtr_1078_10788 tree_1078 tree_10788 0.8192
Cp_10788 tree_10788 0 2.592e-15
Rtr_1078_10789 tree_1078 tree_10789 0.8192
Cp_10789 tree_10789 0 2.592e-15
Rtr_1078_10790 tree_1078 tree_10790 0.8192
Cp_10790 tree_10790 0 2.592e-15
Rtr_1079_10791 tree_1079 tree_10791 0.8192
Cp_10791 tree_10791 0 2.592e-15
Rtr_1079_10792 tree_1079 tree_10792 0.8192
Cp_10792 tree_10792 0 2.592e-15
Rtr_1079_10793 tree_1079 tree_10793 0.8192
Cp_10793 tree_10793 0 2.592e-15
Rtr_1079_10794 tree_1079 tree_10794 0.8192
Cp_10794 tree_10794 0 2.592e-15
Rtr_1079_10795 tree_1079 tree_10795 0.8192
Cp_10795 tree_10795 0 2.592e-15
Rtr_1079_10796 tree_1079 tree_10796 0.8192
Cp_10796 tree_10796 0 2.592e-15
Rtr_1079_10797 tree_1079 tree_10797 0.8192
Cp_10797 tree_10797 0 2.592e-15
Rtr_1079_10798 tree_1079 tree_10798 0.8192
Cp_10798 tree_10798 0 2.592e-15
Rtr_1079_10799 tree_1079 tree_10799 0.8192
Cp_10799 tree_10799 0 2.592e-15
Rtr_1079_10800 tree_1079 tree_10800 0.8192
Cp_10800 tree_10800 0 2.592e-15
Rtr_1080_10801 tree_1080 tree_10801 0.8192
Cp_10801 tree_10801 0 2.592e-15
Rtr_1080_10802 tree_1080 tree_10802 0.8192
Cp_10802 tree_10802 0 2.592e-15
Rtr_1080_10803 tree_1080 tree_10803 0.8192
Cp_10803 tree_10803 0 2.592e-15
Rtr_1080_10804 tree_1080 tree_10804 0.8192
Cp_10804 tree_10804 0 2.592e-15
Rtr_1080_10805 tree_1080 tree_10805 0.8192
Cp_10805 tree_10805 0 2.592e-15
Rtr_1080_10806 tree_1080 tree_10806 0.8192
Cp_10806 tree_10806 0 2.592e-15
Rtr_1080_10807 tree_1080 tree_10807 0.8192
Cp_10807 tree_10807 0 2.592e-15
Rtr_1080_10808 tree_1080 tree_10808 0.8192
Cp_10808 tree_10808 0 2.592e-15
Rtr_1080_10809 tree_1080 tree_10809 0.8192
Cp_10809 tree_10809 0 2.592e-15
Rtr_1080_10810 tree_1080 tree_10810 0.8192
Cp_10810 tree_10810 0 2.592e-15
Rtr_1081_10811 tree_1081 tree_10811 0.8192
Cp_10811 tree_10811 0 2.592e-15
Rtr_1081_10812 tree_1081 tree_10812 0.8192
Cp_10812 tree_10812 0 2.592e-15
Rtr_1081_10813 tree_1081 tree_10813 0.8192
Cp_10813 tree_10813 0 2.592e-15
Rtr_1081_10814 tree_1081 tree_10814 0.8192
Cp_10814 tree_10814 0 2.592e-15
Rtr_1081_10815 tree_1081 tree_10815 0.8192
Cp_10815 tree_10815 0 2.592e-15
Rtr_1081_10816 tree_1081 tree_10816 0.8192
Cp_10816 tree_10816 0 2.592e-15
Rtr_1081_10817 tree_1081 tree_10817 0.8192
Cp_10817 tree_10817 0 2.592e-15
Rtr_1081_10818 tree_1081 tree_10818 0.8192
Cp_10818 tree_10818 0 2.592e-15
Rtr_1081_10819 tree_1081 tree_10819 0.8192
Cp_10819 tree_10819 0 2.592e-15
Rtr_1081_10820 tree_1081 tree_10820 0.8192
Cp_10820 tree_10820 0 2.592e-15
Rtr_1082_10821 tree_1082 tree_10821 0.8192
Cp_10821 tree_10821 0 2.592e-15
Rtr_1082_10822 tree_1082 tree_10822 0.8192
Cp_10822 tree_10822 0 2.592e-15
Rtr_1082_10823 tree_1082 tree_10823 0.8192
Cp_10823 tree_10823 0 2.592e-15
Rtr_1082_10824 tree_1082 tree_10824 0.8192
Cp_10824 tree_10824 0 2.592e-15
Rtr_1082_10825 tree_1082 tree_10825 0.8192
Cp_10825 tree_10825 0 2.592e-15
Rtr_1082_10826 tree_1082 tree_10826 0.8192
Cp_10826 tree_10826 0 2.592e-15
Rtr_1082_10827 tree_1082 tree_10827 0.8192
Cp_10827 tree_10827 0 2.592e-15
Rtr_1082_10828 tree_1082 tree_10828 0.8192
Cp_10828 tree_10828 0 2.592e-15
Rtr_1082_10829 tree_1082 tree_10829 0.8192
Cp_10829 tree_10829 0 2.592e-15
Rtr_1082_10830 tree_1082 tree_10830 0.8192
Cp_10830 tree_10830 0 2.592e-15
Rtr_1083_10831 tree_1083 tree_10831 0.8192
Cp_10831 tree_10831 0 2.592e-15
Rtr_1083_10832 tree_1083 tree_10832 0.8192
Cp_10832 tree_10832 0 2.592e-15
Rtr_1083_10833 tree_1083 tree_10833 0.8192
Cp_10833 tree_10833 0 2.592e-15
Rtr_1083_10834 tree_1083 tree_10834 0.8192
Cp_10834 tree_10834 0 2.592e-15
Rtr_1083_10835 tree_1083 tree_10835 0.8192
Cp_10835 tree_10835 0 2.592e-15
Rtr_1083_10836 tree_1083 tree_10836 0.8192
Cp_10836 tree_10836 0 2.592e-15
Rtr_1083_10837 tree_1083 tree_10837 0.8192
Cp_10837 tree_10837 0 2.592e-15
Rtr_1083_10838 tree_1083 tree_10838 0.8192
Cp_10838 tree_10838 0 2.592e-15
Rtr_1083_10839 tree_1083 tree_10839 0.8192
Cp_10839 tree_10839 0 2.592e-15
Rtr_1083_10840 tree_1083 tree_10840 0.8192
Cp_10840 tree_10840 0 2.592e-15
Rtr_1084_10841 tree_1084 tree_10841 0.8192
Cp_10841 tree_10841 0 2.592e-15
Rtr_1084_10842 tree_1084 tree_10842 0.8192
Cp_10842 tree_10842 0 2.592e-15
Rtr_1084_10843 tree_1084 tree_10843 0.8192
Cp_10843 tree_10843 0 2.592e-15
Rtr_1084_10844 tree_1084 tree_10844 0.8192
Cp_10844 tree_10844 0 2.592e-15
Rtr_1084_10845 tree_1084 tree_10845 0.8192
Cp_10845 tree_10845 0 2.592e-15
Rtr_1084_10846 tree_1084 tree_10846 0.8192
Cp_10846 tree_10846 0 2.592e-15
Rtr_1084_10847 tree_1084 tree_10847 0.8192
Cp_10847 tree_10847 0 2.592e-15
Rtr_1084_10848 tree_1084 tree_10848 0.8192
Cp_10848 tree_10848 0 2.592e-15
Rtr_1084_10849 tree_1084 tree_10849 0.8192
Cp_10849 tree_10849 0 2.592e-15
Rtr_1084_10850 tree_1084 tree_10850 0.8192
Cp_10850 tree_10850 0 2.592e-15
Rtr_1085_10851 tree_1085 tree_10851 0.8192
Cp_10851 tree_10851 0 2.592e-15
Rtr_1085_10852 tree_1085 tree_10852 0.8192
Cp_10852 tree_10852 0 2.592e-15
Rtr_1085_10853 tree_1085 tree_10853 0.8192
Cp_10853 tree_10853 0 2.592e-15
Rtr_1085_10854 tree_1085 tree_10854 0.8192
Cp_10854 tree_10854 0 2.592e-15
Rtr_1085_10855 tree_1085 tree_10855 0.8192
Cp_10855 tree_10855 0 2.592e-15
Rtr_1085_10856 tree_1085 tree_10856 0.8192
Cp_10856 tree_10856 0 2.592e-15
Rtr_1085_10857 tree_1085 tree_10857 0.8192
Cp_10857 tree_10857 0 2.592e-15
Rtr_1085_10858 tree_1085 tree_10858 0.8192
Cp_10858 tree_10858 0 2.592e-15
Rtr_1085_10859 tree_1085 tree_10859 0.8192
Cp_10859 tree_10859 0 2.592e-15
Rtr_1085_10860 tree_1085 tree_10860 0.8192
Cp_10860 tree_10860 0 2.592e-15
Rtr_1086_10861 tree_1086 tree_10861 0.8192
Cp_10861 tree_10861 0 2.592e-15
Rtr_1086_10862 tree_1086 tree_10862 0.8192
Cp_10862 tree_10862 0 2.592e-15
Rtr_1086_10863 tree_1086 tree_10863 0.8192
Cp_10863 tree_10863 0 2.592e-15
Rtr_1086_10864 tree_1086 tree_10864 0.8192
Cp_10864 tree_10864 0 2.592e-15
Rtr_1086_10865 tree_1086 tree_10865 0.8192
Cp_10865 tree_10865 0 2.592e-15
Rtr_1086_10866 tree_1086 tree_10866 0.8192
Cp_10866 tree_10866 0 2.592e-15
Rtr_1086_10867 tree_1086 tree_10867 0.8192
Cp_10867 tree_10867 0 2.592e-15
Rtr_1086_10868 tree_1086 tree_10868 0.8192
Cp_10868 tree_10868 0 2.592e-15
Rtr_1086_10869 tree_1086 tree_10869 0.8192
Cp_10869 tree_10869 0 2.592e-15
Rtr_1086_10870 tree_1086 tree_10870 0.8192
Cp_10870 tree_10870 0 2.592e-15
Rtr_1087_10871 tree_1087 tree_10871 0.8192
Cp_10871 tree_10871 0 2.592e-15
Rtr_1087_10872 tree_1087 tree_10872 0.8192
Cp_10872 tree_10872 0 2.592e-15
Rtr_1087_10873 tree_1087 tree_10873 0.8192
Cp_10873 tree_10873 0 2.592e-15
Rtr_1087_10874 tree_1087 tree_10874 0.8192
Cp_10874 tree_10874 0 2.592e-15
Rtr_1087_10875 tree_1087 tree_10875 0.8192
Cp_10875 tree_10875 0 2.592e-15
Rtr_1087_10876 tree_1087 tree_10876 0.8192
Cp_10876 tree_10876 0 2.592e-15
Rtr_1087_10877 tree_1087 tree_10877 0.8192
Cp_10877 tree_10877 0 2.592e-15
Rtr_1087_10878 tree_1087 tree_10878 0.8192
Cp_10878 tree_10878 0 2.592e-15
Rtr_1087_10879 tree_1087 tree_10879 0.8192
Cp_10879 tree_10879 0 2.592e-15
Rtr_1087_10880 tree_1087 tree_10880 0.8192
Cp_10880 tree_10880 0 2.592e-15
Rtr_1088_10881 tree_1088 tree_10881 0.8192
Cp_10881 tree_10881 0 2.592e-15
Rtr_1088_10882 tree_1088 tree_10882 0.8192
Cp_10882 tree_10882 0 2.592e-15
Rtr_1088_10883 tree_1088 tree_10883 0.8192
Cp_10883 tree_10883 0 2.592e-15
Rtr_1088_10884 tree_1088 tree_10884 0.8192
Cp_10884 tree_10884 0 2.592e-15
Rtr_1088_10885 tree_1088 tree_10885 0.8192
Cp_10885 tree_10885 0 2.592e-15
Rtr_1088_10886 tree_1088 tree_10886 0.8192
Cp_10886 tree_10886 0 2.592e-15
Rtr_1088_10887 tree_1088 tree_10887 0.8192
Cp_10887 tree_10887 0 2.592e-15
Rtr_1088_10888 tree_1088 tree_10888 0.8192
Cp_10888 tree_10888 0 2.592e-15
Rtr_1088_10889 tree_1088 tree_10889 0.8192
Cp_10889 tree_10889 0 2.592e-15
Rtr_1088_10890 tree_1088 tree_10890 0.8192
Cp_10890 tree_10890 0 2.592e-15
Rtr_1089_10891 tree_1089 tree_10891 0.8192
Cp_10891 tree_10891 0 2.592e-15
Rtr_1089_10892 tree_1089 tree_10892 0.8192
Cp_10892 tree_10892 0 2.592e-15
Rtr_1089_10893 tree_1089 tree_10893 0.8192
Cp_10893 tree_10893 0 2.592e-15
Rtr_1089_10894 tree_1089 tree_10894 0.8192
Cp_10894 tree_10894 0 2.592e-15
Rtr_1089_10895 tree_1089 tree_10895 0.8192
Cp_10895 tree_10895 0 2.592e-15
Rtr_1089_10896 tree_1089 tree_10896 0.8192
Cp_10896 tree_10896 0 2.592e-15
Rtr_1089_10897 tree_1089 tree_10897 0.8192
Cp_10897 tree_10897 0 2.592e-15
Rtr_1089_10898 tree_1089 tree_10898 0.8192
Cp_10898 tree_10898 0 2.592e-15
Rtr_1089_10899 tree_1089 tree_10899 0.8192
Cp_10899 tree_10899 0 2.592e-15
Rtr_1089_10900 tree_1089 tree_10900 0.8192
Cp_10900 tree_10900 0 2.592e-15
Rtr_1090_10901 tree_1090 tree_10901 0.8192
Cp_10901 tree_10901 0 2.592e-15
Rtr_1090_10902 tree_1090 tree_10902 0.8192
Cp_10902 tree_10902 0 2.592e-15
Rtr_1090_10903 tree_1090 tree_10903 0.8192
Cp_10903 tree_10903 0 2.592e-15
Rtr_1090_10904 tree_1090 tree_10904 0.8192
Cp_10904 tree_10904 0 2.592e-15
Rtr_1090_10905 tree_1090 tree_10905 0.8192
Cp_10905 tree_10905 0 2.592e-15
Rtr_1090_10906 tree_1090 tree_10906 0.8192
Cp_10906 tree_10906 0 2.592e-15
Rtr_1090_10907 tree_1090 tree_10907 0.8192
Cp_10907 tree_10907 0 2.592e-15
Rtr_1090_10908 tree_1090 tree_10908 0.8192
Cp_10908 tree_10908 0 2.592e-15
Rtr_1090_10909 tree_1090 tree_10909 0.8192
Cp_10909 tree_10909 0 2.592e-15
Rtr_1090_10910 tree_1090 tree_10910 0.8192
Cp_10910 tree_10910 0 2.592e-15
Rtr_1091_10911 tree_1091 tree_10911 0.8192
Cp_10911 tree_10911 0 2.592e-15
Rtr_1091_10912 tree_1091 tree_10912 0.8192
Cp_10912 tree_10912 0 2.592e-15
Rtr_1091_10913 tree_1091 tree_10913 0.8192
Cp_10913 tree_10913 0 2.592e-15
Rtr_1091_10914 tree_1091 tree_10914 0.8192
Cp_10914 tree_10914 0 2.592e-15
Rtr_1091_10915 tree_1091 tree_10915 0.8192
Cp_10915 tree_10915 0 2.592e-15
Rtr_1091_10916 tree_1091 tree_10916 0.8192
Cp_10916 tree_10916 0 2.592e-15
Rtr_1091_10917 tree_1091 tree_10917 0.8192
Cp_10917 tree_10917 0 2.592e-15
Rtr_1091_10918 tree_1091 tree_10918 0.8192
Cp_10918 tree_10918 0 2.592e-15
Rtr_1091_10919 tree_1091 tree_10919 0.8192
Cp_10919 tree_10919 0 2.592e-15
Rtr_1091_10920 tree_1091 tree_10920 0.8192
Cp_10920 tree_10920 0 2.592e-15
Rtr_1092_10921 tree_1092 tree_10921 0.8192
Cp_10921 tree_10921 0 2.592e-15
Rtr_1092_10922 tree_1092 tree_10922 0.8192
Cp_10922 tree_10922 0 2.592e-15
Rtr_1092_10923 tree_1092 tree_10923 0.8192
Cp_10923 tree_10923 0 2.592e-15
Rtr_1092_10924 tree_1092 tree_10924 0.8192
Cp_10924 tree_10924 0 2.592e-15
Rtr_1092_10925 tree_1092 tree_10925 0.8192
Cp_10925 tree_10925 0 2.592e-15
Rtr_1092_10926 tree_1092 tree_10926 0.8192
Cp_10926 tree_10926 0 2.592e-15
Rtr_1092_10927 tree_1092 tree_10927 0.8192
Cp_10927 tree_10927 0 2.592e-15
Rtr_1092_10928 tree_1092 tree_10928 0.8192
Cp_10928 tree_10928 0 2.592e-15
Rtr_1092_10929 tree_1092 tree_10929 0.8192
Cp_10929 tree_10929 0 2.592e-15
Rtr_1092_10930 tree_1092 tree_10930 0.8192
Cp_10930 tree_10930 0 2.592e-15
Rtr_1093_10931 tree_1093 tree_10931 0.8192
Cp_10931 tree_10931 0 2.592e-15
Rtr_1093_10932 tree_1093 tree_10932 0.8192
Cp_10932 tree_10932 0 2.592e-15
Rtr_1093_10933 tree_1093 tree_10933 0.8192
Cp_10933 tree_10933 0 2.592e-15
Rtr_1093_10934 tree_1093 tree_10934 0.8192
Cp_10934 tree_10934 0 2.592e-15
Rtr_1093_10935 tree_1093 tree_10935 0.8192
Cp_10935 tree_10935 0 2.592e-15
Rtr_1093_10936 tree_1093 tree_10936 0.8192
Cp_10936 tree_10936 0 2.592e-15
Rtr_1093_10937 tree_1093 tree_10937 0.8192
Cp_10937 tree_10937 0 2.592e-15
Rtr_1093_10938 tree_1093 tree_10938 0.8192
Cp_10938 tree_10938 0 2.592e-15
Rtr_1093_10939 tree_1093 tree_10939 0.8192
Cp_10939 tree_10939 0 2.592e-15
Rtr_1093_10940 tree_1093 tree_10940 0.8192
Cp_10940 tree_10940 0 2.592e-15
Rtr_1094_10941 tree_1094 tree_10941 0.8192
Cp_10941 tree_10941 0 2.592e-15
Rtr_1094_10942 tree_1094 tree_10942 0.8192
Cp_10942 tree_10942 0 2.592e-15
Rtr_1094_10943 tree_1094 tree_10943 0.8192
Cp_10943 tree_10943 0 2.592e-15
Rtr_1094_10944 tree_1094 tree_10944 0.8192
Cp_10944 tree_10944 0 2.592e-15
Rtr_1094_10945 tree_1094 tree_10945 0.8192
Cp_10945 tree_10945 0 2.592e-15
Rtr_1094_10946 tree_1094 tree_10946 0.8192
Cp_10946 tree_10946 0 2.592e-15
Rtr_1094_10947 tree_1094 tree_10947 0.8192
Cp_10947 tree_10947 0 2.592e-15
Rtr_1094_10948 tree_1094 tree_10948 0.8192
Cp_10948 tree_10948 0 2.592e-15
Rtr_1094_10949 tree_1094 tree_10949 0.8192
Cp_10949 tree_10949 0 2.592e-15
Rtr_1094_10950 tree_1094 tree_10950 0.8192
Cp_10950 tree_10950 0 2.592e-15
Rtr_1095_10951 tree_1095 tree_10951 0.8192
Cp_10951 tree_10951 0 2.592e-15
Rtr_1095_10952 tree_1095 tree_10952 0.8192
Cp_10952 tree_10952 0 2.592e-15
Rtr_1095_10953 tree_1095 tree_10953 0.8192
Cp_10953 tree_10953 0 2.592e-15
Rtr_1095_10954 tree_1095 tree_10954 0.8192
Cp_10954 tree_10954 0 2.592e-15
Rtr_1095_10955 tree_1095 tree_10955 0.8192
Cp_10955 tree_10955 0 2.592e-15
Rtr_1095_10956 tree_1095 tree_10956 0.8192
Cp_10956 tree_10956 0 2.592e-15
Rtr_1095_10957 tree_1095 tree_10957 0.8192
Cp_10957 tree_10957 0 2.592e-15
Rtr_1095_10958 tree_1095 tree_10958 0.8192
Cp_10958 tree_10958 0 2.592e-15
Rtr_1095_10959 tree_1095 tree_10959 0.8192
Cp_10959 tree_10959 0 2.592e-15
Rtr_1095_10960 tree_1095 tree_10960 0.8192
Cp_10960 tree_10960 0 2.592e-15
Rtr_1096_10961 tree_1096 tree_10961 0.8192
Cp_10961 tree_10961 0 2.592e-15
Rtr_1096_10962 tree_1096 tree_10962 0.8192
Cp_10962 tree_10962 0 2.592e-15
Rtr_1096_10963 tree_1096 tree_10963 0.8192
Cp_10963 tree_10963 0 2.592e-15
Rtr_1096_10964 tree_1096 tree_10964 0.8192
Cp_10964 tree_10964 0 2.592e-15
Rtr_1096_10965 tree_1096 tree_10965 0.8192
Cp_10965 tree_10965 0 2.592e-15
Rtr_1096_10966 tree_1096 tree_10966 0.8192
Cp_10966 tree_10966 0 2.592e-15
Rtr_1096_10967 tree_1096 tree_10967 0.8192
Cp_10967 tree_10967 0 2.592e-15
Rtr_1096_10968 tree_1096 tree_10968 0.8192
Cp_10968 tree_10968 0 2.592e-15
Rtr_1096_10969 tree_1096 tree_10969 0.8192
Cp_10969 tree_10969 0 2.592e-15
Rtr_1096_10970 tree_1096 tree_10970 0.8192
Cp_10970 tree_10970 0 2.592e-15
Rtr_1097_10971 tree_1097 tree_10971 0.8192
Cp_10971 tree_10971 0 2.592e-15
Rtr_1097_10972 tree_1097 tree_10972 0.8192
Cp_10972 tree_10972 0 2.592e-15
Rtr_1097_10973 tree_1097 tree_10973 0.8192
Cp_10973 tree_10973 0 2.592e-15
Rtr_1097_10974 tree_1097 tree_10974 0.8192
Cp_10974 tree_10974 0 2.592e-15
Rtr_1097_10975 tree_1097 tree_10975 0.8192
Cp_10975 tree_10975 0 2.592e-15
Rtr_1097_10976 tree_1097 tree_10976 0.8192
Cp_10976 tree_10976 0 2.592e-15
Rtr_1097_10977 tree_1097 tree_10977 0.8192
Cp_10977 tree_10977 0 2.592e-15
Rtr_1097_10978 tree_1097 tree_10978 0.8192
Cp_10978 tree_10978 0 2.592e-15
Rtr_1097_10979 tree_1097 tree_10979 0.8192
Cp_10979 tree_10979 0 2.592e-15
Rtr_1097_10980 tree_1097 tree_10980 0.8192
Cp_10980 tree_10980 0 2.592e-15
Rtr_1098_10981 tree_1098 tree_10981 0.8192
Cp_10981 tree_10981 0 2.592e-15
Rtr_1098_10982 tree_1098 tree_10982 0.8192
Cp_10982 tree_10982 0 2.592e-15
Rtr_1098_10983 tree_1098 tree_10983 0.8192
Cp_10983 tree_10983 0 2.592e-15
Rtr_1098_10984 tree_1098 tree_10984 0.8192
Cp_10984 tree_10984 0 2.592e-15
Rtr_1098_10985 tree_1098 tree_10985 0.8192
Cp_10985 tree_10985 0 2.592e-15
Rtr_1098_10986 tree_1098 tree_10986 0.8192
Cp_10986 tree_10986 0 2.592e-15
Rtr_1098_10987 tree_1098 tree_10987 0.8192
Cp_10987 tree_10987 0 2.592e-15
Rtr_1098_10988 tree_1098 tree_10988 0.8192
Cp_10988 tree_10988 0 2.592e-15
Rtr_1098_10989 tree_1098 tree_10989 0.8192
Cp_10989 tree_10989 0 2.592e-15
Rtr_1098_10990 tree_1098 tree_10990 0.8192
Cp_10990 tree_10990 0 2.592e-15
Rtr_1099_10991 tree_1099 tree_10991 0.8192
Cp_10991 tree_10991 0 2.592e-15
Rtr_1099_10992 tree_1099 tree_10992 0.8192
Cp_10992 tree_10992 0 2.592e-15
Rtr_1099_10993 tree_1099 tree_10993 0.8192
Cp_10993 tree_10993 0 2.592e-15
Rtr_1099_10994 tree_1099 tree_10994 0.8192
Cp_10994 tree_10994 0 2.592e-15
Rtr_1099_10995 tree_1099 tree_10995 0.8192
Cp_10995 tree_10995 0 2.592e-15
Rtr_1099_10996 tree_1099 tree_10996 0.8192
Cp_10996 tree_10996 0 2.592e-15
Rtr_1099_10997 tree_1099 tree_10997 0.8192
Cp_10997 tree_10997 0 2.592e-15
Rtr_1099_10998 tree_1099 tree_10998 0.8192
Cp_10998 tree_10998 0 2.592e-15
Rtr_1099_10999 tree_1099 tree_10999 0.8192
Cp_10999 tree_10999 0 2.592e-15
Rtr_1099_11000 tree_1099 tree_11000 0.8192
Cp_11000 tree_11000 0 2.592e-15
Rtr_1100_11001 tree_1100 tree_11001 0.8192
Cp_11001 tree_11001 0 2.592e-15
Rtr_1100_11002 tree_1100 tree_11002 0.8192
Cp_11002 tree_11002 0 2.592e-15
Rtr_1100_11003 tree_1100 tree_11003 0.8192
Cp_11003 tree_11003 0 2.592e-15
Rtr_1100_11004 tree_1100 tree_11004 0.8192
Cp_11004 tree_11004 0 2.592e-15
Rtr_1100_11005 tree_1100 tree_11005 0.8192
Cp_11005 tree_11005 0 2.592e-15
Rtr_1100_11006 tree_1100 tree_11006 0.8192
Cp_11006 tree_11006 0 2.592e-15
Rtr_1100_11007 tree_1100 tree_11007 0.8192
Cp_11007 tree_11007 0 2.592e-15
Rtr_1100_11008 tree_1100 tree_11008 0.8192
Cp_11008 tree_11008 0 2.592e-15
Rtr_1100_11009 tree_1100 tree_11009 0.8192
Cp_11009 tree_11009 0 2.592e-15
Rtr_1100_11010 tree_1100 tree_11010 0.8192
Cp_11010 tree_11010 0 2.592e-15
Rtr_1101_11011 tree_1101 tree_11011 0.8192
Cp_11011 tree_11011 0 2.592e-15
Rtr_1101_11012 tree_1101 tree_11012 0.8192
Cp_11012 tree_11012 0 2.592e-15
Rtr_1101_11013 tree_1101 tree_11013 0.8192
Cp_11013 tree_11013 0 2.592e-15
Rtr_1101_11014 tree_1101 tree_11014 0.8192
Cp_11014 tree_11014 0 2.592e-15
Rtr_1101_11015 tree_1101 tree_11015 0.8192
Cp_11015 tree_11015 0 2.592e-15
Rtr_1101_11016 tree_1101 tree_11016 0.8192
Cp_11016 tree_11016 0 2.592e-15
Rtr_1101_11017 tree_1101 tree_11017 0.8192
Cp_11017 tree_11017 0 2.592e-15
Rtr_1101_11018 tree_1101 tree_11018 0.8192
Cp_11018 tree_11018 0 2.592e-15
Rtr_1101_11019 tree_1101 tree_11019 0.8192
Cp_11019 tree_11019 0 2.592e-15
Rtr_1101_11020 tree_1101 tree_11020 0.8192
Cp_11020 tree_11020 0 2.592e-15
Rtr_1102_11021 tree_1102 tree_11021 0.8192
Cp_11021 tree_11021 0 2.592e-15
Rtr_1102_11022 tree_1102 tree_11022 0.8192
Cp_11022 tree_11022 0 2.592e-15
Rtr_1102_11023 tree_1102 tree_11023 0.8192
Cp_11023 tree_11023 0 2.592e-15
Rtr_1102_11024 tree_1102 tree_11024 0.8192
Cp_11024 tree_11024 0 2.592e-15
Rtr_1102_11025 tree_1102 tree_11025 0.8192
Cp_11025 tree_11025 0 2.592e-15
Rtr_1102_11026 tree_1102 tree_11026 0.8192
Cp_11026 tree_11026 0 2.592e-15
Rtr_1102_11027 tree_1102 tree_11027 0.8192
Cp_11027 tree_11027 0 2.592e-15
Rtr_1102_11028 tree_1102 tree_11028 0.8192
Cp_11028 tree_11028 0 2.592e-15
Rtr_1102_11029 tree_1102 tree_11029 0.8192
Cp_11029 tree_11029 0 2.592e-15
Rtr_1102_11030 tree_1102 tree_11030 0.8192
Cp_11030 tree_11030 0 2.592e-15
Rtr_1103_11031 tree_1103 tree_11031 0.8192
Cp_11031 tree_11031 0 2.592e-15
Rtr_1103_11032 tree_1103 tree_11032 0.8192
Cp_11032 tree_11032 0 2.592e-15
Rtr_1103_11033 tree_1103 tree_11033 0.8192
Cp_11033 tree_11033 0 2.592e-15
Rtr_1103_11034 tree_1103 tree_11034 0.8192
Cp_11034 tree_11034 0 2.592e-15
Rtr_1103_11035 tree_1103 tree_11035 0.8192
Cp_11035 tree_11035 0 2.592e-15
Rtr_1103_11036 tree_1103 tree_11036 0.8192
Cp_11036 tree_11036 0 2.592e-15
Rtr_1103_11037 tree_1103 tree_11037 0.8192
Cp_11037 tree_11037 0 2.592e-15
Rtr_1103_11038 tree_1103 tree_11038 0.8192
Cp_11038 tree_11038 0 2.592e-15
Rtr_1103_11039 tree_1103 tree_11039 0.8192
Cp_11039 tree_11039 0 2.592e-15
Rtr_1103_11040 tree_1103 tree_11040 0.8192
Cp_11040 tree_11040 0 2.592e-15
Rtr_1104_11041 tree_1104 tree_11041 0.8192
Cp_11041 tree_11041 0 2.592e-15
Rtr_1104_11042 tree_1104 tree_11042 0.8192
Cp_11042 tree_11042 0 2.592e-15
Rtr_1104_11043 tree_1104 tree_11043 0.8192
Cp_11043 tree_11043 0 2.592e-15
Rtr_1104_11044 tree_1104 tree_11044 0.8192
Cp_11044 tree_11044 0 2.592e-15
Rtr_1104_11045 tree_1104 tree_11045 0.8192
Cp_11045 tree_11045 0 2.592e-15
Rtr_1104_11046 tree_1104 tree_11046 0.8192
Cp_11046 tree_11046 0 2.592e-15
Rtr_1104_11047 tree_1104 tree_11047 0.8192
Cp_11047 tree_11047 0 2.592e-15
Rtr_1104_11048 tree_1104 tree_11048 0.8192
Cp_11048 tree_11048 0 2.592e-15
Rtr_1104_11049 tree_1104 tree_11049 0.8192
Cp_11049 tree_11049 0 2.592e-15
Rtr_1104_11050 tree_1104 tree_11050 0.8192
Cp_11050 tree_11050 0 2.592e-15
Rtr_1105_11051 tree_1105 tree_11051 0.8192
Cp_11051 tree_11051 0 2.592e-15
Rtr_1105_11052 tree_1105 tree_11052 0.8192
Cp_11052 tree_11052 0 2.592e-15
Rtr_1105_11053 tree_1105 tree_11053 0.8192
Cp_11053 tree_11053 0 2.592e-15
Rtr_1105_11054 tree_1105 tree_11054 0.8192
Cp_11054 tree_11054 0 2.592e-15
Rtr_1105_11055 tree_1105 tree_11055 0.8192
Cp_11055 tree_11055 0 2.592e-15
Rtr_1105_11056 tree_1105 tree_11056 0.8192
Cp_11056 tree_11056 0 2.592e-15
Rtr_1105_11057 tree_1105 tree_11057 0.8192
Cp_11057 tree_11057 0 2.592e-15
Rtr_1105_11058 tree_1105 tree_11058 0.8192
Cp_11058 tree_11058 0 2.592e-15
Rtr_1105_11059 tree_1105 tree_11059 0.8192
Cp_11059 tree_11059 0 2.592e-15
Rtr_1105_11060 tree_1105 tree_11060 0.8192
Cp_11060 tree_11060 0 2.592e-15
Rtr_1106_11061 tree_1106 tree_11061 0.8192
Cp_11061 tree_11061 0 2.592e-15
Rtr_1106_11062 tree_1106 tree_11062 0.8192
Cp_11062 tree_11062 0 2.592e-15
Rtr_1106_11063 tree_1106 tree_11063 0.8192
Cp_11063 tree_11063 0 2.592e-15
Rtr_1106_11064 tree_1106 tree_11064 0.8192
Cp_11064 tree_11064 0 2.592e-15
Rtr_1106_11065 tree_1106 tree_11065 0.8192
Cp_11065 tree_11065 0 2.592e-15
Rtr_1106_11066 tree_1106 tree_11066 0.8192
Cp_11066 tree_11066 0 2.592e-15
Rtr_1106_11067 tree_1106 tree_11067 0.8192
Cp_11067 tree_11067 0 2.592e-15
Rtr_1106_11068 tree_1106 tree_11068 0.8192
Cp_11068 tree_11068 0 2.592e-15
Rtr_1106_11069 tree_1106 tree_11069 0.8192
Cp_11069 tree_11069 0 2.592e-15
Rtr_1106_11070 tree_1106 tree_11070 0.8192
Cp_11070 tree_11070 0 2.592e-15
Rtr_1107_11071 tree_1107 tree_11071 0.8192
Cp_11071 tree_11071 0 2.592e-15
Rtr_1107_11072 tree_1107 tree_11072 0.8192
Cp_11072 tree_11072 0 2.592e-15
Rtr_1107_11073 tree_1107 tree_11073 0.8192
Cp_11073 tree_11073 0 2.592e-15
Rtr_1107_11074 tree_1107 tree_11074 0.8192
Cp_11074 tree_11074 0 2.592e-15
Rtr_1107_11075 tree_1107 tree_11075 0.8192
Cp_11075 tree_11075 0 2.592e-15
Rtr_1107_11076 tree_1107 tree_11076 0.8192
Cp_11076 tree_11076 0 2.592e-15
Rtr_1107_11077 tree_1107 tree_11077 0.8192
Cp_11077 tree_11077 0 2.592e-15
Rtr_1107_11078 tree_1107 tree_11078 0.8192
Cp_11078 tree_11078 0 2.592e-15
Rtr_1107_11079 tree_1107 tree_11079 0.8192
Cp_11079 tree_11079 0 2.592e-15
Rtr_1107_11080 tree_1107 tree_11080 0.8192
Cp_11080 tree_11080 0 2.592e-15
Rtr_1108_11081 tree_1108 tree_11081 0.8192
Cp_11081 tree_11081 0 2.592e-15
Rtr_1108_11082 tree_1108 tree_11082 0.8192
Cp_11082 tree_11082 0 2.592e-15
Rtr_1108_11083 tree_1108 tree_11083 0.8192
Cp_11083 tree_11083 0 2.592e-15
Rtr_1108_11084 tree_1108 tree_11084 0.8192
Cp_11084 tree_11084 0 2.592e-15
Rtr_1108_11085 tree_1108 tree_11085 0.8192
Cp_11085 tree_11085 0 2.592e-15
Rtr_1108_11086 tree_1108 tree_11086 0.8192
Cp_11086 tree_11086 0 2.592e-15
Rtr_1108_11087 tree_1108 tree_11087 0.8192
Cp_11087 tree_11087 0 2.592e-15
Rtr_1108_11088 tree_1108 tree_11088 0.8192
Cp_11088 tree_11088 0 2.592e-15
Rtr_1108_11089 tree_1108 tree_11089 0.8192
Cp_11089 tree_11089 0 2.592e-15
Rtr_1108_11090 tree_1108 tree_11090 0.8192
Cp_11090 tree_11090 0 2.592e-15
Rtr_1109_11091 tree_1109 tree_11091 0.8192
Cp_11091 tree_11091 0 2.592e-15
Rtr_1109_11092 tree_1109 tree_11092 0.8192
Cp_11092 tree_11092 0 2.592e-15
Rtr_1109_11093 tree_1109 tree_11093 0.8192
Cp_11093 tree_11093 0 2.592e-15
Rtr_1109_11094 tree_1109 tree_11094 0.8192
Cp_11094 tree_11094 0 2.592e-15
Rtr_1109_11095 tree_1109 tree_11095 0.8192
Cp_11095 tree_11095 0 2.592e-15
Rtr_1109_11096 tree_1109 tree_11096 0.8192
Cp_11096 tree_11096 0 2.592e-15
Rtr_1109_11097 tree_1109 tree_11097 0.8192
Cp_11097 tree_11097 0 2.592e-15
Rtr_1109_11098 tree_1109 tree_11098 0.8192
Cp_11098 tree_11098 0 2.592e-15
Rtr_1109_11099 tree_1109 tree_11099 0.8192
Cp_11099 tree_11099 0 2.592e-15
Rtr_1109_11100 tree_1109 tree_11100 0.8192
Cp_11100 tree_11100 0 2.592e-15
Rtr_1110_11101 tree_1110 tree_11101 0.8192
Cp_11101 tree_11101 0 2.592e-15
Rtr_1110_11102 tree_1110 tree_11102 0.8192
Cp_11102 tree_11102 0 2.592e-15
Rtr_1110_11103 tree_1110 tree_11103 0.8192
Cp_11103 tree_11103 0 2.592e-15
Rtr_1110_11104 tree_1110 tree_11104 0.8192
Cp_11104 tree_11104 0 2.592e-15
Rtr_1110_11105 tree_1110 tree_11105 0.8192
Cp_11105 tree_11105 0 2.592e-15
Rtr_1110_11106 tree_1110 tree_11106 0.8192
Cp_11106 tree_11106 0 2.592e-15
Rtr_1110_11107 tree_1110 tree_11107 0.8192
Cp_11107 tree_11107 0 2.592e-15
Rtr_1110_11108 tree_1110 tree_11108 0.8192
Cp_11108 tree_11108 0 2.592e-15
Rtr_1110_11109 tree_1110 tree_11109 0.8192
Cp_11109 tree_11109 0 2.592e-15
Rtr_1110_11110 tree_1110 tree_11110 0.8192
Cp_11110 tree_11110 0 2.592e-15
Rlm_1_2 tree_1 tree_2 0.8
Rlm_4_5 tree_4 tree_5 0.8
Rlm_7_8 tree_7 tree_8 0.8
Rlm_11_12 tree_11 tree_12 1.28
Rlm_14_15 tree_14 tree_15 1.28
Rlm_17_18 tree_17 tree_18 1.28
Rlm_21_22 tree_21 tree_22 1.28
Rlm_24_25 tree_24 tree_25 1.28
Rlm_27_28 tree_27 tree_28 1.28
Rlm_31_32 tree_31 tree_32 1.28
Rlm_34_35 tree_34 tree_35 1.28
Rlm_37_38 tree_37 tree_38 1.28
Rlm_41_42 tree_41 tree_42 1.28
Rlm_44_45 tree_44 tree_45 1.28
Rlm_47_48 tree_47 tree_48 1.28
Rlm_51_52 tree_51 tree_52 1.28
Rlm_54_55 tree_54 tree_55 1.28
Rlm_57_58 tree_57 tree_58 1.28
Rlm_61_62 tree_61 tree_62 1.28
Rlm_64_65 tree_64 tree_65 1.28
Rlm_67_68 tree_67 tree_68 1.28
Rlm_71_72 tree_71 tree_72 1.28
Rlm_74_75 tree_74 tree_75 1.28
Rlm_77_78 tree_77 tree_78 1.28
Rlm_81_82 tree_81 tree_82 1.28
Rlm_84_85 tree_84 tree_85 1.28
Rlm_87_88 tree_87 tree_88 1.28
Rlm_91_92 tree_91 tree_92 1.28
Rlm_94_95 tree_94 tree_95 1.28
Rlm_97_98 tree_97 tree_98 1.28
Rlm_101_102 tree_101 tree_102 1.28
Rlm_104_105 tree_104 tree_105 1.28
Rlm_107_108 tree_107 tree_108 1.28
Rlm_111_112 tree_111 tree_112 2.048
Rlm_114_115 tree_114 tree_115 2.048
Rlm_117_118 tree_117 tree_118 2.048
Rlm_121_122 tree_121 tree_122 2.048
Rlm_124_125 tree_124 tree_125 2.048
Rlm_127_128 tree_127 tree_128 2.048
Rlm_131_132 tree_131 tree_132 2.048
Rlm_134_135 tree_134 tree_135 2.048
Rlm_137_138 tree_137 tree_138 2.048
Rlm_141_142 tree_141 tree_142 2.048
Rlm_144_145 tree_144 tree_145 2.048
Rlm_147_148 tree_147 tree_148 2.048
Rlm_151_152 tree_151 tree_152 2.048
Rlm_154_155 tree_154 tree_155 2.048
Rlm_157_158 tree_157 tree_158 2.048
Rlm_161_162 tree_161 tree_162 2.048
Rlm_164_165 tree_164 tree_165 2.048
Rlm_167_168 tree_167 tree_168 2.048
Rlm_171_172 tree_171 tree_172 2.048
Rlm_174_175 tree_174 tree_175 2.048
Rlm_177_178 tree_177 tree_178 2.048
Rlm_181_182 tree_181 tree_182 2.048
Rlm_184_185 tree_184 tree_185 2.048
Rlm_187_188 tree_187 tree_188 2.048
Rlm_191_192 tree_191 tree_192 2.048
Rlm_194_195 tree_194 tree_195 2.048
Rlm_197_198 tree_197 tree_198 2.048
Rlm_201_202 tree_201 tree_202 2.048
Rlm_204_205 tree_204 tree_205 2.048
Rlm_207_208 tree_207 tree_208 2.048
Rlm_211_212 tree_211 tree_212 2.048
Rlm_214_215 tree_214 tree_215 2.048
Rlm_217_218 tree_217 tree_218 2.048
Rlm_221_222 tree_221 tree_222 2.048
Rlm_224_225 tree_224 tree_225 2.048
Rlm_227_228 tree_227 tree_228 2.048
Rlm_231_232 tree_231 tree_232 2.048
Rlm_234_235 tree_234 tree_235 2.048
Rlm_237_238 tree_237 tree_238 2.048
Rlm_241_242 tree_241 tree_242 2.048
Rlm_244_245 tree_244 tree_245 2.048
Rlm_247_248 tree_247 tree_248 2.048
Rlm_251_252 tree_251 tree_252 2.048
Rlm_254_255 tree_254 tree_255 2.048
Rlm_257_258 tree_257 tree_258 2.048
Rlm_261_262 tree_261 tree_262 2.048
Rlm_264_265 tree_264 tree_265 2.048
Rlm_267_268 tree_267 tree_268 2.048
Rlm_271_272 tree_271 tree_272 2.048
Rlm_274_275 tree_274 tree_275 2.048
Rlm_277_278 tree_277 tree_278 2.048
Rlm_281_282 tree_281 tree_282 2.048
Rlm_284_285 tree_284 tree_285 2.048
Rlm_287_288 tree_287 tree_288 2.048
Rlm_291_292 tree_291 tree_292 2.048
Rlm_294_295 tree_294 tree_295 2.048
Rlm_297_298 tree_297 tree_298 2.048
Rlm_301_302 tree_301 tree_302 2.048
Rlm_304_305 tree_304 tree_305 2.048
Rlm_307_308 tree_307 tree_308 2.048
Rlm_311_312 tree_311 tree_312 2.048
Rlm_314_315 tree_314 tree_315 2.048
Rlm_317_318 tree_317 tree_318 2.048
Rlm_321_322 tree_321 tree_322 2.048
Rlm_324_325 tree_324 tree_325 2.048
Rlm_327_328 tree_327 tree_328 2.048
Rlm_331_332 tree_331 tree_332 2.048
Rlm_334_335 tree_334 tree_335 2.048
Rlm_337_338 tree_337 tree_338 2.048
Rlm_341_342 tree_341 tree_342 2.048
Rlm_344_345 tree_344 tree_345 2.048
Rlm_347_348 tree_347 tree_348 2.048
Rlm_351_352 tree_351 tree_352 2.048
Rlm_354_355 tree_354 tree_355 2.048
Rlm_357_358 tree_357 tree_358 2.048
Rlm_361_362 tree_361 tree_362 2.048
Rlm_364_365 tree_364 tree_365 2.048
Rlm_367_368 tree_367 tree_368 2.048
Rlm_371_372 tree_371 tree_372 2.048
Rlm_374_375 tree_374 tree_375 2.048
Rlm_377_378 tree_377 tree_378 2.048
Rlm_381_382 tree_381 tree_382 2.048
Rlm_384_385 tree_384 tree_385 2.048
Rlm_387_388 tree_387 tree_388 2.048
Rlm_391_392 tree_391 tree_392 2.048
Rlm_394_395 tree_394 tree_395 2.048
Rlm_397_398 tree_397 tree_398 2.048
Rlm_401_402 tree_401 tree_402 2.048
Rlm_404_405 tree_404 tree_405 2.048
Rlm_407_408 tree_407 tree_408 2.048
Rlm_411_412 tree_411 tree_412 2.048
Rlm_414_415 tree_414 tree_415 2.048
Rlm_417_418 tree_417 tree_418 2.048
Rlm_421_422 tree_421 tree_422 2.048
Rlm_424_425 tree_424 tree_425 2.048
Rlm_427_428 tree_427 tree_428 2.048
Rlm_431_432 tree_431 tree_432 2.048
Rlm_434_435 tree_434 tree_435 2.048
Rlm_437_438 tree_437 tree_438 2.048
Rlm_441_442 tree_441 tree_442 2.048
Rlm_444_445 tree_444 tree_445 2.048
Rlm_447_448 tree_447 tree_448 2.048
Rlm_451_452 tree_451 tree_452 2.048
Rlm_454_455 tree_454 tree_455 2.048
Rlm_457_458 tree_457 tree_458 2.048
Rlm_461_462 tree_461 tree_462 2.048
Rlm_464_465 tree_464 tree_465 2.048
Rlm_467_468 tree_467 tree_468 2.048
Rlm_471_472 tree_471 tree_472 2.048
Rlm_474_475 tree_474 tree_475 2.048
Rlm_477_478 tree_477 tree_478 2.048
Rlm_481_482 tree_481 tree_482 2.048
Rlm_484_485 tree_484 tree_485 2.048
Rlm_487_488 tree_487 tree_488 2.048
Rlm_491_492 tree_491 tree_492 2.048
Rlm_494_495 tree_494 tree_495 2.048
Rlm_497_498 tree_497 tree_498 2.048
Rlm_501_502 tree_501 tree_502 2.048
Rlm_504_505 tree_504 tree_505 2.048
Rlm_507_508 tree_507 tree_508 2.048
Rlm_511_512 tree_511 tree_512 2.048
Rlm_514_515 tree_514 tree_515 2.048
Rlm_517_518 tree_517 tree_518 2.048
Rlm_521_522 tree_521 tree_522 2.048
Rlm_524_525 tree_524 tree_525 2.048
Rlm_527_528 tree_527 tree_528 2.048
Rlm_531_532 tree_531 tree_532 2.048
Rlm_534_535 tree_534 tree_535 2.048
Rlm_537_538 tree_537 tree_538 2.048
Rlm_541_542 tree_541 tree_542 2.048
Rlm_544_545 tree_544 tree_545 2.048
Rlm_547_548 tree_547 tree_548 2.048
Rlm_551_552 tree_551 tree_552 2.048
Rlm_554_555 tree_554 tree_555 2.048
Rlm_557_558 tree_557 tree_558 2.048
Rlm_561_562 tree_561 tree_562 2.048
Rlm_564_565 tree_564 tree_565 2.048
Rlm_567_568 tree_567 tree_568 2.048
Rlm_571_572 tree_571 tree_572 2.048
Rlm_574_575 tree_574 tree_575 2.048
Rlm_577_578 tree_577 tree_578 2.048
Rlm_581_582 tree_581 tree_582 2.048
Rlm_584_585 tree_584 tree_585 2.048
Rlm_587_588 tree_587 tree_588 2.048
Rlm_591_592 tree_591 tree_592 2.048
Rlm_594_595 tree_594 tree_595 2.048
Rlm_597_598 tree_597 tree_598 2.048
Rlm_601_602 tree_601 tree_602 2.048
Rlm_604_605 tree_604 tree_605 2.048
Rlm_607_608 tree_607 tree_608 2.048
Rlm_611_612 tree_611 tree_612 2.048
Rlm_614_615 tree_614 tree_615 2.048
Rlm_617_618 tree_617 tree_618 2.048
Rlm_621_622 tree_621 tree_622 2.048
Rlm_624_625 tree_624 tree_625 2.048
Rlm_627_628 tree_627 tree_628 2.048
Rlm_631_632 tree_631 tree_632 2.048
Rlm_634_635 tree_634 tree_635 2.048
Rlm_637_638 tree_637 tree_638 2.048
Rlm_641_642 tree_641 tree_642 2.048
Rlm_644_645 tree_644 tree_645 2.048
Rlm_647_648 tree_647 tree_648 2.048
Rlm_651_652 tree_651 tree_652 2.048
Rlm_654_655 tree_654 tree_655 2.048
Rlm_657_658 tree_657 tree_658 2.048
Rlm_661_662 tree_661 tree_662 2.048
Rlm_664_665 tree_664 tree_665 2.048
Rlm_667_668 tree_667 tree_668 2.048
Rlm_671_672 tree_671 tree_672 2.048
Rlm_674_675 tree_674 tree_675 2.048
Rlm_677_678 tree_677 tree_678 2.048
Rlm_681_682 tree_681 tree_682 2.048
Rlm_684_685 tree_684 tree_685 2.048
Rlm_687_688 tree_687 tree_688 2.048
Rlm_691_692 tree_691 tree_692 2.048
Rlm_694_695 tree_694 tree_695 2.048
Rlm_697_698 tree_697 tree_698 2.048
Rlm_701_702 tree_701 tree_702 2.048
Rlm_704_705 tree_704 tree_705 2.048
Rlm_707_708 tree_707 tree_708 2.048
Rlm_711_712 tree_711 tree_712 2.048
Rlm_714_715 tree_714 tree_715 2.048
Rlm_717_718 tree_717 tree_718 2.048
Rlm_721_722 tree_721 tree_722 2.048
Rlm_724_725 tree_724 tree_725 2.048
Rlm_727_728 tree_727 tree_728 2.048
Rlm_731_732 tree_731 tree_732 2.048
Rlm_734_735 tree_734 tree_735 2.048
Rlm_737_738 tree_737 tree_738 2.048
Rlm_741_742 tree_741 tree_742 2.048
Rlm_744_745 tree_744 tree_745 2.048
Rlm_747_748 tree_747 tree_748 2.048
Rlm_751_752 tree_751 tree_752 2.048
Rlm_754_755 tree_754 tree_755 2.048
Rlm_757_758 tree_757 tree_758 2.048
Rlm_761_762 tree_761 tree_762 2.048
Rlm_764_765 tree_764 tree_765 2.048
Rlm_767_768 tree_767 tree_768 2.048
Rlm_771_772 tree_771 tree_772 2.048
Rlm_774_775 tree_774 tree_775 2.048
Rlm_777_778 tree_777 tree_778 2.048
Rlm_781_782 tree_781 tree_782 2.048
Rlm_784_785 tree_784 tree_785 2.048
Rlm_787_788 tree_787 tree_788 2.048
Rlm_791_792 tree_791 tree_792 2.048
Rlm_794_795 tree_794 tree_795 2.048
Rlm_797_798 tree_797 tree_798 2.048
Rlm_801_802 tree_801 tree_802 2.048
Rlm_804_805 tree_804 tree_805 2.048
Rlm_807_808 tree_807 tree_808 2.048
Rlm_811_812 tree_811 tree_812 2.048
Rlm_814_815 tree_814 tree_815 2.048
Rlm_817_818 tree_817 tree_818 2.048
Rlm_821_822 tree_821 tree_822 2.048
Rlm_824_825 tree_824 tree_825 2.048
Rlm_827_828 tree_827 tree_828 2.048
Rlm_831_832 tree_831 tree_832 2.048
Rlm_834_835 tree_834 tree_835 2.048
Rlm_837_838 tree_837 tree_838 2.048
Rlm_841_842 tree_841 tree_842 2.048
Rlm_844_845 tree_844 tree_845 2.048
Rlm_847_848 tree_847 tree_848 2.048
Rlm_851_852 tree_851 tree_852 2.048
Rlm_854_855 tree_854 tree_855 2.048
Rlm_857_858 tree_857 tree_858 2.048
Rlm_861_862 tree_861 tree_862 2.048
Rlm_864_865 tree_864 tree_865 2.048
Rlm_867_868 tree_867 tree_868 2.048
Rlm_871_872 tree_871 tree_872 2.048
Rlm_874_875 tree_874 tree_875 2.048
Rlm_877_878 tree_877 tree_878 2.048
Rlm_881_882 tree_881 tree_882 2.048
Rlm_884_885 tree_884 tree_885 2.048
Rlm_887_888 tree_887 tree_888 2.048
Rlm_891_892 tree_891 tree_892 2.048
Rlm_894_895 tree_894 tree_895 2.048
Rlm_897_898 tree_897 tree_898 2.048
Rlm_901_902 tree_901 tree_902 2.048
Rlm_904_905 tree_904 tree_905 2.048
Rlm_907_908 tree_907 tree_908 2.048
Rlm_911_912 tree_911 tree_912 2.048
Rlm_914_915 tree_914 tree_915 2.048
Rlm_917_918 tree_917 tree_918 2.048
Rlm_921_922 tree_921 tree_922 2.048
Rlm_924_925 tree_924 tree_925 2.048
Rlm_927_928 tree_927 tree_928 2.048
Rlm_931_932 tree_931 tree_932 2.048
Rlm_934_935 tree_934 tree_935 2.048
Rlm_937_938 tree_937 tree_938 2.048
Rlm_941_942 tree_941 tree_942 2.048
Rlm_944_945 tree_944 tree_945 2.048
Rlm_947_948 tree_947 tree_948 2.048
Rlm_951_952 tree_951 tree_952 2.048
Rlm_954_955 tree_954 tree_955 2.048
Rlm_957_958 tree_957 tree_958 2.048
Rlm_961_962 tree_961 tree_962 2.048
Rlm_964_965 tree_964 tree_965 2.048
Rlm_967_968 tree_967 tree_968 2.048
Rlm_971_972 tree_971 tree_972 2.048
Rlm_974_975 tree_974 tree_975 2.048
Rlm_977_978 tree_977 tree_978 2.048
Rlm_981_982 tree_981 tree_982 2.048
Rlm_984_985 tree_984 tree_985 2.048
Rlm_987_988 tree_987 tree_988 2.048
Rlm_991_992 tree_991 tree_992 2.048
Rlm_994_995 tree_994 tree_995 2.048
Rlm_997_998 tree_997 tree_998 2.048
Rlm_1001_1002 tree_1001 tree_1002 2.048
Rlm_1004_1005 tree_1004 tree_1005 2.048
Rlm_1007_1008 tree_1007 tree_1008 2.048
Rlm_1011_1012 tree_1011 tree_1012 2.048
Rlm_1014_1015 tree_1014 tree_1015 2.048
Rlm_1017_1018 tree_1017 tree_1018 2.048
Rlm_1021_1022 tree_1021 tree_1022 2.048
Rlm_1024_1025 tree_1024 tree_1025 2.048
Rlm_1027_1028 tree_1027 tree_1028 2.048
Rlm_1031_1032 tree_1031 tree_1032 2.048
Rlm_1034_1035 tree_1034 tree_1035 2.048
Rlm_1037_1038 tree_1037 tree_1038 2.048
Rlm_1041_1042 tree_1041 tree_1042 2.048
Rlm_1044_1045 tree_1044 tree_1045 2.048
Rlm_1047_1048 tree_1047 tree_1048 2.048
Rlm_1051_1052 tree_1051 tree_1052 2.048
Rlm_1054_1055 tree_1054 tree_1055 2.048
Rlm_1057_1058 tree_1057 tree_1058 2.048
Rlm_1061_1062 tree_1061 tree_1062 2.048
Rlm_1064_1065 tree_1064 tree_1065 2.048
Rlm_1067_1068 tree_1067 tree_1068 2.048
Rlm_1071_1072 tree_1071 tree_1072 2.048
Rlm_1074_1075 tree_1074 tree_1075 2.048
Rlm_1077_1078 tree_1077 tree_1078 2.048
Rlm_1081_1082 tree_1081 tree_1082 2.048
Rlm_1084_1085 tree_1084 tree_1085 2.048
Rlm_1087_1088 tree_1087 tree_1088 2.048
Rlm_1091_1092 tree_1091 tree_1092 2.048
Rlm_1094_1095 tree_1094 tree_1095 2.048
Rlm_1097_1098 tree_1097 tree_1098 2.048
Rlm_1101_1102 tree_1101 tree_1102 2.048
Rlm_1104_1105 tree_1104 tree_1105 2.048
Rlm_1107_1108 tree_1107 tree_1108 2.048
Rlm_1111_1112 tree_1111 tree_1112 3.2768
Rlm_1114_1115 tree_1114 tree_1115 3.2768
Rlm_1117_1118 tree_1117 tree_1118 3.2768
Rlm_1121_1122 tree_1121 tree_1122 3.2768
Rlm_1124_1125 tree_1124 tree_1125 3.2768
Rlm_1127_1128 tree_1127 tree_1128 3.2768
Rlm_1131_1132 tree_1131 tree_1132 3.2768
Rlm_1134_1135 tree_1134 tree_1135 3.2768
Rlm_1137_1138 tree_1137 tree_1138 3.2768
Rlm_1141_1142 tree_1141 tree_1142 3.2768
Rlm_1144_1145 tree_1144 tree_1145 3.2768
Rlm_1147_1148 tree_1147 tree_1148 3.2768
Rlm_1151_1152 tree_1151 tree_1152 3.2768
Rlm_1154_1155 tree_1154 tree_1155 3.2768
Rlm_1157_1158 tree_1157 tree_1158 3.2768
Rlm_1161_1162 tree_1161 tree_1162 3.2768
Rlm_1164_1165 tree_1164 tree_1165 3.2768
Rlm_1167_1168 tree_1167 tree_1168 3.2768
Rlm_1171_1172 tree_1171 tree_1172 3.2768
Rlm_1174_1175 tree_1174 tree_1175 3.2768
Rlm_1177_1178 tree_1177 tree_1178 3.2768
Rlm_1181_1182 tree_1181 tree_1182 3.2768
Rlm_1184_1185 tree_1184 tree_1185 3.2768
Rlm_1187_1188 tree_1187 tree_1188 3.2768
Rlm_1191_1192 tree_1191 tree_1192 3.2768
Rlm_1194_1195 tree_1194 tree_1195 3.2768
Rlm_1197_1198 tree_1197 tree_1198 3.2768
Rlm_1201_1202 tree_1201 tree_1202 3.2768
Rlm_1204_1205 tree_1204 tree_1205 3.2768
Rlm_1207_1208 tree_1207 tree_1208 3.2768
Rlm_1211_1212 tree_1211 tree_1212 3.2768
Rlm_1214_1215 tree_1214 tree_1215 3.2768
Rlm_1217_1218 tree_1217 tree_1218 3.2768
Rlm_1221_1222 tree_1221 tree_1222 3.2768
Rlm_1224_1225 tree_1224 tree_1225 3.2768
Rlm_1227_1228 tree_1227 tree_1228 3.2768
Rlm_1231_1232 tree_1231 tree_1232 3.2768
Rlm_1234_1235 tree_1234 tree_1235 3.2768
Rlm_1237_1238 tree_1237 tree_1238 3.2768
Rlm_1241_1242 tree_1241 tree_1242 3.2768
Rlm_1244_1245 tree_1244 tree_1245 3.2768
Rlm_1247_1248 tree_1247 tree_1248 3.2768
Rlm_1251_1252 tree_1251 tree_1252 3.2768
Rlm_1254_1255 tree_1254 tree_1255 3.2768
Rlm_1257_1258 tree_1257 tree_1258 3.2768
Rlm_1261_1262 tree_1261 tree_1262 3.2768
Rlm_1264_1265 tree_1264 tree_1265 3.2768
Rlm_1267_1268 tree_1267 tree_1268 3.2768
Rlm_1271_1272 tree_1271 tree_1272 3.2768
Rlm_1274_1275 tree_1274 tree_1275 3.2768
Rlm_1277_1278 tree_1277 tree_1278 3.2768
Rlm_1281_1282 tree_1281 tree_1282 3.2768
Rlm_1284_1285 tree_1284 tree_1285 3.2768
Rlm_1287_1288 tree_1287 tree_1288 3.2768
Rlm_1291_1292 tree_1291 tree_1292 3.2768
Rlm_1294_1295 tree_1294 tree_1295 3.2768
Rlm_1297_1298 tree_1297 tree_1298 3.2768
Rlm_1301_1302 tree_1301 tree_1302 3.2768
Rlm_1304_1305 tree_1304 tree_1305 3.2768
Rlm_1307_1308 tree_1307 tree_1308 3.2768
Rlm_1311_1312 tree_1311 tree_1312 3.2768
Rlm_1314_1315 tree_1314 tree_1315 3.2768
Rlm_1317_1318 tree_1317 tree_1318 3.2768
Rlm_1321_1322 tree_1321 tree_1322 3.2768
Rlm_1324_1325 tree_1324 tree_1325 3.2768
Rlm_1327_1328 tree_1327 tree_1328 3.2768
Rlm_1331_1332 tree_1331 tree_1332 3.2768
Rlm_1334_1335 tree_1334 tree_1335 3.2768
Rlm_1337_1338 tree_1337 tree_1338 3.2768
Rlm_1341_1342 tree_1341 tree_1342 3.2768
Rlm_1344_1345 tree_1344 tree_1345 3.2768
Rlm_1347_1348 tree_1347 tree_1348 3.2768
Rlm_1351_1352 tree_1351 tree_1352 3.2768
Rlm_1354_1355 tree_1354 tree_1355 3.2768
Rlm_1357_1358 tree_1357 tree_1358 3.2768
Rlm_1361_1362 tree_1361 tree_1362 3.2768
Rlm_1364_1365 tree_1364 tree_1365 3.2768
Rlm_1367_1368 tree_1367 tree_1368 3.2768
Rlm_1371_1372 tree_1371 tree_1372 3.2768
Rlm_1374_1375 tree_1374 tree_1375 3.2768
Rlm_1377_1378 tree_1377 tree_1378 3.2768
Rlm_1381_1382 tree_1381 tree_1382 3.2768
Rlm_1384_1385 tree_1384 tree_1385 3.2768
Rlm_1387_1388 tree_1387 tree_1388 3.2768
Rlm_1391_1392 tree_1391 tree_1392 3.2768
Rlm_1394_1395 tree_1394 tree_1395 3.2768
Rlm_1397_1398 tree_1397 tree_1398 3.2768
Rlm_1401_1402 tree_1401 tree_1402 3.2768
Rlm_1404_1405 tree_1404 tree_1405 3.2768
Rlm_1407_1408 tree_1407 tree_1408 3.2768
Rlm_1411_1412 tree_1411 tree_1412 3.2768
Rlm_1414_1415 tree_1414 tree_1415 3.2768
Rlm_1417_1418 tree_1417 tree_1418 3.2768
Rlm_1421_1422 tree_1421 tree_1422 3.2768
Rlm_1424_1425 tree_1424 tree_1425 3.2768
Rlm_1427_1428 tree_1427 tree_1428 3.2768
Rlm_1431_1432 tree_1431 tree_1432 3.2768
Rlm_1434_1435 tree_1434 tree_1435 3.2768
Rlm_1437_1438 tree_1437 tree_1438 3.2768
Rlm_1441_1442 tree_1441 tree_1442 3.2768
Rlm_1444_1445 tree_1444 tree_1445 3.2768
Rlm_1447_1448 tree_1447 tree_1448 3.2768
Rlm_1451_1452 tree_1451 tree_1452 3.2768
Rlm_1454_1455 tree_1454 tree_1455 3.2768
Rlm_1457_1458 tree_1457 tree_1458 3.2768
Rlm_1461_1462 tree_1461 tree_1462 3.2768
Rlm_1464_1465 tree_1464 tree_1465 3.2768
Rlm_1467_1468 tree_1467 tree_1468 3.2768
Rlm_1471_1472 tree_1471 tree_1472 3.2768
Rlm_1474_1475 tree_1474 tree_1475 3.2768
Rlm_1477_1478 tree_1477 tree_1478 3.2768
Rlm_1481_1482 tree_1481 tree_1482 3.2768
Rlm_1484_1485 tree_1484 tree_1485 3.2768
Rlm_1487_1488 tree_1487 tree_1488 3.2768
Rlm_1491_1492 tree_1491 tree_1492 3.2768
Rlm_1494_1495 tree_1494 tree_1495 3.2768
Rlm_1497_1498 tree_1497 tree_1498 3.2768
Rlm_1501_1502 tree_1501 tree_1502 3.2768
Rlm_1504_1505 tree_1504 tree_1505 3.2768
Rlm_1507_1508 tree_1507 tree_1508 3.2768
Rlm_1511_1512 tree_1511 tree_1512 3.2768
Rlm_1514_1515 tree_1514 tree_1515 3.2768
Rlm_1517_1518 tree_1517 tree_1518 3.2768
Rlm_1521_1522 tree_1521 tree_1522 3.2768
Rlm_1524_1525 tree_1524 tree_1525 3.2768
Rlm_1527_1528 tree_1527 tree_1528 3.2768
Rlm_1531_1532 tree_1531 tree_1532 3.2768
Rlm_1534_1535 tree_1534 tree_1535 3.2768
Rlm_1537_1538 tree_1537 tree_1538 3.2768
Rlm_1541_1542 tree_1541 tree_1542 3.2768
Rlm_1544_1545 tree_1544 tree_1545 3.2768
Rlm_1547_1548 tree_1547 tree_1548 3.2768
Rlm_1551_1552 tree_1551 tree_1552 3.2768
Rlm_1554_1555 tree_1554 tree_1555 3.2768
Rlm_1557_1558 tree_1557 tree_1558 3.2768
Rlm_1561_1562 tree_1561 tree_1562 3.2768
Rlm_1564_1565 tree_1564 tree_1565 3.2768
Rlm_1567_1568 tree_1567 tree_1568 3.2768
Rlm_1571_1572 tree_1571 tree_1572 3.2768
Rlm_1574_1575 tree_1574 tree_1575 3.2768
Rlm_1577_1578 tree_1577 tree_1578 3.2768
Rlm_1581_1582 tree_1581 tree_1582 3.2768
Rlm_1584_1585 tree_1584 tree_1585 3.2768
Rlm_1587_1588 tree_1587 tree_1588 3.2768
Rlm_1591_1592 tree_1591 tree_1592 3.2768
Rlm_1594_1595 tree_1594 tree_1595 3.2768
Rlm_1597_1598 tree_1597 tree_1598 3.2768
Rlm_1601_1602 tree_1601 tree_1602 3.2768
Rlm_1604_1605 tree_1604 tree_1605 3.2768
Rlm_1607_1608 tree_1607 tree_1608 3.2768
Rlm_1611_1612 tree_1611 tree_1612 3.2768
Rlm_1614_1615 tree_1614 tree_1615 3.2768
Rlm_1617_1618 tree_1617 tree_1618 3.2768
Rlm_1621_1622 tree_1621 tree_1622 3.2768
Rlm_1624_1625 tree_1624 tree_1625 3.2768
Rlm_1627_1628 tree_1627 tree_1628 3.2768
Rlm_1631_1632 tree_1631 tree_1632 3.2768
Rlm_1634_1635 tree_1634 tree_1635 3.2768
Rlm_1637_1638 tree_1637 tree_1638 3.2768
Rlm_1641_1642 tree_1641 tree_1642 3.2768
Rlm_1644_1645 tree_1644 tree_1645 3.2768
Rlm_1647_1648 tree_1647 tree_1648 3.2768
Rlm_1651_1652 tree_1651 tree_1652 3.2768
Rlm_1654_1655 tree_1654 tree_1655 3.2768
Rlm_1657_1658 tree_1657 tree_1658 3.2768
Rlm_1661_1662 tree_1661 tree_1662 3.2768
Rlm_1664_1665 tree_1664 tree_1665 3.2768
Rlm_1667_1668 tree_1667 tree_1668 3.2768
Rlm_1671_1672 tree_1671 tree_1672 3.2768
Rlm_1674_1675 tree_1674 tree_1675 3.2768
Rlm_1677_1678 tree_1677 tree_1678 3.2768
Rlm_1681_1682 tree_1681 tree_1682 3.2768
Rlm_1684_1685 tree_1684 tree_1685 3.2768
Rlm_1687_1688 tree_1687 tree_1688 3.2768
Rlm_1691_1692 tree_1691 tree_1692 3.2768
Rlm_1694_1695 tree_1694 tree_1695 3.2768
Rlm_1697_1698 tree_1697 tree_1698 3.2768
Rlm_1701_1702 tree_1701 tree_1702 3.2768
Rlm_1704_1705 tree_1704 tree_1705 3.2768
Rlm_1707_1708 tree_1707 tree_1708 3.2768
Rlm_1711_1712 tree_1711 tree_1712 3.2768
Rlm_1714_1715 tree_1714 tree_1715 3.2768
Rlm_1717_1718 tree_1717 tree_1718 3.2768
Rlm_1721_1722 tree_1721 tree_1722 3.2768
Rlm_1724_1725 tree_1724 tree_1725 3.2768
Rlm_1727_1728 tree_1727 tree_1728 3.2768
Rlm_1731_1732 tree_1731 tree_1732 3.2768
Rlm_1734_1735 tree_1734 tree_1735 3.2768
Rlm_1737_1738 tree_1737 tree_1738 3.2768
Rlm_1741_1742 tree_1741 tree_1742 3.2768
Rlm_1744_1745 tree_1744 tree_1745 3.2768
Rlm_1747_1748 tree_1747 tree_1748 3.2768
Rlm_1751_1752 tree_1751 tree_1752 3.2768
Rlm_1754_1755 tree_1754 tree_1755 3.2768
Rlm_1757_1758 tree_1757 tree_1758 3.2768
Rlm_1761_1762 tree_1761 tree_1762 3.2768
Rlm_1764_1765 tree_1764 tree_1765 3.2768
Rlm_1767_1768 tree_1767 tree_1768 3.2768
Rlm_1771_1772 tree_1771 tree_1772 3.2768
Rlm_1774_1775 tree_1774 tree_1775 3.2768
Rlm_1777_1778 tree_1777 tree_1778 3.2768
Rlm_1781_1782 tree_1781 tree_1782 3.2768
Rlm_1784_1785 tree_1784 tree_1785 3.2768
Rlm_1787_1788 tree_1787 tree_1788 3.2768
Rlm_1791_1792 tree_1791 tree_1792 3.2768
Rlm_1794_1795 tree_1794 tree_1795 3.2768
Rlm_1797_1798 tree_1797 tree_1798 3.2768
Rlm_1801_1802 tree_1801 tree_1802 3.2768
Rlm_1804_1805 tree_1804 tree_1805 3.2768
Rlm_1807_1808 tree_1807 tree_1808 3.2768
Rlm_1811_1812 tree_1811 tree_1812 3.2768
Rlm_1814_1815 tree_1814 tree_1815 3.2768
Rlm_1817_1818 tree_1817 tree_1818 3.2768
Rlm_1821_1822 tree_1821 tree_1822 3.2768
Rlm_1824_1825 tree_1824 tree_1825 3.2768
Rlm_1827_1828 tree_1827 tree_1828 3.2768
Rlm_1831_1832 tree_1831 tree_1832 3.2768
Rlm_1834_1835 tree_1834 tree_1835 3.2768
Rlm_1837_1838 tree_1837 tree_1838 3.2768
Rlm_1841_1842 tree_1841 tree_1842 3.2768
Rlm_1844_1845 tree_1844 tree_1845 3.2768
Rlm_1847_1848 tree_1847 tree_1848 3.2768
Rlm_1851_1852 tree_1851 tree_1852 3.2768
Rlm_1854_1855 tree_1854 tree_1855 3.2768
Rlm_1857_1858 tree_1857 tree_1858 3.2768
Rlm_1861_1862 tree_1861 tree_1862 3.2768
Rlm_1864_1865 tree_1864 tree_1865 3.2768
Rlm_1867_1868 tree_1867 tree_1868 3.2768
Rlm_1871_1872 tree_1871 tree_1872 3.2768
Rlm_1874_1875 tree_1874 tree_1875 3.2768
Rlm_1877_1878 tree_1877 tree_1878 3.2768
Rlm_1881_1882 tree_1881 tree_1882 3.2768
Rlm_1884_1885 tree_1884 tree_1885 3.2768
Rlm_1887_1888 tree_1887 tree_1888 3.2768
Rlm_1891_1892 tree_1891 tree_1892 3.2768
Rlm_1894_1895 tree_1894 tree_1895 3.2768
Rlm_1897_1898 tree_1897 tree_1898 3.2768
Rlm_1901_1902 tree_1901 tree_1902 3.2768
Rlm_1904_1905 tree_1904 tree_1905 3.2768
Rlm_1907_1908 tree_1907 tree_1908 3.2768
Rlm_1911_1912 tree_1911 tree_1912 3.2768
Rlm_1914_1915 tree_1914 tree_1915 3.2768
Rlm_1917_1918 tree_1917 tree_1918 3.2768
Rlm_1921_1922 tree_1921 tree_1922 3.2768
Rlm_1924_1925 tree_1924 tree_1925 3.2768
Rlm_1927_1928 tree_1927 tree_1928 3.2768
Rlm_1931_1932 tree_1931 tree_1932 3.2768
Rlm_1934_1935 tree_1934 tree_1935 3.2768
Rlm_1937_1938 tree_1937 tree_1938 3.2768
Rlm_1941_1942 tree_1941 tree_1942 3.2768
Rlm_1944_1945 tree_1944 tree_1945 3.2768
Rlm_1947_1948 tree_1947 tree_1948 3.2768
Rlm_1951_1952 tree_1951 tree_1952 3.2768
Rlm_1954_1955 tree_1954 tree_1955 3.2768
Rlm_1957_1958 tree_1957 tree_1958 3.2768
Rlm_1961_1962 tree_1961 tree_1962 3.2768
Rlm_1964_1965 tree_1964 tree_1965 3.2768
Rlm_1967_1968 tree_1967 tree_1968 3.2768
Rlm_1971_1972 tree_1971 tree_1972 3.2768
Rlm_1974_1975 tree_1974 tree_1975 3.2768
Rlm_1977_1978 tree_1977 tree_1978 3.2768
Rlm_1981_1982 tree_1981 tree_1982 3.2768
Rlm_1984_1985 tree_1984 tree_1985 3.2768
Rlm_1987_1988 tree_1987 tree_1988 3.2768
Rlm_1991_1992 tree_1991 tree_1992 3.2768
Rlm_1994_1995 tree_1994 tree_1995 3.2768
Rlm_1997_1998 tree_1997 tree_1998 3.2768
Rlm_2001_2002 tree_2001 tree_2002 3.2768
Rlm_2004_2005 tree_2004 tree_2005 3.2768
Rlm_2007_2008 tree_2007 tree_2008 3.2768
Rlm_2011_2012 tree_2011 tree_2012 3.2768
Rlm_2014_2015 tree_2014 tree_2015 3.2768
Rlm_2017_2018 tree_2017 tree_2018 3.2768
Rlm_2021_2022 tree_2021 tree_2022 3.2768
Rlm_2024_2025 tree_2024 tree_2025 3.2768
Rlm_2027_2028 tree_2027 tree_2028 3.2768
Rlm_2031_2032 tree_2031 tree_2032 3.2768
Rlm_2034_2035 tree_2034 tree_2035 3.2768
Rlm_2037_2038 tree_2037 tree_2038 3.2768
Rlm_2041_2042 tree_2041 tree_2042 3.2768
Rlm_2044_2045 tree_2044 tree_2045 3.2768
Rlm_2047_2048 tree_2047 tree_2048 3.2768
Rlm_2051_2052 tree_2051 tree_2052 3.2768
Rlm_2054_2055 tree_2054 tree_2055 3.2768
Rlm_2057_2058 tree_2057 tree_2058 3.2768
Rlm_2061_2062 tree_2061 tree_2062 3.2768
Rlm_2064_2065 tree_2064 tree_2065 3.2768
Rlm_2067_2068 tree_2067 tree_2068 3.2768
Rlm_2071_2072 tree_2071 tree_2072 3.2768
Rlm_2074_2075 tree_2074 tree_2075 3.2768
Rlm_2077_2078 tree_2077 tree_2078 3.2768
Rlm_2081_2082 tree_2081 tree_2082 3.2768
Rlm_2084_2085 tree_2084 tree_2085 3.2768
Rlm_2087_2088 tree_2087 tree_2088 3.2768
Rlm_2091_2092 tree_2091 tree_2092 3.2768
Rlm_2094_2095 tree_2094 tree_2095 3.2768
Rlm_2097_2098 tree_2097 tree_2098 3.2768
Rlm_2101_2102 tree_2101 tree_2102 3.2768
Rlm_2104_2105 tree_2104 tree_2105 3.2768
Rlm_2107_2108 tree_2107 tree_2108 3.2768
Rlm_2111_2112 tree_2111 tree_2112 3.2768
Rlm_2114_2115 tree_2114 tree_2115 3.2768
Rlm_2117_2118 tree_2117 tree_2118 3.2768
Rlm_2121_2122 tree_2121 tree_2122 3.2768
Rlm_2124_2125 tree_2124 tree_2125 3.2768
Rlm_2127_2128 tree_2127 tree_2128 3.2768
Rlm_2131_2132 tree_2131 tree_2132 3.2768
Rlm_2134_2135 tree_2134 tree_2135 3.2768
Rlm_2137_2138 tree_2137 tree_2138 3.2768
Rlm_2141_2142 tree_2141 tree_2142 3.2768
Rlm_2144_2145 tree_2144 tree_2145 3.2768
Rlm_2147_2148 tree_2147 tree_2148 3.2768
Rlm_2151_2152 tree_2151 tree_2152 3.2768
Rlm_2154_2155 tree_2154 tree_2155 3.2768
Rlm_2157_2158 tree_2157 tree_2158 3.2768
Rlm_2161_2162 tree_2161 tree_2162 3.2768
Rlm_2164_2165 tree_2164 tree_2165 3.2768
Rlm_2167_2168 tree_2167 tree_2168 3.2768
Rlm_2171_2172 tree_2171 tree_2172 3.2768
Rlm_2174_2175 tree_2174 tree_2175 3.2768
Rlm_2177_2178 tree_2177 tree_2178 3.2768
Rlm_2181_2182 tree_2181 tree_2182 3.2768
Rlm_2184_2185 tree_2184 tree_2185 3.2768
Rlm_2187_2188 tree_2187 tree_2188 3.2768
Rlm_2191_2192 tree_2191 tree_2192 3.2768
Rlm_2194_2195 tree_2194 tree_2195 3.2768
Rlm_2197_2198 tree_2197 tree_2198 3.2768
Rlm_2201_2202 tree_2201 tree_2202 3.2768
Rlm_2204_2205 tree_2204 tree_2205 3.2768
Rlm_2207_2208 tree_2207 tree_2208 3.2768
Rlm_2211_2212 tree_2211 tree_2212 3.2768
Rlm_2214_2215 tree_2214 tree_2215 3.2768
Rlm_2217_2218 tree_2217 tree_2218 3.2768
Rlm_2221_2222 tree_2221 tree_2222 3.2768
Rlm_2224_2225 tree_2224 tree_2225 3.2768
Rlm_2227_2228 tree_2227 tree_2228 3.2768
Rlm_2231_2232 tree_2231 tree_2232 3.2768
Rlm_2234_2235 tree_2234 tree_2235 3.2768
Rlm_2237_2238 tree_2237 tree_2238 3.2768
Rlm_2241_2242 tree_2241 tree_2242 3.2768
Rlm_2244_2245 tree_2244 tree_2245 3.2768
Rlm_2247_2248 tree_2247 tree_2248 3.2768
Rlm_2251_2252 tree_2251 tree_2252 3.2768
Rlm_2254_2255 tree_2254 tree_2255 3.2768
Rlm_2257_2258 tree_2257 tree_2258 3.2768
Rlm_2261_2262 tree_2261 tree_2262 3.2768
Rlm_2264_2265 tree_2264 tree_2265 3.2768
Rlm_2267_2268 tree_2267 tree_2268 3.2768
Rlm_2271_2272 tree_2271 tree_2272 3.2768
Rlm_2274_2275 tree_2274 tree_2275 3.2768
Rlm_2277_2278 tree_2277 tree_2278 3.2768
Rlm_2281_2282 tree_2281 tree_2282 3.2768
Rlm_2284_2285 tree_2284 tree_2285 3.2768
Rlm_2287_2288 tree_2287 tree_2288 3.2768
Rlm_2291_2292 tree_2291 tree_2292 3.2768
Rlm_2294_2295 tree_2294 tree_2295 3.2768
Rlm_2297_2298 tree_2297 tree_2298 3.2768
Rlm_2301_2302 tree_2301 tree_2302 3.2768
Rlm_2304_2305 tree_2304 tree_2305 3.2768
Rlm_2307_2308 tree_2307 tree_2308 3.2768
Rlm_2311_2312 tree_2311 tree_2312 3.2768
Rlm_2314_2315 tree_2314 tree_2315 3.2768
Rlm_2317_2318 tree_2317 tree_2318 3.2768
Rlm_2321_2322 tree_2321 tree_2322 3.2768
Rlm_2324_2325 tree_2324 tree_2325 3.2768
Rlm_2327_2328 tree_2327 tree_2328 3.2768
Rlm_2331_2332 tree_2331 tree_2332 3.2768
Rlm_2334_2335 tree_2334 tree_2335 3.2768
Rlm_2337_2338 tree_2337 tree_2338 3.2768
Rlm_2341_2342 tree_2341 tree_2342 3.2768
Rlm_2344_2345 tree_2344 tree_2345 3.2768
Rlm_2347_2348 tree_2347 tree_2348 3.2768
Rlm_2351_2352 tree_2351 tree_2352 3.2768
Rlm_2354_2355 tree_2354 tree_2355 3.2768
Rlm_2357_2358 tree_2357 tree_2358 3.2768
Rlm_2361_2362 tree_2361 tree_2362 3.2768
Rlm_2364_2365 tree_2364 tree_2365 3.2768
Rlm_2367_2368 tree_2367 tree_2368 3.2768
Rlm_2371_2372 tree_2371 tree_2372 3.2768
Rlm_2374_2375 tree_2374 tree_2375 3.2768
Rlm_2377_2378 tree_2377 tree_2378 3.2768
Rlm_2381_2382 tree_2381 tree_2382 3.2768
Rlm_2384_2385 tree_2384 tree_2385 3.2768
Rlm_2387_2388 tree_2387 tree_2388 3.2768
Rlm_2391_2392 tree_2391 tree_2392 3.2768
Rlm_2394_2395 tree_2394 tree_2395 3.2768
Rlm_2397_2398 tree_2397 tree_2398 3.2768
Rlm_2401_2402 tree_2401 tree_2402 3.2768
Rlm_2404_2405 tree_2404 tree_2405 3.2768
Rlm_2407_2408 tree_2407 tree_2408 3.2768
Rlm_2411_2412 tree_2411 tree_2412 3.2768
Rlm_2414_2415 tree_2414 tree_2415 3.2768
Rlm_2417_2418 tree_2417 tree_2418 3.2768
Rlm_2421_2422 tree_2421 tree_2422 3.2768
Rlm_2424_2425 tree_2424 tree_2425 3.2768
Rlm_2427_2428 tree_2427 tree_2428 3.2768
Rlm_2431_2432 tree_2431 tree_2432 3.2768
Rlm_2434_2435 tree_2434 tree_2435 3.2768
Rlm_2437_2438 tree_2437 tree_2438 3.2768
Rlm_2441_2442 tree_2441 tree_2442 3.2768
Rlm_2444_2445 tree_2444 tree_2445 3.2768
Rlm_2447_2448 tree_2447 tree_2448 3.2768
Rlm_2451_2452 tree_2451 tree_2452 3.2768
Rlm_2454_2455 tree_2454 tree_2455 3.2768
Rlm_2457_2458 tree_2457 tree_2458 3.2768
Rlm_2461_2462 tree_2461 tree_2462 3.2768
Rlm_2464_2465 tree_2464 tree_2465 3.2768
Rlm_2467_2468 tree_2467 tree_2468 3.2768
Rlm_2471_2472 tree_2471 tree_2472 3.2768
Rlm_2474_2475 tree_2474 tree_2475 3.2768
Rlm_2477_2478 tree_2477 tree_2478 3.2768
Rlm_2481_2482 tree_2481 tree_2482 3.2768
Rlm_2484_2485 tree_2484 tree_2485 3.2768
Rlm_2487_2488 tree_2487 tree_2488 3.2768
Rlm_2491_2492 tree_2491 tree_2492 3.2768
Rlm_2494_2495 tree_2494 tree_2495 3.2768
Rlm_2497_2498 tree_2497 tree_2498 3.2768
Rlm_2501_2502 tree_2501 tree_2502 3.2768
Rlm_2504_2505 tree_2504 tree_2505 3.2768
Rlm_2507_2508 tree_2507 tree_2508 3.2768
Rlm_2511_2512 tree_2511 tree_2512 3.2768
Rlm_2514_2515 tree_2514 tree_2515 3.2768
Rlm_2517_2518 tree_2517 tree_2518 3.2768
Rlm_2521_2522 tree_2521 tree_2522 3.2768
Rlm_2524_2525 tree_2524 tree_2525 3.2768
Rlm_2527_2528 tree_2527 tree_2528 3.2768
Rlm_2531_2532 tree_2531 tree_2532 3.2768
Rlm_2534_2535 tree_2534 tree_2535 3.2768
Rlm_2537_2538 tree_2537 tree_2538 3.2768
Rlm_2541_2542 tree_2541 tree_2542 3.2768
Rlm_2544_2545 tree_2544 tree_2545 3.2768
Rlm_2547_2548 tree_2547 tree_2548 3.2768
Rlm_2551_2552 tree_2551 tree_2552 3.2768
Rlm_2554_2555 tree_2554 tree_2555 3.2768
Rlm_2557_2558 tree_2557 tree_2558 3.2768
Rlm_2561_2562 tree_2561 tree_2562 3.2768
Rlm_2564_2565 tree_2564 tree_2565 3.2768
Rlm_2567_2568 tree_2567 tree_2568 3.2768
Rlm_2571_2572 tree_2571 tree_2572 3.2768
Rlm_2574_2575 tree_2574 tree_2575 3.2768
Rlm_2577_2578 tree_2577 tree_2578 3.2768
Rlm_2581_2582 tree_2581 tree_2582 3.2768
Rlm_2584_2585 tree_2584 tree_2585 3.2768
Rlm_2587_2588 tree_2587 tree_2588 3.2768
Rlm_2591_2592 tree_2591 tree_2592 3.2768
Rlm_2594_2595 tree_2594 tree_2595 3.2768
Rlm_2597_2598 tree_2597 tree_2598 3.2768
Rlm_2601_2602 tree_2601 tree_2602 3.2768
Rlm_2604_2605 tree_2604 tree_2605 3.2768
Rlm_2607_2608 tree_2607 tree_2608 3.2768
Rlm_2611_2612 tree_2611 tree_2612 3.2768
Rlm_2614_2615 tree_2614 tree_2615 3.2768
Rlm_2617_2618 tree_2617 tree_2618 3.2768
Rlm_2621_2622 tree_2621 tree_2622 3.2768
Rlm_2624_2625 tree_2624 tree_2625 3.2768
Rlm_2627_2628 tree_2627 tree_2628 3.2768
Rlm_2631_2632 tree_2631 tree_2632 3.2768
Rlm_2634_2635 tree_2634 tree_2635 3.2768
Rlm_2637_2638 tree_2637 tree_2638 3.2768
Rlm_2641_2642 tree_2641 tree_2642 3.2768
Rlm_2644_2645 tree_2644 tree_2645 3.2768
Rlm_2647_2648 tree_2647 tree_2648 3.2768
Rlm_2651_2652 tree_2651 tree_2652 3.2768
Rlm_2654_2655 tree_2654 tree_2655 3.2768
Rlm_2657_2658 tree_2657 tree_2658 3.2768
Rlm_2661_2662 tree_2661 tree_2662 3.2768
Rlm_2664_2665 tree_2664 tree_2665 3.2768
Rlm_2667_2668 tree_2667 tree_2668 3.2768
Rlm_2671_2672 tree_2671 tree_2672 3.2768
Rlm_2674_2675 tree_2674 tree_2675 3.2768
Rlm_2677_2678 tree_2677 tree_2678 3.2768
Rlm_2681_2682 tree_2681 tree_2682 3.2768
Rlm_2684_2685 tree_2684 tree_2685 3.2768
Rlm_2687_2688 tree_2687 tree_2688 3.2768
Rlm_2691_2692 tree_2691 tree_2692 3.2768
Rlm_2694_2695 tree_2694 tree_2695 3.2768
Rlm_2697_2698 tree_2697 tree_2698 3.2768
Rlm_2701_2702 tree_2701 tree_2702 3.2768
Rlm_2704_2705 tree_2704 tree_2705 3.2768
Rlm_2707_2708 tree_2707 tree_2708 3.2768
Rlm_2711_2712 tree_2711 tree_2712 3.2768
Rlm_2714_2715 tree_2714 tree_2715 3.2768
Rlm_2717_2718 tree_2717 tree_2718 3.2768
Rlm_2721_2722 tree_2721 tree_2722 3.2768
Rlm_2724_2725 tree_2724 tree_2725 3.2768
Rlm_2727_2728 tree_2727 tree_2728 3.2768
Rlm_2731_2732 tree_2731 tree_2732 3.2768
Rlm_2734_2735 tree_2734 tree_2735 3.2768
Rlm_2737_2738 tree_2737 tree_2738 3.2768
Rlm_2741_2742 tree_2741 tree_2742 3.2768
Rlm_2744_2745 tree_2744 tree_2745 3.2768
Rlm_2747_2748 tree_2747 tree_2748 3.2768
Rlm_2751_2752 tree_2751 tree_2752 3.2768
Rlm_2754_2755 tree_2754 tree_2755 3.2768
Rlm_2757_2758 tree_2757 tree_2758 3.2768
Rlm_2761_2762 tree_2761 tree_2762 3.2768
Rlm_2764_2765 tree_2764 tree_2765 3.2768
Rlm_2767_2768 tree_2767 tree_2768 3.2768
Rlm_2771_2772 tree_2771 tree_2772 3.2768
Rlm_2774_2775 tree_2774 tree_2775 3.2768
Rlm_2777_2778 tree_2777 tree_2778 3.2768
Rlm_2781_2782 tree_2781 tree_2782 3.2768
Rlm_2784_2785 tree_2784 tree_2785 3.2768
Rlm_2787_2788 tree_2787 tree_2788 3.2768
Rlm_2791_2792 tree_2791 tree_2792 3.2768
Rlm_2794_2795 tree_2794 tree_2795 3.2768
Rlm_2797_2798 tree_2797 tree_2798 3.2768
Rlm_2801_2802 tree_2801 tree_2802 3.2768
Rlm_2804_2805 tree_2804 tree_2805 3.2768
Rlm_2807_2808 tree_2807 tree_2808 3.2768
Rlm_2811_2812 tree_2811 tree_2812 3.2768
Rlm_2814_2815 tree_2814 tree_2815 3.2768
Rlm_2817_2818 tree_2817 tree_2818 3.2768
Rlm_2821_2822 tree_2821 tree_2822 3.2768
Rlm_2824_2825 tree_2824 tree_2825 3.2768
Rlm_2827_2828 tree_2827 tree_2828 3.2768
Rlm_2831_2832 tree_2831 tree_2832 3.2768
Rlm_2834_2835 tree_2834 tree_2835 3.2768
Rlm_2837_2838 tree_2837 tree_2838 3.2768
Rlm_2841_2842 tree_2841 tree_2842 3.2768
Rlm_2844_2845 tree_2844 tree_2845 3.2768
Rlm_2847_2848 tree_2847 tree_2848 3.2768
Rlm_2851_2852 tree_2851 tree_2852 3.2768
Rlm_2854_2855 tree_2854 tree_2855 3.2768
Rlm_2857_2858 tree_2857 tree_2858 3.2768
Rlm_2861_2862 tree_2861 tree_2862 3.2768
Rlm_2864_2865 tree_2864 tree_2865 3.2768
Rlm_2867_2868 tree_2867 tree_2868 3.2768
Rlm_2871_2872 tree_2871 tree_2872 3.2768
Rlm_2874_2875 tree_2874 tree_2875 3.2768
Rlm_2877_2878 tree_2877 tree_2878 3.2768
Rlm_2881_2882 tree_2881 tree_2882 3.2768
Rlm_2884_2885 tree_2884 tree_2885 3.2768
Rlm_2887_2888 tree_2887 tree_2888 3.2768
Rlm_2891_2892 tree_2891 tree_2892 3.2768
Rlm_2894_2895 tree_2894 tree_2895 3.2768
Rlm_2897_2898 tree_2897 tree_2898 3.2768
Rlm_2901_2902 tree_2901 tree_2902 3.2768
Rlm_2904_2905 tree_2904 tree_2905 3.2768
Rlm_2907_2908 tree_2907 tree_2908 3.2768
Rlm_2911_2912 tree_2911 tree_2912 3.2768
Rlm_2914_2915 tree_2914 tree_2915 3.2768
Rlm_2917_2918 tree_2917 tree_2918 3.2768
Rlm_2921_2922 tree_2921 tree_2922 3.2768
Rlm_2924_2925 tree_2924 tree_2925 3.2768
Rlm_2927_2928 tree_2927 tree_2928 3.2768
Rlm_2931_2932 tree_2931 tree_2932 3.2768
Rlm_2934_2935 tree_2934 tree_2935 3.2768
Rlm_2937_2938 tree_2937 tree_2938 3.2768
Rlm_2941_2942 tree_2941 tree_2942 3.2768
Rlm_2944_2945 tree_2944 tree_2945 3.2768
Rlm_2947_2948 tree_2947 tree_2948 3.2768
Rlm_2951_2952 tree_2951 tree_2952 3.2768
Rlm_2954_2955 tree_2954 tree_2955 3.2768
Rlm_2957_2958 tree_2957 tree_2958 3.2768
Rlm_2961_2962 tree_2961 tree_2962 3.2768
Rlm_2964_2965 tree_2964 tree_2965 3.2768
Rlm_2967_2968 tree_2967 tree_2968 3.2768
Rlm_2971_2972 tree_2971 tree_2972 3.2768
Rlm_2974_2975 tree_2974 tree_2975 3.2768
Rlm_2977_2978 tree_2977 tree_2978 3.2768
Rlm_2981_2982 tree_2981 tree_2982 3.2768
Rlm_2984_2985 tree_2984 tree_2985 3.2768
Rlm_2987_2988 tree_2987 tree_2988 3.2768
Rlm_2991_2992 tree_2991 tree_2992 3.2768
Rlm_2994_2995 tree_2994 tree_2995 3.2768
Rlm_2997_2998 tree_2997 tree_2998 3.2768
Rlm_3001_3002 tree_3001 tree_3002 3.2768
Rlm_3004_3005 tree_3004 tree_3005 3.2768
Rlm_3007_3008 tree_3007 tree_3008 3.2768
Rlm_3011_3012 tree_3011 tree_3012 3.2768
Rlm_3014_3015 tree_3014 tree_3015 3.2768
Rlm_3017_3018 tree_3017 tree_3018 3.2768
Rlm_3021_3022 tree_3021 tree_3022 3.2768
Rlm_3024_3025 tree_3024 tree_3025 3.2768
Rlm_3027_3028 tree_3027 tree_3028 3.2768
Rlm_3031_3032 tree_3031 tree_3032 3.2768
Rlm_3034_3035 tree_3034 tree_3035 3.2768
Rlm_3037_3038 tree_3037 tree_3038 3.2768
Rlm_3041_3042 tree_3041 tree_3042 3.2768
Rlm_3044_3045 tree_3044 tree_3045 3.2768
Rlm_3047_3048 tree_3047 tree_3048 3.2768
Rlm_3051_3052 tree_3051 tree_3052 3.2768
Rlm_3054_3055 tree_3054 tree_3055 3.2768
Rlm_3057_3058 tree_3057 tree_3058 3.2768
Rlm_3061_3062 tree_3061 tree_3062 3.2768
Rlm_3064_3065 tree_3064 tree_3065 3.2768
Rlm_3067_3068 tree_3067 tree_3068 3.2768
Rlm_3071_3072 tree_3071 tree_3072 3.2768
Rlm_3074_3075 tree_3074 tree_3075 3.2768
Rlm_3077_3078 tree_3077 tree_3078 3.2768
Rlm_3081_3082 tree_3081 tree_3082 3.2768
Rlm_3084_3085 tree_3084 tree_3085 3.2768
Rlm_3087_3088 tree_3087 tree_3088 3.2768
Rlm_3091_3092 tree_3091 tree_3092 3.2768
Rlm_3094_3095 tree_3094 tree_3095 3.2768
Rlm_3097_3098 tree_3097 tree_3098 3.2768
Rlm_3101_3102 tree_3101 tree_3102 3.2768
Rlm_3104_3105 tree_3104 tree_3105 3.2768
Rlm_3107_3108 tree_3107 tree_3108 3.2768
Rlm_3111_3112 tree_3111 tree_3112 3.2768
Rlm_3114_3115 tree_3114 tree_3115 3.2768
Rlm_3117_3118 tree_3117 tree_3118 3.2768
Rlm_3121_3122 tree_3121 tree_3122 3.2768
Rlm_3124_3125 tree_3124 tree_3125 3.2768
Rlm_3127_3128 tree_3127 tree_3128 3.2768
Rlm_3131_3132 tree_3131 tree_3132 3.2768
Rlm_3134_3135 tree_3134 tree_3135 3.2768
Rlm_3137_3138 tree_3137 tree_3138 3.2768
Rlm_3141_3142 tree_3141 tree_3142 3.2768
Rlm_3144_3145 tree_3144 tree_3145 3.2768
Rlm_3147_3148 tree_3147 tree_3148 3.2768
Rlm_3151_3152 tree_3151 tree_3152 3.2768
Rlm_3154_3155 tree_3154 tree_3155 3.2768
Rlm_3157_3158 tree_3157 tree_3158 3.2768
Rlm_3161_3162 tree_3161 tree_3162 3.2768
Rlm_3164_3165 tree_3164 tree_3165 3.2768
Rlm_3167_3168 tree_3167 tree_3168 3.2768
Rlm_3171_3172 tree_3171 tree_3172 3.2768
Rlm_3174_3175 tree_3174 tree_3175 3.2768
Rlm_3177_3178 tree_3177 tree_3178 3.2768
Rlm_3181_3182 tree_3181 tree_3182 3.2768
Rlm_3184_3185 tree_3184 tree_3185 3.2768
Rlm_3187_3188 tree_3187 tree_3188 3.2768
Rlm_3191_3192 tree_3191 tree_3192 3.2768
Rlm_3194_3195 tree_3194 tree_3195 3.2768
Rlm_3197_3198 tree_3197 tree_3198 3.2768
Rlm_3201_3202 tree_3201 tree_3202 3.2768
Rlm_3204_3205 tree_3204 tree_3205 3.2768
Rlm_3207_3208 tree_3207 tree_3208 3.2768
Rlm_3211_3212 tree_3211 tree_3212 3.2768
Rlm_3214_3215 tree_3214 tree_3215 3.2768
Rlm_3217_3218 tree_3217 tree_3218 3.2768
Rlm_3221_3222 tree_3221 tree_3222 3.2768
Rlm_3224_3225 tree_3224 tree_3225 3.2768
Rlm_3227_3228 tree_3227 tree_3228 3.2768
Rlm_3231_3232 tree_3231 tree_3232 3.2768
Rlm_3234_3235 tree_3234 tree_3235 3.2768
Rlm_3237_3238 tree_3237 tree_3238 3.2768
Rlm_3241_3242 tree_3241 tree_3242 3.2768
Rlm_3244_3245 tree_3244 tree_3245 3.2768
Rlm_3247_3248 tree_3247 tree_3248 3.2768
Rlm_3251_3252 tree_3251 tree_3252 3.2768
Rlm_3254_3255 tree_3254 tree_3255 3.2768
Rlm_3257_3258 tree_3257 tree_3258 3.2768
Rlm_3261_3262 tree_3261 tree_3262 3.2768
Rlm_3264_3265 tree_3264 tree_3265 3.2768
Rlm_3267_3268 tree_3267 tree_3268 3.2768
Rlm_3271_3272 tree_3271 tree_3272 3.2768
Rlm_3274_3275 tree_3274 tree_3275 3.2768
Rlm_3277_3278 tree_3277 tree_3278 3.2768
Rlm_3281_3282 tree_3281 tree_3282 3.2768
Rlm_3284_3285 tree_3284 tree_3285 3.2768
Rlm_3287_3288 tree_3287 tree_3288 3.2768
Rlm_3291_3292 tree_3291 tree_3292 3.2768
Rlm_3294_3295 tree_3294 tree_3295 3.2768
Rlm_3297_3298 tree_3297 tree_3298 3.2768
Rlm_3301_3302 tree_3301 tree_3302 3.2768
Rlm_3304_3305 tree_3304 tree_3305 3.2768
Rlm_3307_3308 tree_3307 tree_3308 3.2768
Rlm_3311_3312 tree_3311 tree_3312 3.2768
Rlm_3314_3315 tree_3314 tree_3315 3.2768
Rlm_3317_3318 tree_3317 tree_3318 3.2768
Rlm_3321_3322 tree_3321 tree_3322 3.2768
Rlm_3324_3325 tree_3324 tree_3325 3.2768
Rlm_3327_3328 tree_3327 tree_3328 3.2768
Rlm_3331_3332 tree_3331 tree_3332 3.2768
Rlm_3334_3335 tree_3334 tree_3335 3.2768
Rlm_3337_3338 tree_3337 tree_3338 3.2768
Rlm_3341_3342 tree_3341 tree_3342 3.2768
Rlm_3344_3345 tree_3344 tree_3345 3.2768
Rlm_3347_3348 tree_3347 tree_3348 3.2768
Rlm_3351_3352 tree_3351 tree_3352 3.2768
Rlm_3354_3355 tree_3354 tree_3355 3.2768
Rlm_3357_3358 tree_3357 tree_3358 3.2768
Rlm_3361_3362 tree_3361 tree_3362 3.2768
Rlm_3364_3365 tree_3364 tree_3365 3.2768
Rlm_3367_3368 tree_3367 tree_3368 3.2768
Rlm_3371_3372 tree_3371 tree_3372 3.2768
Rlm_3374_3375 tree_3374 tree_3375 3.2768
Rlm_3377_3378 tree_3377 tree_3378 3.2768
Rlm_3381_3382 tree_3381 tree_3382 3.2768
Rlm_3384_3385 tree_3384 tree_3385 3.2768
Rlm_3387_3388 tree_3387 tree_3388 3.2768
Rlm_3391_3392 tree_3391 tree_3392 3.2768
Rlm_3394_3395 tree_3394 tree_3395 3.2768
Rlm_3397_3398 tree_3397 tree_3398 3.2768
Rlm_3401_3402 tree_3401 tree_3402 3.2768
Rlm_3404_3405 tree_3404 tree_3405 3.2768
Rlm_3407_3408 tree_3407 tree_3408 3.2768
Rlm_3411_3412 tree_3411 tree_3412 3.2768
Rlm_3414_3415 tree_3414 tree_3415 3.2768
Rlm_3417_3418 tree_3417 tree_3418 3.2768
Rlm_3421_3422 tree_3421 tree_3422 3.2768
Rlm_3424_3425 tree_3424 tree_3425 3.2768
Rlm_3427_3428 tree_3427 tree_3428 3.2768
Rlm_3431_3432 tree_3431 tree_3432 3.2768
Rlm_3434_3435 tree_3434 tree_3435 3.2768
Rlm_3437_3438 tree_3437 tree_3438 3.2768
Rlm_3441_3442 tree_3441 tree_3442 3.2768
Rlm_3444_3445 tree_3444 tree_3445 3.2768
Rlm_3447_3448 tree_3447 tree_3448 3.2768
Rlm_3451_3452 tree_3451 tree_3452 3.2768
Rlm_3454_3455 tree_3454 tree_3455 3.2768
Rlm_3457_3458 tree_3457 tree_3458 3.2768
Rlm_3461_3462 tree_3461 tree_3462 3.2768
Rlm_3464_3465 tree_3464 tree_3465 3.2768
Rlm_3467_3468 tree_3467 tree_3468 3.2768
Rlm_3471_3472 tree_3471 tree_3472 3.2768
Rlm_3474_3475 tree_3474 tree_3475 3.2768
Rlm_3477_3478 tree_3477 tree_3478 3.2768
Rlm_3481_3482 tree_3481 tree_3482 3.2768
Rlm_3484_3485 tree_3484 tree_3485 3.2768
Rlm_3487_3488 tree_3487 tree_3488 3.2768
Rlm_3491_3492 tree_3491 tree_3492 3.2768
Rlm_3494_3495 tree_3494 tree_3495 3.2768
Rlm_3497_3498 tree_3497 tree_3498 3.2768
Rlm_3501_3502 tree_3501 tree_3502 3.2768
Rlm_3504_3505 tree_3504 tree_3505 3.2768
Rlm_3507_3508 tree_3507 tree_3508 3.2768
Rlm_3511_3512 tree_3511 tree_3512 3.2768
Rlm_3514_3515 tree_3514 tree_3515 3.2768
Rlm_3517_3518 tree_3517 tree_3518 3.2768
Rlm_3521_3522 tree_3521 tree_3522 3.2768
Rlm_3524_3525 tree_3524 tree_3525 3.2768
Rlm_3527_3528 tree_3527 tree_3528 3.2768
Rlm_3531_3532 tree_3531 tree_3532 3.2768
Rlm_3534_3535 tree_3534 tree_3535 3.2768
Rlm_3537_3538 tree_3537 tree_3538 3.2768
Rlm_3541_3542 tree_3541 tree_3542 3.2768
Rlm_3544_3545 tree_3544 tree_3545 3.2768
Rlm_3547_3548 tree_3547 tree_3548 3.2768
Rlm_3551_3552 tree_3551 tree_3552 3.2768
Rlm_3554_3555 tree_3554 tree_3555 3.2768
Rlm_3557_3558 tree_3557 tree_3558 3.2768
Rlm_3561_3562 tree_3561 tree_3562 3.2768
Rlm_3564_3565 tree_3564 tree_3565 3.2768
Rlm_3567_3568 tree_3567 tree_3568 3.2768
Rlm_3571_3572 tree_3571 tree_3572 3.2768
Rlm_3574_3575 tree_3574 tree_3575 3.2768
Rlm_3577_3578 tree_3577 tree_3578 3.2768
Rlm_3581_3582 tree_3581 tree_3582 3.2768
Rlm_3584_3585 tree_3584 tree_3585 3.2768
Rlm_3587_3588 tree_3587 tree_3588 3.2768
Rlm_3591_3592 tree_3591 tree_3592 3.2768
Rlm_3594_3595 tree_3594 tree_3595 3.2768
Rlm_3597_3598 tree_3597 tree_3598 3.2768
Rlm_3601_3602 tree_3601 tree_3602 3.2768
Rlm_3604_3605 tree_3604 tree_3605 3.2768
Rlm_3607_3608 tree_3607 tree_3608 3.2768
Rlm_3611_3612 tree_3611 tree_3612 3.2768
Rlm_3614_3615 tree_3614 tree_3615 3.2768
Rlm_3617_3618 tree_3617 tree_3618 3.2768
Rlm_3621_3622 tree_3621 tree_3622 3.2768
Rlm_3624_3625 tree_3624 tree_3625 3.2768
Rlm_3627_3628 tree_3627 tree_3628 3.2768
Rlm_3631_3632 tree_3631 tree_3632 3.2768
Rlm_3634_3635 tree_3634 tree_3635 3.2768
Rlm_3637_3638 tree_3637 tree_3638 3.2768
Rlm_3641_3642 tree_3641 tree_3642 3.2768
Rlm_3644_3645 tree_3644 tree_3645 3.2768
Rlm_3647_3648 tree_3647 tree_3648 3.2768
Rlm_3651_3652 tree_3651 tree_3652 3.2768
Rlm_3654_3655 tree_3654 tree_3655 3.2768
Rlm_3657_3658 tree_3657 tree_3658 3.2768
Rlm_3661_3662 tree_3661 tree_3662 3.2768
Rlm_3664_3665 tree_3664 tree_3665 3.2768
Rlm_3667_3668 tree_3667 tree_3668 3.2768
Rlm_3671_3672 tree_3671 tree_3672 3.2768
Rlm_3674_3675 tree_3674 tree_3675 3.2768
Rlm_3677_3678 tree_3677 tree_3678 3.2768
Rlm_3681_3682 tree_3681 tree_3682 3.2768
Rlm_3684_3685 tree_3684 tree_3685 3.2768
Rlm_3687_3688 tree_3687 tree_3688 3.2768
Rlm_3691_3692 tree_3691 tree_3692 3.2768
Rlm_3694_3695 tree_3694 tree_3695 3.2768
Rlm_3697_3698 tree_3697 tree_3698 3.2768
Rlm_3701_3702 tree_3701 tree_3702 3.2768
Rlm_3704_3705 tree_3704 tree_3705 3.2768
Rlm_3707_3708 tree_3707 tree_3708 3.2768
Rlm_3711_3712 tree_3711 tree_3712 3.2768
Rlm_3714_3715 tree_3714 tree_3715 3.2768
Rlm_3717_3718 tree_3717 tree_3718 3.2768
Rlm_3721_3722 tree_3721 tree_3722 3.2768
Rlm_3724_3725 tree_3724 tree_3725 3.2768
Rlm_3727_3728 tree_3727 tree_3728 3.2768
Rlm_3731_3732 tree_3731 tree_3732 3.2768
Rlm_3734_3735 tree_3734 tree_3735 3.2768
Rlm_3737_3738 tree_3737 tree_3738 3.2768
Rlm_3741_3742 tree_3741 tree_3742 3.2768
Rlm_3744_3745 tree_3744 tree_3745 3.2768
Rlm_3747_3748 tree_3747 tree_3748 3.2768
Rlm_3751_3752 tree_3751 tree_3752 3.2768
Rlm_3754_3755 tree_3754 tree_3755 3.2768
Rlm_3757_3758 tree_3757 tree_3758 3.2768
Rlm_3761_3762 tree_3761 tree_3762 3.2768
Rlm_3764_3765 tree_3764 tree_3765 3.2768
Rlm_3767_3768 tree_3767 tree_3768 3.2768
Rlm_3771_3772 tree_3771 tree_3772 3.2768
Rlm_3774_3775 tree_3774 tree_3775 3.2768
Rlm_3777_3778 tree_3777 tree_3778 3.2768
Rlm_3781_3782 tree_3781 tree_3782 3.2768
Rlm_3784_3785 tree_3784 tree_3785 3.2768
Rlm_3787_3788 tree_3787 tree_3788 3.2768
Rlm_3791_3792 tree_3791 tree_3792 3.2768
Rlm_3794_3795 tree_3794 tree_3795 3.2768
Rlm_3797_3798 tree_3797 tree_3798 3.2768
Rlm_3801_3802 tree_3801 tree_3802 3.2768
Rlm_3804_3805 tree_3804 tree_3805 3.2768
Rlm_3807_3808 tree_3807 tree_3808 3.2768
Rlm_3811_3812 tree_3811 tree_3812 3.2768
Rlm_3814_3815 tree_3814 tree_3815 3.2768
Rlm_3817_3818 tree_3817 tree_3818 3.2768
Rlm_3821_3822 tree_3821 tree_3822 3.2768
Rlm_3824_3825 tree_3824 tree_3825 3.2768
Rlm_3827_3828 tree_3827 tree_3828 3.2768
Rlm_3831_3832 tree_3831 tree_3832 3.2768
Rlm_3834_3835 tree_3834 tree_3835 3.2768
Rlm_3837_3838 tree_3837 tree_3838 3.2768
Rlm_3841_3842 tree_3841 tree_3842 3.2768
Rlm_3844_3845 tree_3844 tree_3845 3.2768
Rlm_3847_3848 tree_3847 tree_3848 3.2768
Rlm_3851_3852 tree_3851 tree_3852 3.2768
Rlm_3854_3855 tree_3854 tree_3855 3.2768
Rlm_3857_3858 tree_3857 tree_3858 3.2768
Rlm_3861_3862 tree_3861 tree_3862 3.2768
Rlm_3864_3865 tree_3864 tree_3865 3.2768
Rlm_3867_3868 tree_3867 tree_3868 3.2768
Rlm_3871_3872 tree_3871 tree_3872 3.2768
Rlm_3874_3875 tree_3874 tree_3875 3.2768
Rlm_3877_3878 tree_3877 tree_3878 3.2768
Rlm_3881_3882 tree_3881 tree_3882 3.2768
Rlm_3884_3885 tree_3884 tree_3885 3.2768
Rlm_3887_3888 tree_3887 tree_3888 3.2768
Rlm_3891_3892 tree_3891 tree_3892 3.2768
Rlm_3894_3895 tree_3894 tree_3895 3.2768
Rlm_3897_3898 tree_3897 tree_3898 3.2768
Rlm_3901_3902 tree_3901 tree_3902 3.2768
Rlm_3904_3905 tree_3904 tree_3905 3.2768
Rlm_3907_3908 tree_3907 tree_3908 3.2768
Rlm_3911_3912 tree_3911 tree_3912 3.2768
Rlm_3914_3915 tree_3914 tree_3915 3.2768
Rlm_3917_3918 tree_3917 tree_3918 3.2768
Rlm_3921_3922 tree_3921 tree_3922 3.2768
Rlm_3924_3925 tree_3924 tree_3925 3.2768
Rlm_3927_3928 tree_3927 tree_3928 3.2768
Rlm_3931_3932 tree_3931 tree_3932 3.2768
Rlm_3934_3935 tree_3934 tree_3935 3.2768
Rlm_3937_3938 tree_3937 tree_3938 3.2768
Rlm_3941_3942 tree_3941 tree_3942 3.2768
Rlm_3944_3945 tree_3944 tree_3945 3.2768
Rlm_3947_3948 tree_3947 tree_3948 3.2768
Rlm_3951_3952 tree_3951 tree_3952 3.2768
Rlm_3954_3955 tree_3954 tree_3955 3.2768
Rlm_3957_3958 tree_3957 tree_3958 3.2768
Rlm_3961_3962 tree_3961 tree_3962 3.2768
Rlm_3964_3965 tree_3964 tree_3965 3.2768
Rlm_3967_3968 tree_3967 tree_3968 3.2768
Rlm_3971_3972 tree_3971 tree_3972 3.2768
Rlm_3974_3975 tree_3974 tree_3975 3.2768
Rlm_3977_3978 tree_3977 tree_3978 3.2768
Rlm_3981_3982 tree_3981 tree_3982 3.2768
Rlm_3984_3985 tree_3984 tree_3985 3.2768
Rlm_3987_3988 tree_3987 tree_3988 3.2768
Rlm_3991_3992 tree_3991 tree_3992 3.2768
Rlm_3994_3995 tree_3994 tree_3995 3.2768
Rlm_3997_3998 tree_3997 tree_3998 3.2768
Rlm_4001_4002 tree_4001 tree_4002 3.2768
Rlm_4004_4005 tree_4004 tree_4005 3.2768
Rlm_4007_4008 tree_4007 tree_4008 3.2768
Rlm_4011_4012 tree_4011 tree_4012 3.2768
Rlm_4014_4015 tree_4014 tree_4015 3.2768
Rlm_4017_4018 tree_4017 tree_4018 3.2768
Rlm_4021_4022 tree_4021 tree_4022 3.2768
Rlm_4024_4025 tree_4024 tree_4025 3.2768
Rlm_4027_4028 tree_4027 tree_4028 3.2768
Rlm_4031_4032 tree_4031 tree_4032 3.2768
Rlm_4034_4035 tree_4034 tree_4035 3.2768
Rlm_4037_4038 tree_4037 tree_4038 3.2768
Rlm_4041_4042 tree_4041 tree_4042 3.2768
Rlm_4044_4045 tree_4044 tree_4045 3.2768
Rlm_4047_4048 tree_4047 tree_4048 3.2768
Rlm_4051_4052 tree_4051 tree_4052 3.2768
Rlm_4054_4055 tree_4054 tree_4055 3.2768
Rlm_4057_4058 tree_4057 tree_4058 3.2768
Rlm_4061_4062 tree_4061 tree_4062 3.2768
Rlm_4064_4065 tree_4064 tree_4065 3.2768
Rlm_4067_4068 tree_4067 tree_4068 3.2768
Rlm_4071_4072 tree_4071 tree_4072 3.2768
Rlm_4074_4075 tree_4074 tree_4075 3.2768
Rlm_4077_4078 tree_4077 tree_4078 3.2768
Rlm_4081_4082 tree_4081 tree_4082 3.2768
Rlm_4084_4085 tree_4084 tree_4085 3.2768
Rlm_4087_4088 tree_4087 tree_4088 3.2768
Rlm_4091_4092 tree_4091 tree_4092 3.2768
Rlm_4094_4095 tree_4094 tree_4095 3.2768
Rlm_4097_4098 tree_4097 tree_4098 3.2768
Rlm_4101_4102 tree_4101 tree_4102 3.2768
Rlm_4104_4105 tree_4104 tree_4105 3.2768
Rlm_4107_4108 tree_4107 tree_4108 3.2768
Rlm_4111_4112 tree_4111 tree_4112 3.2768
Rlm_4114_4115 tree_4114 tree_4115 3.2768
Rlm_4117_4118 tree_4117 tree_4118 3.2768
Rlm_4121_4122 tree_4121 tree_4122 3.2768
Rlm_4124_4125 tree_4124 tree_4125 3.2768
Rlm_4127_4128 tree_4127 tree_4128 3.2768
Rlm_4131_4132 tree_4131 tree_4132 3.2768
Rlm_4134_4135 tree_4134 tree_4135 3.2768
Rlm_4137_4138 tree_4137 tree_4138 3.2768
Rlm_4141_4142 tree_4141 tree_4142 3.2768
Rlm_4144_4145 tree_4144 tree_4145 3.2768
Rlm_4147_4148 tree_4147 tree_4148 3.2768
Rlm_4151_4152 tree_4151 tree_4152 3.2768
Rlm_4154_4155 tree_4154 tree_4155 3.2768
Rlm_4157_4158 tree_4157 tree_4158 3.2768
Rlm_4161_4162 tree_4161 tree_4162 3.2768
Rlm_4164_4165 tree_4164 tree_4165 3.2768
Rlm_4167_4168 tree_4167 tree_4168 3.2768
Rlm_4171_4172 tree_4171 tree_4172 3.2768
Rlm_4174_4175 tree_4174 tree_4175 3.2768
Rlm_4177_4178 tree_4177 tree_4178 3.2768
Rlm_4181_4182 tree_4181 tree_4182 3.2768
Rlm_4184_4185 tree_4184 tree_4185 3.2768
Rlm_4187_4188 tree_4187 tree_4188 3.2768
Rlm_4191_4192 tree_4191 tree_4192 3.2768
Rlm_4194_4195 tree_4194 tree_4195 3.2768
Rlm_4197_4198 tree_4197 tree_4198 3.2768
Rlm_4201_4202 tree_4201 tree_4202 3.2768
Rlm_4204_4205 tree_4204 tree_4205 3.2768
Rlm_4207_4208 tree_4207 tree_4208 3.2768
Rlm_4211_4212 tree_4211 tree_4212 3.2768
Rlm_4214_4215 tree_4214 tree_4215 3.2768
Rlm_4217_4218 tree_4217 tree_4218 3.2768
Rlm_4221_4222 tree_4221 tree_4222 3.2768
Rlm_4224_4225 tree_4224 tree_4225 3.2768
Rlm_4227_4228 tree_4227 tree_4228 3.2768
Rlm_4231_4232 tree_4231 tree_4232 3.2768
Rlm_4234_4235 tree_4234 tree_4235 3.2768
Rlm_4237_4238 tree_4237 tree_4238 3.2768
Rlm_4241_4242 tree_4241 tree_4242 3.2768
Rlm_4244_4245 tree_4244 tree_4245 3.2768
Rlm_4247_4248 tree_4247 tree_4248 3.2768
Rlm_4251_4252 tree_4251 tree_4252 3.2768
Rlm_4254_4255 tree_4254 tree_4255 3.2768
Rlm_4257_4258 tree_4257 tree_4258 3.2768
Rlm_4261_4262 tree_4261 tree_4262 3.2768
Rlm_4264_4265 tree_4264 tree_4265 3.2768
Rlm_4267_4268 tree_4267 tree_4268 3.2768
Rlm_4271_4272 tree_4271 tree_4272 3.2768
Rlm_4274_4275 tree_4274 tree_4275 3.2768
Rlm_4277_4278 tree_4277 tree_4278 3.2768
Rlm_4281_4282 tree_4281 tree_4282 3.2768
Rlm_4284_4285 tree_4284 tree_4285 3.2768
Rlm_4287_4288 tree_4287 tree_4288 3.2768
Rlm_4291_4292 tree_4291 tree_4292 3.2768
Rlm_4294_4295 tree_4294 tree_4295 3.2768
Rlm_4297_4298 tree_4297 tree_4298 3.2768
Rlm_4301_4302 tree_4301 tree_4302 3.2768
Rlm_4304_4305 tree_4304 tree_4305 3.2768
Rlm_4307_4308 tree_4307 tree_4308 3.2768
Rlm_4311_4312 tree_4311 tree_4312 3.2768
Rlm_4314_4315 tree_4314 tree_4315 3.2768
Rlm_4317_4318 tree_4317 tree_4318 3.2768
Rlm_4321_4322 tree_4321 tree_4322 3.2768
Rlm_4324_4325 tree_4324 tree_4325 3.2768
Rlm_4327_4328 tree_4327 tree_4328 3.2768
Rlm_4331_4332 tree_4331 tree_4332 3.2768
Rlm_4334_4335 tree_4334 tree_4335 3.2768
Rlm_4337_4338 tree_4337 tree_4338 3.2768
Rlm_4341_4342 tree_4341 tree_4342 3.2768
Rlm_4344_4345 tree_4344 tree_4345 3.2768
Rlm_4347_4348 tree_4347 tree_4348 3.2768
Rlm_4351_4352 tree_4351 tree_4352 3.2768
Rlm_4354_4355 tree_4354 tree_4355 3.2768
Rlm_4357_4358 tree_4357 tree_4358 3.2768
Rlm_4361_4362 tree_4361 tree_4362 3.2768
Rlm_4364_4365 tree_4364 tree_4365 3.2768
Rlm_4367_4368 tree_4367 tree_4368 3.2768
Rlm_4371_4372 tree_4371 tree_4372 3.2768
Rlm_4374_4375 tree_4374 tree_4375 3.2768
Rlm_4377_4378 tree_4377 tree_4378 3.2768
Rlm_4381_4382 tree_4381 tree_4382 3.2768
Rlm_4384_4385 tree_4384 tree_4385 3.2768
Rlm_4387_4388 tree_4387 tree_4388 3.2768
Rlm_4391_4392 tree_4391 tree_4392 3.2768
Rlm_4394_4395 tree_4394 tree_4395 3.2768
Rlm_4397_4398 tree_4397 tree_4398 3.2768
Rlm_4401_4402 tree_4401 tree_4402 3.2768
Rlm_4404_4405 tree_4404 tree_4405 3.2768
Rlm_4407_4408 tree_4407 tree_4408 3.2768
Rlm_4411_4412 tree_4411 tree_4412 3.2768
Rlm_4414_4415 tree_4414 tree_4415 3.2768
Rlm_4417_4418 tree_4417 tree_4418 3.2768
Rlm_4421_4422 tree_4421 tree_4422 3.2768
Rlm_4424_4425 tree_4424 tree_4425 3.2768
Rlm_4427_4428 tree_4427 tree_4428 3.2768
Rlm_4431_4432 tree_4431 tree_4432 3.2768
Rlm_4434_4435 tree_4434 tree_4435 3.2768
Rlm_4437_4438 tree_4437 tree_4438 3.2768
Rlm_4441_4442 tree_4441 tree_4442 3.2768
Rlm_4444_4445 tree_4444 tree_4445 3.2768
Rlm_4447_4448 tree_4447 tree_4448 3.2768
Rlm_4451_4452 tree_4451 tree_4452 3.2768
Rlm_4454_4455 tree_4454 tree_4455 3.2768
Rlm_4457_4458 tree_4457 tree_4458 3.2768
Rlm_4461_4462 tree_4461 tree_4462 3.2768
Rlm_4464_4465 tree_4464 tree_4465 3.2768
Rlm_4467_4468 tree_4467 tree_4468 3.2768
Rlm_4471_4472 tree_4471 tree_4472 3.2768
Rlm_4474_4475 tree_4474 tree_4475 3.2768
Rlm_4477_4478 tree_4477 tree_4478 3.2768
Rlm_4481_4482 tree_4481 tree_4482 3.2768
Rlm_4484_4485 tree_4484 tree_4485 3.2768
Rlm_4487_4488 tree_4487 tree_4488 3.2768
Rlm_4491_4492 tree_4491 tree_4492 3.2768
Rlm_4494_4495 tree_4494 tree_4495 3.2768
Rlm_4497_4498 tree_4497 tree_4498 3.2768
Rlm_4501_4502 tree_4501 tree_4502 3.2768
Rlm_4504_4505 tree_4504 tree_4505 3.2768
Rlm_4507_4508 tree_4507 tree_4508 3.2768
Rlm_4511_4512 tree_4511 tree_4512 3.2768
Rlm_4514_4515 tree_4514 tree_4515 3.2768
Rlm_4517_4518 tree_4517 tree_4518 3.2768
Rlm_4521_4522 tree_4521 tree_4522 3.2768
Rlm_4524_4525 tree_4524 tree_4525 3.2768
Rlm_4527_4528 tree_4527 tree_4528 3.2768
Rlm_4531_4532 tree_4531 tree_4532 3.2768
Rlm_4534_4535 tree_4534 tree_4535 3.2768
Rlm_4537_4538 tree_4537 tree_4538 3.2768
Rlm_4541_4542 tree_4541 tree_4542 3.2768
Rlm_4544_4545 tree_4544 tree_4545 3.2768
Rlm_4547_4548 tree_4547 tree_4548 3.2768
Rlm_4551_4552 tree_4551 tree_4552 3.2768
Rlm_4554_4555 tree_4554 tree_4555 3.2768
Rlm_4557_4558 tree_4557 tree_4558 3.2768
Rlm_4561_4562 tree_4561 tree_4562 3.2768
Rlm_4564_4565 tree_4564 tree_4565 3.2768
Rlm_4567_4568 tree_4567 tree_4568 3.2768
Rlm_4571_4572 tree_4571 tree_4572 3.2768
Rlm_4574_4575 tree_4574 tree_4575 3.2768
Rlm_4577_4578 tree_4577 tree_4578 3.2768
Rlm_4581_4582 tree_4581 tree_4582 3.2768
Rlm_4584_4585 tree_4584 tree_4585 3.2768
Rlm_4587_4588 tree_4587 tree_4588 3.2768
Rlm_4591_4592 tree_4591 tree_4592 3.2768
Rlm_4594_4595 tree_4594 tree_4595 3.2768
Rlm_4597_4598 tree_4597 tree_4598 3.2768
Rlm_4601_4602 tree_4601 tree_4602 3.2768
Rlm_4604_4605 tree_4604 tree_4605 3.2768
Rlm_4607_4608 tree_4607 tree_4608 3.2768
Rlm_4611_4612 tree_4611 tree_4612 3.2768
Rlm_4614_4615 tree_4614 tree_4615 3.2768
Rlm_4617_4618 tree_4617 tree_4618 3.2768
Rlm_4621_4622 tree_4621 tree_4622 3.2768
Rlm_4624_4625 tree_4624 tree_4625 3.2768
Rlm_4627_4628 tree_4627 tree_4628 3.2768
Rlm_4631_4632 tree_4631 tree_4632 3.2768
Rlm_4634_4635 tree_4634 tree_4635 3.2768
Rlm_4637_4638 tree_4637 tree_4638 3.2768
Rlm_4641_4642 tree_4641 tree_4642 3.2768
Rlm_4644_4645 tree_4644 tree_4645 3.2768
Rlm_4647_4648 tree_4647 tree_4648 3.2768
Rlm_4651_4652 tree_4651 tree_4652 3.2768
Rlm_4654_4655 tree_4654 tree_4655 3.2768
Rlm_4657_4658 tree_4657 tree_4658 3.2768
Rlm_4661_4662 tree_4661 tree_4662 3.2768
Rlm_4664_4665 tree_4664 tree_4665 3.2768
Rlm_4667_4668 tree_4667 tree_4668 3.2768
Rlm_4671_4672 tree_4671 tree_4672 3.2768
Rlm_4674_4675 tree_4674 tree_4675 3.2768
Rlm_4677_4678 tree_4677 tree_4678 3.2768
Rlm_4681_4682 tree_4681 tree_4682 3.2768
Rlm_4684_4685 tree_4684 tree_4685 3.2768
Rlm_4687_4688 tree_4687 tree_4688 3.2768
Rlm_4691_4692 tree_4691 tree_4692 3.2768
Rlm_4694_4695 tree_4694 tree_4695 3.2768
Rlm_4697_4698 tree_4697 tree_4698 3.2768
Rlm_4701_4702 tree_4701 tree_4702 3.2768
Rlm_4704_4705 tree_4704 tree_4705 3.2768
Rlm_4707_4708 tree_4707 tree_4708 3.2768
Rlm_4711_4712 tree_4711 tree_4712 3.2768
Rlm_4714_4715 tree_4714 tree_4715 3.2768
Rlm_4717_4718 tree_4717 tree_4718 3.2768
Rlm_4721_4722 tree_4721 tree_4722 3.2768
Rlm_4724_4725 tree_4724 tree_4725 3.2768
Rlm_4727_4728 tree_4727 tree_4728 3.2768
Rlm_4731_4732 tree_4731 tree_4732 3.2768
Rlm_4734_4735 tree_4734 tree_4735 3.2768
Rlm_4737_4738 tree_4737 tree_4738 3.2768
Rlm_4741_4742 tree_4741 tree_4742 3.2768
Rlm_4744_4745 tree_4744 tree_4745 3.2768
Rlm_4747_4748 tree_4747 tree_4748 3.2768
Rlm_4751_4752 tree_4751 tree_4752 3.2768
Rlm_4754_4755 tree_4754 tree_4755 3.2768
Rlm_4757_4758 tree_4757 tree_4758 3.2768
Rlm_4761_4762 tree_4761 tree_4762 3.2768
Rlm_4764_4765 tree_4764 tree_4765 3.2768
Rlm_4767_4768 tree_4767 tree_4768 3.2768
Rlm_4771_4772 tree_4771 tree_4772 3.2768
Rlm_4774_4775 tree_4774 tree_4775 3.2768
Rlm_4777_4778 tree_4777 tree_4778 3.2768
Rlm_4781_4782 tree_4781 tree_4782 3.2768
Rlm_4784_4785 tree_4784 tree_4785 3.2768
Rlm_4787_4788 tree_4787 tree_4788 3.2768
Rlm_4791_4792 tree_4791 tree_4792 3.2768
Rlm_4794_4795 tree_4794 tree_4795 3.2768
Rlm_4797_4798 tree_4797 tree_4798 3.2768
Rlm_4801_4802 tree_4801 tree_4802 3.2768
Rlm_4804_4805 tree_4804 tree_4805 3.2768
Rlm_4807_4808 tree_4807 tree_4808 3.2768
Rlm_4811_4812 tree_4811 tree_4812 3.2768
Rlm_4814_4815 tree_4814 tree_4815 3.2768
Rlm_4817_4818 tree_4817 tree_4818 3.2768
Rlm_4821_4822 tree_4821 tree_4822 3.2768
Rlm_4824_4825 tree_4824 tree_4825 3.2768
Rlm_4827_4828 tree_4827 tree_4828 3.2768
Rlm_4831_4832 tree_4831 tree_4832 3.2768
Rlm_4834_4835 tree_4834 tree_4835 3.2768
Rlm_4837_4838 tree_4837 tree_4838 3.2768
Rlm_4841_4842 tree_4841 tree_4842 3.2768
Rlm_4844_4845 tree_4844 tree_4845 3.2768
Rlm_4847_4848 tree_4847 tree_4848 3.2768
Rlm_4851_4852 tree_4851 tree_4852 3.2768
Rlm_4854_4855 tree_4854 tree_4855 3.2768
Rlm_4857_4858 tree_4857 tree_4858 3.2768
Rlm_4861_4862 tree_4861 tree_4862 3.2768
Rlm_4864_4865 tree_4864 tree_4865 3.2768
Rlm_4867_4868 tree_4867 tree_4868 3.2768
Rlm_4871_4872 tree_4871 tree_4872 3.2768
Rlm_4874_4875 tree_4874 tree_4875 3.2768
Rlm_4877_4878 tree_4877 tree_4878 3.2768
Rlm_4881_4882 tree_4881 tree_4882 3.2768
Rlm_4884_4885 tree_4884 tree_4885 3.2768
Rlm_4887_4888 tree_4887 tree_4888 3.2768
Rlm_4891_4892 tree_4891 tree_4892 3.2768
Rlm_4894_4895 tree_4894 tree_4895 3.2768
Rlm_4897_4898 tree_4897 tree_4898 3.2768
Rlm_4901_4902 tree_4901 tree_4902 3.2768
Rlm_4904_4905 tree_4904 tree_4905 3.2768
Rlm_4907_4908 tree_4907 tree_4908 3.2768
Rlm_4911_4912 tree_4911 tree_4912 3.2768
Rlm_4914_4915 tree_4914 tree_4915 3.2768
Rlm_4917_4918 tree_4917 tree_4918 3.2768
Rlm_4921_4922 tree_4921 tree_4922 3.2768
Rlm_4924_4925 tree_4924 tree_4925 3.2768
Rlm_4927_4928 tree_4927 tree_4928 3.2768
Rlm_4931_4932 tree_4931 tree_4932 3.2768
Rlm_4934_4935 tree_4934 tree_4935 3.2768
Rlm_4937_4938 tree_4937 tree_4938 3.2768
Rlm_4941_4942 tree_4941 tree_4942 3.2768
Rlm_4944_4945 tree_4944 tree_4945 3.2768
Rlm_4947_4948 tree_4947 tree_4948 3.2768
Rlm_4951_4952 tree_4951 tree_4952 3.2768
Rlm_4954_4955 tree_4954 tree_4955 3.2768
Rlm_4957_4958 tree_4957 tree_4958 3.2768
Rlm_4961_4962 tree_4961 tree_4962 3.2768
Rlm_4964_4965 tree_4964 tree_4965 3.2768
Rlm_4967_4968 tree_4967 tree_4968 3.2768
Rlm_4971_4972 tree_4971 tree_4972 3.2768
Rlm_4974_4975 tree_4974 tree_4975 3.2768
Rlm_4977_4978 tree_4977 tree_4978 3.2768
Rlm_4981_4982 tree_4981 tree_4982 3.2768
Rlm_4984_4985 tree_4984 tree_4985 3.2768
Rlm_4987_4988 tree_4987 tree_4988 3.2768
Rlm_4991_4992 tree_4991 tree_4992 3.2768
Rlm_4994_4995 tree_4994 tree_4995 3.2768
Rlm_4997_4998 tree_4997 tree_4998 3.2768
Rlm_5001_5002 tree_5001 tree_5002 3.2768
Rlm_5004_5005 tree_5004 tree_5005 3.2768
Rlm_5007_5008 tree_5007 tree_5008 3.2768
Rlm_5011_5012 tree_5011 tree_5012 3.2768
Rlm_5014_5015 tree_5014 tree_5015 3.2768
Rlm_5017_5018 tree_5017 tree_5018 3.2768
Rlm_5021_5022 tree_5021 tree_5022 3.2768
Rlm_5024_5025 tree_5024 tree_5025 3.2768
Rlm_5027_5028 tree_5027 tree_5028 3.2768
Rlm_5031_5032 tree_5031 tree_5032 3.2768
Rlm_5034_5035 tree_5034 tree_5035 3.2768
Rlm_5037_5038 tree_5037 tree_5038 3.2768
Rlm_5041_5042 tree_5041 tree_5042 3.2768
Rlm_5044_5045 tree_5044 tree_5045 3.2768
Rlm_5047_5048 tree_5047 tree_5048 3.2768
Rlm_5051_5052 tree_5051 tree_5052 3.2768
Rlm_5054_5055 tree_5054 tree_5055 3.2768
Rlm_5057_5058 tree_5057 tree_5058 3.2768
Rlm_5061_5062 tree_5061 tree_5062 3.2768
Rlm_5064_5065 tree_5064 tree_5065 3.2768
Rlm_5067_5068 tree_5067 tree_5068 3.2768
Rlm_5071_5072 tree_5071 tree_5072 3.2768
Rlm_5074_5075 tree_5074 tree_5075 3.2768
Rlm_5077_5078 tree_5077 tree_5078 3.2768
Rlm_5081_5082 tree_5081 tree_5082 3.2768
Rlm_5084_5085 tree_5084 tree_5085 3.2768
Rlm_5087_5088 tree_5087 tree_5088 3.2768
Rlm_5091_5092 tree_5091 tree_5092 3.2768
Rlm_5094_5095 tree_5094 tree_5095 3.2768
Rlm_5097_5098 tree_5097 tree_5098 3.2768
Rlm_5101_5102 tree_5101 tree_5102 3.2768
Rlm_5104_5105 tree_5104 tree_5105 3.2768
Rlm_5107_5108 tree_5107 tree_5108 3.2768
Rlm_5111_5112 tree_5111 tree_5112 3.2768
Rlm_5114_5115 tree_5114 tree_5115 3.2768
Rlm_5117_5118 tree_5117 tree_5118 3.2768
Rlm_5121_5122 tree_5121 tree_5122 3.2768
Rlm_5124_5125 tree_5124 tree_5125 3.2768
Rlm_5127_5128 tree_5127 tree_5128 3.2768
Rlm_5131_5132 tree_5131 tree_5132 3.2768
Rlm_5134_5135 tree_5134 tree_5135 3.2768
Rlm_5137_5138 tree_5137 tree_5138 3.2768
Rlm_5141_5142 tree_5141 tree_5142 3.2768
Rlm_5144_5145 tree_5144 tree_5145 3.2768
Rlm_5147_5148 tree_5147 tree_5148 3.2768
Rlm_5151_5152 tree_5151 tree_5152 3.2768
Rlm_5154_5155 tree_5154 tree_5155 3.2768
Rlm_5157_5158 tree_5157 tree_5158 3.2768
Rlm_5161_5162 tree_5161 tree_5162 3.2768
Rlm_5164_5165 tree_5164 tree_5165 3.2768
Rlm_5167_5168 tree_5167 tree_5168 3.2768
Rlm_5171_5172 tree_5171 tree_5172 3.2768
Rlm_5174_5175 tree_5174 tree_5175 3.2768
Rlm_5177_5178 tree_5177 tree_5178 3.2768
Rlm_5181_5182 tree_5181 tree_5182 3.2768
Rlm_5184_5185 tree_5184 tree_5185 3.2768
Rlm_5187_5188 tree_5187 tree_5188 3.2768
Rlm_5191_5192 tree_5191 tree_5192 3.2768
Rlm_5194_5195 tree_5194 tree_5195 3.2768
Rlm_5197_5198 tree_5197 tree_5198 3.2768
Rlm_5201_5202 tree_5201 tree_5202 3.2768
Rlm_5204_5205 tree_5204 tree_5205 3.2768
Rlm_5207_5208 tree_5207 tree_5208 3.2768
Rlm_5211_5212 tree_5211 tree_5212 3.2768
Rlm_5214_5215 tree_5214 tree_5215 3.2768
Rlm_5217_5218 tree_5217 tree_5218 3.2768
Rlm_5221_5222 tree_5221 tree_5222 3.2768
Rlm_5224_5225 tree_5224 tree_5225 3.2768
Rlm_5227_5228 tree_5227 tree_5228 3.2768
Rlm_5231_5232 tree_5231 tree_5232 3.2768
Rlm_5234_5235 tree_5234 tree_5235 3.2768
Rlm_5237_5238 tree_5237 tree_5238 3.2768
Rlm_5241_5242 tree_5241 tree_5242 3.2768
Rlm_5244_5245 tree_5244 tree_5245 3.2768
Rlm_5247_5248 tree_5247 tree_5248 3.2768
Rlm_5251_5252 tree_5251 tree_5252 3.2768
Rlm_5254_5255 tree_5254 tree_5255 3.2768
Rlm_5257_5258 tree_5257 tree_5258 3.2768
Rlm_5261_5262 tree_5261 tree_5262 3.2768
Rlm_5264_5265 tree_5264 tree_5265 3.2768
Rlm_5267_5268 tree_5267 tree_5268 3.2768
Rlm_5271_5272 tree_5271 tree_5272 3.2768
Rlm_5274_5275 tree_5274 tree_5275 3.2768
Rlm_5277_5278 tree_5277 tree_5278 3.2768
Rlm_5281_5282 tree_5281 tree_5282 3.2768
Rlm_5284_5285 tree_5284 tree_5285 3.2768
Rlm_5287_5288 tree_5287 tree_5288 3.2768
Rlm_5291_5292 tree_5291 tree_5292 3.2768
Rlm_5294_5295 tree_5294 tree_5295 3.2768
Rlm_5297_5298 tree_5297 tree_5298 3.2768
Rlm_5301_5302 tree_5301 tree_5302 3.2768
Rlm_5304_5305 tree_5304 tree_5305 3.2768
Rlm_5307_5308 tree_5307 tree_5308 3.2768
Rlm_5311_5312 tree_5311 tree_5312 3.2768
Rlm_5314_5315 tree_5314 tree_5315 3.2768
Rlm_5317_5318 tree_5317 tree_5318 3.2768
Rlm_5321_5322 tree_5321 tree_5322 3.2768
Rlm_5324_5325 tree_5324 tree_5325 3.2768
Rlm_5327_5328 tree_5327 tree_5328 3.2768
Rlm_5331_5332 tree_5331 tree_5332 3.2768
Rlm_5334_5335 tree_5334 tree_5335 3.2768
Rlm_5337_5338 tree_5337 tree_5338 3.2768
Rlm_5341_5342 tree_5341 tree_5342 3.2768
Rlm_5344_5345 tree_5344 tree_5345 3.2768
Rlm_5347_5348 tree_5347 tree_5348 3.2768
Rlm_5351_5352 tree_5351 tree_5352 3.2768
Rlm_5354_5355 tree_5354 tree_5355 3.2768
Rlm_5357_5358 tree_5357 tree_5358 3.2768
Rlm_5361_5362 tree_5361 tree_5362 3.2768
Rlm_5364_5365 tree_5364 tree_5365 3.2768
Rlm_5367_5368 tree_5367 tree_5368 3.2768
Rlm_5371_5372 tree_5371 tree_5372 3.2768
Rlm_5374_5375 tree_5374 tree_5375 3.2768
Rlm_5377_5378 tree_5377 tree_5378 3.2768
Rlm_5381_5382 tree_5381 tree_5382 3.2768
Rlm_5384_5385 tree_5384 tree_5385 3.2768
Rlm_5387_5388 tree_5387 tree_5388 3.2768
Rlm_5391_5392 tree_5391 tree_5392 3.2768
Rlm_5394_5395 tree_5394 tree_5395 3.2768
Rlm_5397_5398 tree_5397 tree_5398 3.2768
Rlm_5401_5402 tree_5401 tree_5402 3.2768
Rlm_5404_5405 tree_5404 tree_5405 3.2768
Rlm_5407_5408 tree_5407 tree_5408 3.2768
Rlm_5411_5412 tree_5411 tree_5412 3.2768
Rlm_5414_5415 tree_5414 tree_5415 3.2768
Rlm_5417_5418 tree_5417 tree_5418 3.2768
Rlm_5421_5422 tree_5421 tree_5422 3.2768
Rlm_5424_5425 tree_5424 tree_5425 3.2768
Rlm_5427_5428 tree_5427 tree_5428 3.2768
Rlm_5431_5432 tree_5431 tree_5432 3.2768
Rlm_5434_5435 tree_5434 tree_5435 3.2768
Rlm_5437_5438 tree_5437 tree_5438 3.2768
Rlm_5441_5442 tree_5441 tree_5442 3.2768
Rlm_5444_5445 tree_5444 tree_5445 3.2768
Rlm_5447_5448 tree_5447 tree_5448 3.2768
Rlm_5451_5452 tree_5451 tree_5452 3.2768
Rlm_5454_5455 tree_5454 tree_5455 3.2768
Rlm_5457_5458 tree_5457 tree_5458 3.2768
Rlm_5461_5462 tree_5461 tree_5462 3.2768
Rlm_5464_5465 tree_5464 tree_5465 3.2768
Rlm_5467_5468 tree_5467 tree_5468 3.2768
Rlm_5471_5472 tree_5471 tree_5472 3.2768
Rlm_5474_5475 tree_5474 tree_5475 3.2768
Rlm_5477_5478 tree_5477 tree_5478 3.2768
Rlm_5481_5482 tree_5481 tree_5482 3.2768
Rlm_5484_5485 tree_5484 tree_5485 3.2768
Rlm_5487_5488 tree_5487 tree_5488 3.2768
Rlm_5491_5492 tree_5491 tree_5492 3.2768
Rlm_5494_5495 tree_5494 tree_5495 3.2768
Rlm_5497_5498 tree_5497 tree_5498 3.2768
Rlm_5501_5502 tree_5501 tree_5502 3.2768
Rlm_5504_5505 tree_5504 tree_5505 3.2768
Rlm_5507_5508 tree_5507 tree_5508 3.2768
Rlm_5511_5512 tree_5511 tree_5512 3.2768
Rlm_5514_5515 tree_5514 tree_5515 3.2768
Rlm_5517_5518 tree_5517 tree_5518 3.2768
Rlm_5521_5522 tree_5521 tree_5522 3.2768
Rlm_5524_5525 tree_5524 tree_5525 3.2768
Rlm_5527_5528 tree_5527 tree_5528 3.2768
Rlm_5531_5532 tree_5531 tree_5532 3.2768
Rlm_5534_5535 tree_5534 tree_5535 3.2768
Rlm_5537_5538 tree_5537 tree_5538 3.2768
Rlm_5541_5542 tree_5541 tree_5542 3.2768
Rlm_5544_5545 tree_5544 tree_5545 3.2768
Rlm_5547_5548 tree_5547 tree_5548 3.2768
Rlm_5551_5552 tree_5551 tree_5552 3.2768
Rlm_5554_5555 tree_5554 tree_5555 3.2768
Rlm_5557_5558 tree_5557 tree_5558 3.2768
Rlm_5561_5562 tree_5561 tree_5562 3.2768
Rlm_5564_5565 tree_5564 tree_5565 3.2768
Rlm_5567_5568 tree_5567 tree_5568 3.2768
Rlm_5571_5572 tree_5571 tree_5572 3.2768
Rlm_5574_5575 tree_5574 tree_5575 3.2768
Rlm_5577_5578 tree_5577 tree_5578 3.2768
Rlm_5581_5582 tree_5581 tree_5582 3.2768
Rlm_5584_5585 tree_5584 tree_5585 3.2768
Rlm_5587_5588 tree_5587 tree_5588 3.2768
Rlm_5591_5592 tree_5591 tree_5592 3.2768
Rlm_5594_5595 tree_5594 tree_5595 3.2768
Rlm_5597_5598 tree_5597 tree_5598 3.2768
Rlm_5601_5602 tree_5601 tree_5602 3.2768
Rlm_5604_5605 tree_5604 tree_5605 3.2768
Rlm_5607_5608 tree_5607 tree_5608 3.2768
Rlm_5611_5612 tree_5611 tree_5612 3.2768
Rlm_5614_5615 tree_5614 tree_5615 3.2768
Rlm_5617_5618 tree_5617 tree_5618 3.2768
Rlm_5621_5622 tree_5621 tree_5622 3.2768
Rlm_5624_5625 tree_5624 tree_5625 3.2768
Rlm_5627_5628 tree_5627 tree_5628 3.2768
Rlm_5631_5632 tree_5631 tree_5632 3.2768
Rlm_5634_5635 tree_5634 tree_5635 3.2768
Rlm_5637_5638 tree_5637 tree_5638 3.2768
Rlm_5641_5642 tree_5641 tree_5642 3.2768
Rlm_5644_5645 tree_5644 tree_5645 3.2768
Rlm_5647_5648 tree_5647 tree_5648 3.2768
Rlm_5651_5652 tree_5651 tree_5652 3.2768
Rlm_5654_5655 tree_5654 tree_5655 3.2768
Rlm_5657_5658 tree_5657 tree_5658 3.2768
Rlm_5661_5662 tree_5661 tree_5662 3.2768
Rlm_5664_5665 tree_5664 tree_5665 3.2768
Rlm_5667_5668 tree_5667 tree_5668 3.2768
Rlm_5671_5672 tree_5671 tree_5672 3.2768
Rlm_5674_5675 tree_5674 tree_5675 3.2768
Rlm_5677_5678 tree_5677 tree_5678 3.2768
Rlm_5681_5682 tree_5681 tree_5682 3.2768
Rlm_5684_5685 tree_5684 tree_5685 3.2768
Rlm_5687_5688 tree_5687 tree_5688 3.2768
Rlm_5691_5692 tree_5691 tree_5692 3.2768
Rlm_5694_5695 tree_5694 tree_5695 3.2768
Rlm_5697_5698 tree_5697 tree_5698 3.2768
Rlm_5701_5702 tree_5701 tree_5702 3.2768
Rlm_5704_5705 tree_5704 tree_5705 3.2768
Rlm_5707_5708 tree_5707 tree_5708 3.2768
Rlm_5711_5712 tree_5711 tree_5712 3.2768
Rlm_5714_5715 tree_5714 tree_5715 3.2768
Rlm_5717_5718 tree_5717 tree_5718 3.2768
Rlm_5721_5722 tree_5721 tree_5722 3.2768
Rlm_5724_5725 tree_5724 tree_5725 3.2768
Rlm_5727_5728 tree_5727 tree_5728 3.2768
Rlm_5731_5732 tree_5731 tree_5732 3.2768
Rlm_5734_5735 tree_5734 tree_5735 3.2768
Rlm_5737_5738 tree_5737 tree_5738 3.2768
Rlm_5741_5742 tree_5741 tree_5742 3.2768
Rlm_5744_5745 tree_5744 tree_5745 3.2768
Rlm_5747_5748 tree_5747 tree_5748 3.2768
Rlm_5751_5752 tree_5751 tree_5752 3.2768
Rlm_5754_5755 tree_5754 tree_5755 3.2768
Rlm_5757_5758 tree_5757 tree_5758 3.2768
Rlm_5761_5762 tree_5761 tree_5762 3.2768
Rlm_5764_5765 tree_5764 tree_5765 3.2768
Rlm_5767_5768 tree_5767 tree_5768 3.2768
Rlm_5771_5772 tree_5771 tree_5772 3.2768
Rlm_5774_5775 tree_5774 tree_5775 3.2768
Rlm_5777_5778 tree_5777 tree_5778 3.2768
Rlm_5781_5782 tree_5781 tree_5782 3.2768
Rlm_5784_5785 tree_5784 tree_5785 3.2768
Rlm_5787_5788 tree_5787 tree_5788 3.2768
Rlm_5791_5792 tree_5791 tree_5792 3.2768
Rlm_5794_5795 tree_5794 tree_5795 3.2768
Rlm_5797_5798 tree_5797 tree_5798 3.2768
Rlm_5801_5802 tree_5801 tree_5802 3.2768
Rlm_5804_5805 tree_5804 tree_5805 3.2768
Rlm_5807_5808 tree_5807 tree_5808 3.2768
Rlm_5811_5812 tree_5811 tree_5812 3.2768
Rlm_5814_5815 tree_5814 tree_5815 3.2768
Rlm_5817_5818 tree_5817 tree_5818 3.2768
Rlm_5821_5822 tree_5821 tree_5822 3.2768
Rlm_5824_5825 tree_5824 tree_5825 3.2768
Rlm_5827_5828 tree_5827 tree_5828 3.2768
Rlm_5831_5832 tree_5831 tree_5832 3.2768
Rlm_5834_5835 tree_5834 tree_5835 3.2768
Rlm_5837_5838 tree_5837 tree_5838 3.2768
Rlm_5841_5842 tree_5841 tree_5842 3.2768
Rlm_5844_5845 tree_5844 tree_5845 3.2768
Rlm_5847_5848 tree_5847 tree_5848 3.2768
Rlm_5851_5852 tree_5851 tree_5852 3.2768
Rlm_5854_5855 tree_5854 tree_5855 3.2768
Rlm_5857_5858 tree_5857 tree_5858 3.2768
Rlm_5861_5862 tree_5861 tree_5862 3.2768
Rlm_5864_5865 tree_5864 tree_5865 3.2768
Rlm_5867_5868 tree_5867 tree_5868 3.2768
Rlm_5871_5872 tree_5871 tree_5872 3.2768
Rlm_5874_5875 tree_5874 tree_5875 3.2768
Rlm_5877_5878 tree_5877 tree_5878 3.2768
Rlm_5881_5882 tree_5881 tree_5882 3.2768
Rlm_5884_5885 tree_5884 tree_5885 3.2768
Rlm_5887_5888 tree_5887 tree_5888 3.2768
Rlm_5891_5892 tree_5891 tree_5892 3.2768
Rlm_5894_5895 tree_5894 tree_5895 3.2768
Rlm_5897_5898 tree_5897 tree_5898 3.2768
Rlm_5901_5902 tree_5901 tree_5902 3.2768
Rlm_5904_5905 tree_5904 tree_5905 3.2768
Rlm_5907_5908 tree_5907 tree_5908 3.2768
Rlm_5911_5912 tree_5911 tree_5912 3.2768
Rlm_5914_5915 tree_5914 tree_5915 3.2768
Rlm_5917_5918 tree_5917 tree_5918 3.2768
Rlm_5921_5922 tree_5921 tree_5922 3.2768
Rlm_5924_5925 tree_5924 tree_5925 3.2768
Rlm_5927_5928 tree_5927 tree_5928 3.2768
Rlm_5931_5932 tree_5931 tree_5932 3.2768
Rlm_5934_5935 tree_5934 tree_5935 3.2768
Rlm_5937_5938 tree_5937 tree_5938 3.2768
Rlm_5941_5942 tree_5941 tree_5942 3.2768
Rlm_5944_5945 tree_5944 tree_5945 3.2768
Rlm_5947_5948 tree_5947 tree_5948 3.2768
Rlm_5951_5952 tree_5951 tree_5952 3.2768
Rlm_5954_5955 tree_5954 tree_5955 3.2768
Rlm_5957_5958 tree_5957 tree_5958 3.2768
Rlm_5961_5962 tree_5961 tree_5962 3.2768
Rlm_5964_5965 tree_5964 tree_5965 3.2768
Rlm_5967_5968 tree_5967 tree_5968 3.2768
Rlm_5971_5972 tree_5971 tree_5972 3.2768
Rlm_5974_5975 tree_5974 tree_5975 3.2768
Rlm_5977_5978 tree_5977 tree_5978 3.2768
Rlm_5981_5982 tree_5981 tree_5982 3.2768
Rlm_5984_5985 tree_5984 tree_5985 3.2768
Rlm_5987_5988 tree_5987 tree_5988 3.2768
Rlm_5991_5992 tree_5991 tree_5992 3.2768
Rlm_5994_5995 tree_5994 tree_5995 3.2768
Rlm_5997_5998 tree_5997 tree_5998 3.2768
Rlm_6001_6002 tree_6001 tree_6002 3.2768
Rlm_6004_6005 tree_6004 tree_6005 3.2768
Rlm_6007_6008 tree_6007 tree_6008 3.2768
Rlm_6011_6012 tree_6011 tree_6012 3.2768
Rlm_6014_6015 tree_6014 tree_6015 3.2768
Rlm_6017_6018 tree_6017 tree_6018 3.2768
Rlm_6021_6022 tree_6021 tree_6022 3.2768
Rlm_6024_6025 tree_6024 tree_6025 3.2768
Rlm_6027_6028 tree_6027 tree_6028 3.2768
Rlm_6031_6032 tree_6031 tree_6032 3.2768
Rlm_6034_6035 tree_6034 tree_6035 3.2768
Rlm_6037_6038 tree_6037 tree_6038 3.2768
Rlm_6041_6042 tree_6041 tree_6042 3.2768
Rlm_6044_6045 tree_6044 tree_6045 3.2768
Rlm_6047_6048 tree_6047 tree_6048 3.2768
Rlm_6051_6052 tree_6051 tree_6052 3.2768
Rlm_6054_6055 tree_6054 tree_6055 3.2768
Rlm_6057_6058 tree_6057 tree_6058 3.2768
Rlm_6061_6062 tree_6061 tree_6062 3.2768
Rlm_6064_6065 tree_6064 tree_6065 3.2768
Rlm_6067_6068 tree_6067 tree_6068 3.2768
Rlm_6071_6072 tree_6071 tree_6072 3.2768
Rlm_6074_6075 tree_6074 tree_6075 3.2768
Rlm_6077_6078 tree_6077 tree_6078 3.2768
Rlm_6081_6082 tree_6081 tree_6082 3.2768
Rlm_6084_6085 tree_6084 tree_6085 3.2768
Rlm_6087_6088 tree_6087 tree_6088 3.2768
Rlm_6091_6092 tree_6091 tree_6092 3.2768
Rlm_6094_6095 tree_6094 tree_6095 3.2768
Rlm_6097_6098 tree_6097 tree_6098 3.2768
Rlm_6101_6102 tree_6101 tree_6102 3.2768
Rlm_6104_6105 tree_6104 tree_6105 3.2768
Rlm_6107_6108 tree_6107 tree_6108 3.2768
Rlm_6111_6112 tree_6111 tree_6112 3.2768
Rlm_6114_6115 tree_6114 tree_6115 3.2768
Rlm_6117_6118 tree_6117 tree_6118 3.2768
Rlm_6121_6122 tree_6121 tree_6122 3.2768
Rlm_6124_6125 tree_6124 tree_6125 3.2768
Rlm_6127_6128 tree_6127 tree_6128 3.2768
Rlm_6131_6132 tree_6131 tree_6132 3.2768
Rlm_6134_6135 tree_6134 tree_6135 3.2768
Rlm_6137_6138 tree_6137 tree_6138 3.2768
Rlm_6141_6142 tree_6141 tree_6142 3.2768
Rlm_6144_6145 tree_6144 tree_6145 3.2768
Rlm_6147_6148 tree_6147 tree_6148 3.2768
Rlm_6151_6152 tree_6151 tree_6152 3.2768
Rlm_6154_6155 tree_6154 tree_6155 3.2768
Rlm_6157_6158 tree_6157 tree_6158 3.2768
Rlm_6161_6162 tree_6161 tree_6162 3.2768
Rlm_6164_6165 tree_6164 tree_6165 3.2768
Rlm_6167_6168 tree_6167 tree_6168 3.2768
Rlm_6171_6172 tree_6171 tree_6172 3.2768
Rlm_6174_6175 tree_6174 tree_6175 3.2768
Rlm_6177_6178 tree_6177 tree_6178 3.2768
Rlm_6181_6182 tree_6181 tree_6182 3.2768
Rlm_6184_6185 tree_6184 tree_6185 3.2768
Rlm_6187_6188 tree_6187 tree_6188 3.2768
Rlm_6191_6192 tree_6191 tree_6192 3.2768
Rlm_6194_6195 tree_6194 tree_6195 3.2768
Rlm_6197_6198 tree_6197 tree_6198 3.2768
Rlm_6201_6202 tree_6201 tree_6202 3.2768
Rlm_6204_6205 tree_6204 tree_6205 3.2768
Rlm_6207_6208 tree_6207 tree_6208 3.2768
Rlm_6211_6212 tree_6211 tree_6212 3.2768
Rlm_6214_6215 tree_6214 tree_6215 3.2768
Rlm_6217_6218 tree_6217 tree_6218 3.2768
Rlm_6221_6222 tree_6221 tree_6222 3.2768
Rlm_6224_6225 tree_6224 tree_6225 3.2768
Rlm_6227_6228 tree_6227 tree_6228 3.2768
Rlm_6231_6232 tree_6231 tree_6232 3.2768
Rlm_6234_6235 tree_6234 tree_6235 3.2768
Rlm_6237_6238 tree_6237 tree_6238 3.2768
Rlm_6241_6242 tree_6241 tree_6242 3.2768
Rlm_6244_6245 tree_6244 tree_6245 3.2768
Rlm_6247_6248 tree_6247 tree_6248 3.2768
Rlm_6251_6252 tree_6251 tree_6252 3.2768
Rlm_6254_6255 tree_6254 tree_6255 3.2768
Rlm_6257_6258 tree_6257 tree_6258 3.2768
Rlm_6261_6262 tree_6261 tree_6262 3.2768
Rlm_6264_6265 tree_6264 tree_6265 3.2768
Rlm_6267_6268 tree_6267 tree_6268 3.2768
Rlm_6271_6272 tree_6271 tree_6272 3.2768
Rlm_6274_6275 tree_6274 tree_6275 3.2768
Rlm_6277_6278 tree_6277 tree_6278 3.2768
Rlm_6281_6282 tree_6281 tree_6282 3.2768
Rlm_6284_6285 tree_6284 tree_6285 3.2768
Rlm_6287_6288 tree_6287 tree_6288 3.2768
Rlm_6291_6292 tree_6291 tree_6292 3.2768
Rlm_6294_6295 tree_6294 tree_6295 3.2768
Rlm_6297_6298 tree_6297 tree_6298 3.2768
Rlm_6301_6302 tree_6301 tree_6302 3.2768
Rlm_6304_6305 tree_6304 tree_6305 3.2768
Rlm_6307_6308 tree_6307 tree_6308 3.2768
Rlm_6311_6312 tree_6311 tree_6312 3.2768
Rlm_6314_6315 tree_6314 tree_6315 3.2768
Rlm_6317_6318 tree_6317 tree_6318 3.2768
Rlm_6321_6322 tree_6321 tree_6322 3.2768
Rlm_6324_6325 tree_6324 tree_6325 3.2768
Rlm_6327_6328 tree_6327 tree_6328 3.2768
Rlm_6331_6332 tree_6331 tree_6332 3.2768
Rlm_6334_6335 tree_6334 tree_6335 3.2768
Rlm_6337_6338 tree_6337 tree_6338 3.2768
Rlm_6341_6342 tree_6341 tree_6342 3.2768
Rlm_6344_6345 tree_6344 tree_6345 3.2768
Rlm_6347_6348 tree_6347 tree_6348 3.2768
Rlm_6351_6352 tree_6351 tree_6352 3.2768
Rlm_6354_6355 tree_6354 tree_6355 3.2768
Rlm_6357_6358 tree_6357 tree_6358 3.2768
Rlm_6361_6362 tree_6361 tree_6362 3.2768
Rlm_6364_6365 tree_6364 tree_6365 3.2768
Rlm_6367_6368 tree_6367 tree_6368 3.2768
Rlm_6371_6372 tree_6371 tree_6372 3.2768
Rlm_6374_6375 tree_6374 tree_6375 3.2768
Rlm_6377_6378 tree_6377 tree_6378 3.2768
Rlm_6381_6382 tree_6381 tree_6382 3.2768
Rlm_6384_6385 tree_6384 tree_6385 3.2768
Rlm_6387_6388 tree_6387 tree_6388 3.2768
Rlm_6391_6392 tree_6391 tree_6392 3.2768
Rlm_6394_6395 tree_6394 tree_6395 3.2768
Rlm_6397_6398 tree_6397 tree_6398 3.2768
Rlm_6401_6402 tree_6401 tree_6402 3.2768
Rlm_6404_6405 tree_6404 tree_6405 3.2768
Rlm_6407_6408 tree_6407 tree_6408 3.2768
Rlm_6411_6412 tree_6411 tree_6412 3.2768
Rlm_6414_6415 tree_6414 tree_6415 3.2768
Rlm_6417_6418 tree_6417 tree_6418 3.2768
Rlm_6421_6422 tree_6421 tree_6422 3.2768
Rlm_6424_6425 tree_6424 tree_6425 3.2768
Rlm_6427_6428 tree_6427 tree_6428 3.2768
Rlm_6431_6432 tree_6431 tree_6432 3.2768
Rlm_6434_6435 tree_6434 tree_6435 3.2768
Rlm_6437_6438 tree_6437 tree_6438 3.2768
Rlm_6441_6442 tree_6441 tree_6442 3.2768
Rlm_6444_6445 tree_6444 tree_6445 3.2768
Rlm_6447_6448 tree_6447 tree_6448 3.2768
Rlm_6451_6452 tree_6451 tree_6452 3.2768
Rlm_6454_6455 tree_6454 tree_6455 3.2768
Rlm_6457_6458 tree_6457 tree_6458 3.2768
Rlm_6461_6462 tree_6461 tree_6462 3.2768
Rlm_6464_6465 tree_6464 tree_6465 3.2768
Rlm_6467_6468 tree_6467 tree_6468 3.2768
Rlm_6471_6472 tree_6471 tree_6472 3.2768
Rlm_6474_6475 tree_6474 tree_6475 3.2768
Rlm_6477_6478 tree_6477 tree_6478 3.2768
Rlm_6481_6482 tree_6481 tree_6482 3.2768
Rlm_6484_6485 tree_6484 tree_6485 3.2768
Rlm_6487_6488 tree_6487 tree_6488 3.2768
Rlm_6491_6492 tree_6491 tree_6492 3.2768
Rlm_6494_6495 tree_6494 tree_6495 3.2768
Rlm_6497_6498 tree_6497 tree_6498 3.2768
Rlm_6501_6502 tree_6501 tree_6502 3.2768
Rlm_6504_6505 tree_6504 tree_6505 3.2768
Rlm_6507_6508 tree_6507 tree_6508 3.2768
Rlm_6511_6512 tree_6511 tree_6512 3.2768
Rlm_6514_6515 tree_6514 tree_6515 3.2768
Rlm_6517_6518 tree_6517 tree_6518 3.2768
Rlm_6521_6522 tree_6521 tree_6522 3.2768
Rlm_6524_6525 tree_6524 tree_6525 3.2768
Rlm_6527_6528 tree_6527 tree_6528 3.2768
Rlm_6531_6532 tree_6531 tree_6532 3.2768
Rlm_6534_6535 tree_6534 tree_6535 3.2768
Rlm_6537_6538 tree_6537 tree_6538 3.2768
Rlm_6541_6542 tree_6541 tree_6542 3.2768
Rlm_6544_6545 tree_6544 tree_6545 3.2768
Rlm_6547_6548 tree_6547 tree_6548 3.2768
Rlm_6551_6552 tree_6551 tree_6552 3.2768
Rlm_6554_6555 tree_6554 tree_6555 3.2768
Rlm_6557_6558 tree_6557 tree_6558 3.2768
Rlm_6561_6562 tree_6561 tree_6562 3.2768
Rlm_6564_6565 tree_6564 tree_6565 3.2768
Rlm_6567_6568 tree_6567 tree_6568 3.2768
Rlm_6571_6572 tree_6571 tree_6572 3.2768
Rlm_6574_6575 tree_6574 tree_6575 3.2768
Rlm_6577_6578 tree_6577 tree_6578 3.2768
Rlm_6581_6582 tree_6581 tree_6582 3.2768
Rlm_6584_6585 tree_6584 tree_6585 3.2768
Rlm_6587_6588 tree_6587 tree_6588 3.2768
Rlm_6591_6592 tree_6591 tree_6592 3.2768
Rlm_6594_6595 tree_6594 tree_6595 3.2768
Rlm_6597_6598 tree_6597 tree_6598 3.2768
Rlm_6601_6602 tree_6601 tree_6602 3.2768
Rlm_6604_6605 tree_6604 tree_6605 3.2768
Rlm_6607_6608 tree_6607 tree_6608 3.2768
Rlm_6611_6612 tree_6611 tree_6612 3.2768
Rlm_6614_6615 tree_6614 tree_6615 3.2768
Rlm_6617_6618 tree_6617 tree_6618 3.2768
Rlm_6621_6622 tree_6621 tree_6622 3.2768
Rlm_6624_6625 tree_6624 tree_6625 3.2768
Rlm_6627_6628 tree_6627 tree_6628 3.2768
Rlm_6631_6632 tree_6631 tree_6632 3.2768
Rlm_6634_6635 tree_6634 tree_6635 3.2768
Rlm_6637_6638 tree_6637 tree_6638 3.2768
Rlm_6641_6642 tree_6641 tree_6642 3.2768
Rlm_6644_6645 tree_6644 tree_6645 3.2768
Rlm_6647_6648 tree_6647 tree_6648 3.2768
Rlm_6651_6652 tree_6651 tree_6652 3.2768
Rlm_6654_6655 tree_6654 tree_6655 3.2768
Rlm_6657_6658 tree_6657 tree_6658 3.2768
Rlm_6661_6662 tree_6661 tree_6662 3.2768
Rlm_6664_6665 tree_6664 tree_6665 3.2768
Rlm_6667_6668 tree_6667 tree_6668 3.2768
Rlm_6671_6672 tree_6671 tree_6672 3.2768
Rlm_6674_6675 tree_6674 tree_6675 3.2768
Rlm_6677_6678 tree_6677 tree_6678 3.2768
Rlm_6681_6682 tree_6681 tree_6682 3.2768
Rlm_6684_6685 tree_6684 tree_6685 3.2768
Rlm_6687_6688 tree_6687 tree_6688 3.2768
Rlm_6691_6692 tree_6691 tree_6692 3.2768
Rlm_6694_6695 tree_6694 tree_6695 3.2768
Rlm_6697_6698 tree_6697 tree_6698 3.2768
Rlm_6701_6702 tree_6701 tree_6702 3.2768
Rlm_6704_6705 tree_6704 tree_6705 3.2768
Rlm_6707_6708 tree_6707 tree_6708 3.2768
Rlm_6711_6712 tree_6711 tree_6712 3.2768
Rlm_6714_6715 tree_6714 tree_6715 3.2768
Rlm_6717_6718 tree_6717 tree_6718 3.2768
Rlm_6721_6722 tree_6721 tree_6722 3.2768
Rlm_6724_6725 tree_6724 tree_6725 3.2768
Rlm_6727_6728 tree_6727 tree_6728 3.2768
Rlm_6731_6732 tree_6731 tree_6732 3.2768
Rlm_6734_6735 tree_6734 tree_6735 3.2768
Rlm_6737_6738 tree_6737 tree_6738 3.2768
Rlm_6741_6742 tree_6741 tree_6742 3.2768
Rlm_6744_6745 tree_6744 tree_6745 3.2768
Rlm_6747_6748 tree_6747 tree_6748 3.2768
Rlm_6751_6752 tree_6751 tree_6752 3.2768
Rlm_6754_6755 tree_6754 tree_6755 3.2768
Rlm_6757_6758 tree_6757 tree_6758 3.2768
Rlm_6761_6762 tree_6761 tree_6762 3.2768
Rlm_6764_6765 tree_6764 tree_6765 3.2768
Rlm_6767_6768 tree_6767 tree_6768 3.2768
Rlm_6771_6772 tree_6771 tree_6772 3.2768
Rlm_6774_6775 tree_6774 tree_6775 3.2768
Rlm_6777_6778 tree_6777 tree_6778 3.2768
Rlm_6781_6782 tree_6781 tree_6782 3.2768
Rlm_6784_6785 tree_6784 tree_6785 3.2768
Rlm_6787_6788 tree_6787 tree_6788 3.2768
Rlm_6791_6792 tree_6791 tree_6792 3.2768
Rlm_6794_6795 tree_6794 tree_6795 3.2768
Rlm_6797_6798 tree_6797 tree_6798 3.2768
Rlm_6801_6802 tree_6801 tree_6802 3.2768
Rlm_6804_6805 tree_6804 tree_6805 3.2768
Rlm_6807_6808 tree_6807 tree_6808 3.2768
Rlm_6811_6812 tree_6811 tree_6812 3.2768
Rlm_6814_6815 tree_6814 tree_6815 3.2768
Rlm_6817_6818 tree_6817 tree_6818 3.2768
Rlm_6821_6822 tree_6821 tree_6822 3.2768
Rlm_6824_6825 tree_6824 tree_6825 3.2768
Rlm_6827_6828 tree_6827 tree_6828 3.2768
Rlm_6831_6832 tree_6831 tree_6832 3.2768
Rlm_6834_6835 tree_6834 tree_6835 3.2768
Rlm_6837_6838 tree_6837 tree_6838 3.2768
Rlm_6841_6842 tree_6841 tree_6842 3.2768
Rlm_6844_6845 tree_6844 tree_6845 3.2768
Rlm_6847_6848 tree_6847 tree_6848 3.2768
Rlm_6851_6852 tree_6851 tree_6852 3.2768
Rlm_6854_6855 tree_6854 tree_6855 3.2768
Rlm_6857_6858 tree_6857 tree_6858 3.2768
Rlm_6861_6862 tree_6861 tree_6862 3.2768
Rlm_6864_6865 tree_6864 tree_6865 3.2768
Rlm_6867_6868 tree_6867 tree_6868 3.2768
Rlm_6871_6872 tree_6871 tree_6872 3.2768
Rlm_6874_6875 tree_6874 tree_6875 3.2768
Rlm_6877_6878 tree_6877 tree_6878 3.2768
Rlm_6881_6882 tree_6881 tree_6882 3.2768
Rlm_6884_6885 tree_6884 tree_6885 3.2768
Rlm_6887_6888 tree_6887 tree_6888 3.2768
Rlm_6891_6892 tree_6891 tree_6892 3.2768
Rlm_6894_6895 tree_6894 tree_6895 3.2768
Rlm_6897_6898 tree_6897 tree_6898 3.2768
Rlm_6901_6902 tree_6901 tree_6902 3.2768
Rlm_6904_6905 tree_6904 tree_6905 3.2768
Rlm_6907_6908 tree_6907 tree_6908 3.2768
Rlm_6911_6912 tree_6911 tree_6912 3.2768
Rlm_6914_6915 tree_6914 tree_6915 3.2768
Rlm_6917_6918 tree_6917 tree_6918 3.2768
Rlm_6921_6922 tree_6921 tree_6922 3.2768
Rlm_6924_6925 tree_6924 tree_6925 3.2768
Rlm_6927_6928 tree_6927 tree_6928 3.2768
Rlm_6931_6932 tree_6931 tree_6932 3.2768
Rlm_6934_6935 tree_6934 tree_6935 3.2768
Rlm_6937_6938 tree_6937 tree_6938 3.2768
Rlm_6941_6942 tree_6941 tree_6942 3.2768
Rlm_6944_6945 tree_6944 tree_6945 3.2768
Rlm_6947_6948 tree_6947 tree_6948 3.2768
Rlm_6951_6952 tree_6951 tree_6952 3.2768
Rlm_6954_6955 tree_6954 tree_6955 3.2768
Rlm_6957_6958 tree_6957 tree_6958 3.2768
Rlm_6961_6962 tree_6961 tree_6962 3.2768
Rlm_6964_6965 tree_6964 tree_6965 3.2768
Rlm_6967_6968 tree_6967 tree_6968 3.2768
Rlm_6971_6972 tree_6971 tree_6972 3.2768
Rlm_6974_6975 tree_6974 tree_6975 3.2768
Rlm_6977_6978 tree_6977 tree_6978 3.2768
Rlm_6981_6982 tree_6981 tree_6982 3.2768
Rlm_6984_6985 tree_6984 tree_6985 3.2768
Rlm_6987_6988 tree_6987 tree_6988 3.2768
Rlm_6991_6992 tree_6991 tree_6992 3.2768
Rlm_6994_6995 tree_6994 tree_6995 3.2768
Rlm_6997_6998 tree_6997 tree_6998 3.2768
Rlm_7001_7002 tree_7001 tree_7002 3.2768
Rlm_7004_7005 tree_7004 tree_7005 3.2768
Rlm_7007_7008 tree_7007 tree_7008 3.2768
Rlm_7011_7012 tree_7011 tree_7012 3.2768
Rlm_7014_7015 tree_7014 tree_7015 3.2768
Rlm_7017_7018 tree_7017 tree_7018 3.2768
Rlm_7021_7022 tree_7021 tree_7022 3.2768
Rlm_7024_7025 tree_7024 tree_7025 3.2768
Rlm_7027_7028 tree_7027 tree_7028 3.2768
Rlm_7031_7032 tree_7031 tree_7032 3.2768
Rlm_7034_7035 tree_7034 tree_7035 3.2768
Rlm_7037_7038 tree_7037 tree_7038 3.2768
Rlm_7041_7042 tree_7041 tree_7042 3.2768
Rlm_7044_7045 tree_7044 tree_7045 3.2768
Rlm_7047_7048 tree_7047 tree_7048 3.2768
Rlm_7051_7052 tree_7051 tree_7052 3.2768
Rlm_7054_7055 tree_7054 tree_7055 3.2768
Rlm_7057_7058 tree_7057 tree_7058 3.2768
Rlm_7061_7062 tree_7061 tree_7062 3.2768
Rlm_7064_7065 tree_7064 tree_7065 3.2768
Rlm_7067_7068 tree_7067 tree_7068 3.2768
Rlm_7071_7072 tree_7071 tree_7072 3.2768
Rlm_7074_7075 tree_7074 tree_7075 3.2768
Rlm_7077_7078 tree_7077 tree_7078 3.2768
Rlm_7081_7082 tree_7081 tree_7082 3.2768
Rlm_7084_7085 tree_7084 tree_7085 3.2768
Rlm_7087_7088 tree_7087 tree_7088 3.2768
Rlm_7091_7092 tree_7091 tree_7092 3.2768
Rlm_7094_7095 tree_7094 tree_7095 3.2768
Rlm_7097_7098 tree_7097 tree_7098 3.2768
Rlm_7101_7102 tree_7101 tree_7102 3.2768
Rlm_7104_7105 tree_7104 tree_7105 3.2768
Rlm_7107_7108 tree_7107 tree_7108 3.2768
Rlm_7111_7112 tree_7111 tree_7112 3.2768
Rlm_7114_7115 tree_7114 tree_7115 3.2768
Rlm_7117_7118 tree_7117 tree_7118 3.2768
Rlm_7121_7122 tree_7121 tree_7122 3.2768
Rlm_7124_7125 tree_7124 tree_7125 3.2768
Rlm_7127_7128 tree_7127 tree_7128 3.2768
Rlm_7131_7132 tree_7131 tree_7132 3.2768
Rlm_7134_7135 tree_7134 tree_7135 3.2768
Rlm_7137_7138 tree_7137 tree_7138 3.2768
Rlm_7141_7142 tree_7141 tree_7142 3.2768
Rlm_7144_7145 tree_7144 tree_7145 3.2768
Rlm_7147_7148 tree_7147 tree_7148 3.2768
Rlm_7151_7152 tree_7151 tree_7152 3.2768
Rlm_7154_7155 tree_7154 tree_7155 3.2768
Rlm_7157_7158 tree_7157 tree_7158 3.2768
Rlm_7161_7162 tree_7161 tree_7162 3.2768
Rlm_7164_7165 tree_7164 tree_7165 3.2768
Rlm_7167_7168 tree_7167 tree_7168 3.2768
Rlm_7171_7172 tree_7171 tree_7172 3.2768
Rlm_7174_7175 tree_7174 tree_7175 3.2768
Rlm_7177_7178 tree_7177 tree_7178 3.2768
Rlm_7181_7182 tree_7181 tree_7182 3.2768
Rlm_7184_7185 tree_7184 tree_7185 3.2768
Rlm_7187_7188 tree_7187 tree_7188 3.2768
Rlm_7191_7192 tree_7191 tree_7192 3.2768
Rlm_7194_7195 tree_7194 tree_7195 3.2768
Rlm_7197_7198 tree_7197 tree_7198 3.2768
Rlm_7201_7202 tree_7201 tree_7202 3.2768
Rlm_7204_7205 tree_7204 tree_7205 3.2768
Rlm_7207_7208 tree_7207 tree_7208 3.2768
Rlm_7211_7212 tree_7211 tree_7212 3.2768
Rlm_7214_7215 tree_7214 tree_7215 3.2768
Rlm_7217_7218 tree_7217 tree_7218 3.2768
Rlm_7221_7222 tree_7221 tree_7222 3.2768
Rlm_7224_7225 tree_7224 tree_7225 3.2768
Rlm_7227_7228 tree_7227 tree_7228 3.2768
Rlm_7231_7232 tree_7231 tree_7232 3.2768
Rlm_7234_7235 tree_7234 tree_7235 3.2768
Rlm_7237_7238 tree_7237 tree_7238 3.2768
Rlm_7241_7242 tree_7241 tree_7242 3.2768
Rlm_7244_7245 tree_7244 tree_7245 3.2768
Rlm_7247_7248 tree_7247 tree_7248 3.2768
Rlm_7251_7252 tree_7251 tree_7252 3.2768
Rlm_7254_7255 tree_7254 tree_7255 3.2768
Rlm_7257_7258 tree_7257 tree_7258 3.2768
Rlm_7261_7262 tree_7261 tree_7262 3.2768
Rlm_7264_7265 tree_7264 tree_7265 3.2768
Rlm_7267_7268 tree_7267 tree_7268 3.2768
Rlm_7271_7272 tree_7271 tree_7272 3.2768
Rlm_7274_7275 tree_7274 tree_7275 3.2768
Rlm_7277_7278 tree_7277 tree_7278 3.2768
Rlm_7281_7282 tree_7281 tree_7282 3.2768
Rlm_7284_7285 tree_7284 tree_7285 3.2768
Rlm_7287_7288 tree_7287 tree_7288 3.2768
Rlm_7291_7292 tree_7291 tree_7292 3.2768
Rlm_7294_7295 tree_7294 tree_7295 3.2768
Rlm_7297_7298 tree_7297 tree_7298 3.2768
Rlm_7301_7302 tree_7301 tree_7302 3.2768
Rlm_7304_7305 tree_7304 tree_7305 3.2768
Rlm_7307_7308 tree_7307 tree_7308 3.2768
Rlm_7311_7312 tree_7311 tree_7312 3.2768
Rlm_7314_7315 tree_7314 tree_7315 3.2768
Rlm_7317_7318 tree_7317 tree_7318 3.2768
Rlm_7321_7322 tree_7321 tree_7322 3.2768
Rlm_7324_7325 tree_7324 tree_7325 3.2768
Rlm_7327_7328 tree_7327 tree_7328 3.2768
Rlm_7331_7332 tree_7331 tree_7332 3.2768
Rlm_7334_7335 tree_7334 tree_7335 3.2768
Rlm_7337_7338 tree_7337 tree_7338 3.2768
Rlm_7341_7342 tree_7341 tree_7342 3.2768
Rlm_7344_7345 tree_7344 tree_7345 3.2768
Rlm_7347_7348 tree_7347 tree_7348 3.2768
Rlm_7351_7352 tree_7351 tree_7352 3.2768
Rlm_7354_7355 tree_7354 tree_7355 3.2768
Rlm_7357_7358 tree_7357 tree_7358 3.2768
Rlm_7361_7362 tree_7361 tree_7362 3.2768
Rlm_7364_7365 tree_7364 tree_7365 3.2768
Rlm_7367_7368 tree_7367 tree_7368 3.2768
Rlm_7371_7372 tree_7371 tree_7372 3.2768
Rlm_7374_7375 tree_7374 tree_7375 3.2768
Rlm_7377_7378 tree_7377 tree_7378 3.2768
Rlm_7381_7382 tree_7381 tree_7382 3.2768
Rlm_7384_7385 tree_7384 tree_7385 3.2768
Rlm_7387_7388 tree_7387 tree_7388 3.2768
Rlm_7391_7392 tree_7391 tree_7392 3.2768
Rlm_7394_7395 tree_7394 tree_7395 3.2768
Rlm_7397_7398 tree_7397 tree_7398 3.2768
Rlm_7401_7402 tree_7401 tree_7402 3.2768
Rlm_7404_7405 tree_7404 tree_7405 3.2768
Rlm_7407_7408 tree_7407 tree_7408 3.2768
Rlm_7411_7412 tree_7411 tree_7412 3.2768
Rlm_7414_7415 tree_7414 tree_7415 3.2768
Rlm_7417_7418 tree_7417 tree_7418 3.2768
Rlm_7421_7422 tree_7421 tree_7422 3.2768
Rlm_7424_7425 tree_7424 tree_7425 3.2768
Rlm_7427_7428 tree_7427 tree_7428 3.2768
Rlm_7431_7432 tree_7431 tree_7432 3.2768
Rlm_7434_7435 tree_7434 tree_7435 3.2768
Rlm_7437_7438 tree_7437 tree_7438 3.2768
Rlm_7441_7442 tree_7441 tree_7442 3.2768
Rlm_7444_7445 tree_7444 tree_7445 3.2768
Rlm_7447_7448 tree_7447 tree_7448 3.2768
Rlm_7451_7452 tree_7451 tree_7452 3.2768
Rlm_7454_7455 tree_7454 tree_7455 3.2768
Rlm_7457_7458 tree_7457 tree_7458 3.2768
Rlm_7461_7462 tree_7461 tree_7462 3.2768
Rlm_7464_7465 tree_7464 tree_7465 3.2768
Rlm_7467_7468 tree_7467 tree_7468 3.2768
Rlm_7471_7472 tree_7471 tree_7472 3.2768
Rlm_7474_7475 tree_7474 tree_7475 3.2768
Rlm_7477_7478 tree_7477 tree_7478 3.2768
Rlm_7481_7482 tree_7481 tree_7482 3.2768
Rlm_7484_7485 tree_7484 tree_7485 3.2768
Rlm_7487_7488 tree_7487 tree_7488 3.2768
Rlm_7491_7492 tree_7491 tree_7492 3.2768
Rlm_7494_7495 tree_7494 tree_7495 3.2768
Rlm_7497_7498 tree_7497 tree_7498 3.2768
Rlm_7501_7502 tree_7501 tree_7502 3.2768
Rlm_7504_7505 tree_7504 tree_7505 3.2768
Rlm_7507_7508 tree_7507 tree_7508 3.2768
Rlm_7511_7512 tree_7511 tree_7512 3.2768
Rlm_7514_7515 tree_7514 tree_7515 3.2768
Rlm_7517_7518 tree_7517 tree_7518 3.2768
Rlm_7521_7522 tree_7521 tree_7522 3.2768
Rlm_7524_7525 tree_7524 tree_7525 3.2768
Rlm_7527_7528 tree_7527 tree_7528 3.2768
Rlm_7531_7532 tree_7531 tree_7532 3.2768
Rlm_7534_7535 tree_7534 tree_7535 3.2768
Rlm_7537_7538 tree_7537 tree_7538 3.2768
Rlm_7541_7542 tree_7541 tree_7542 3.2768
Rlm_7544_7545 tree_7544 tree_7545 3.2768
Rlm_7547_7548 tree_7547 tree_7548 3.2768
Rlm_7551_7552 tree_7551 tree_7552 3.2768
Rlm_7554_7555 tree_7554 tree_7555 3.2768
Rlm_7557_7558 tree_7557 tree_7558 3.2768
Rlm_7561_7562 tree_7561 tree_7562 3.2768
Rlm_7564_7565 tree_7564 tree_7565 3.2768
Rlm_7567_7568 tree_7567 tree_7568 3.2768
Rlm_7571_7572 tree_7571 tree_7572 3.2768
Rlm_7574_7575 tree_7574 tree_7575 3.2768
Rlm_7577_7578 tree_7577 tree_7578 3.2768
Rlm_7581_7582 tree_7581 tree_7582 3.2768
Rlm_7584_7585 tree_7584 tree_7585 3.2768
Rlm_7587_7588 tree_7587 tree_7588 3.2768
Rlm_7591_7592 tree_7591 tree_7592 3.2768
Rlm_7594_7595 tree_7594 tree_7595 3.2768
Rlm_7597_7598 tree_7597 tree_7598 3.2768
Rlm_7601_7602 tree_7601 tree_7602 3.2768
Rlm_7604_7605 tree_7604 tree_7605 3.2768
Rlm_7607_7608 tree_7607 tree_7608 3.2768
Rlm_7611_7612 tree_7611 tree_7612 3.2768
Rlm_7614_7615 tree_7614 tree_7615 3.2768
Rlm_7617_7618 tree_7617 tree_7618 3.2768
Rlm_7621_7622 tree_7621 tree_7622 3.2768
Rlm_7624_7625 tree_7624 tree_7625 3.2768
Rlm_7627_7628 tree_7627 tree_7628 3.2768
Rlm_7631_7632 tree_7631 tree_7632 3.2768
Rlm_7634_7635 tree_7634 tree_7635 3.2768
Rlm_7637_7638 tree_7637 tree_7638 3.2768
Rlm_7641_7642 tree_7641 tree_7642 3.2768
Rlm_7644_7645 tree_7644 tree_7645 3.2768
Rlm_7647_7648 tree_7647 tree_7648 3.2768
Rlm_7651_7652 tree_7651 tree_7652 3.2768
Rlm_7654_7655 tree_7654 tree_7655 3.2768
Rlm_7657_7658 tree_7657 tree_7658 3.2768
Rlm_7661_7662 tree_7661 tree_7662 3.2768
Rlm_7664_7665 tree_7664 tree_7665 3.2768
Rlm_7667_7668 tree_7667 tree_7668 3.2768
Rlm_7671_7672 tree_7671 tree_7672 3.2768
Rlm_7674_7675 tree_7674 tree_7675 3.2768
Rlm_7677_7678 tree_7677 tree_7678 3.2768
Rlm_7681_7682 tree_7681 tree_7682 3.2768
Rlm_7684_7685 tree_7684 tree_7685 3.2768
Rlm_7687_7688 tree_7687 tree_7688 3.2768
Rlm_7691_7692 tree_7691 tree_7692 3.2768
Rlm_7694_7695 tree_7694 tree_7695 3.2768
Rlm_7697_7698 tree_7697 tree_7698 3.2768
Rlm_7701_7702 tree_7701 tree_7702 3.2768
Rlm_7704_7705 tree_7704 tree_7705 3.2768
Rlm_7707_7708 tree_7707 tree_7708 3.2768
Rlm_7711_7712 tree_7711 tree_7712 3.2768
Rlm_7714_7715 tree_7714 tree_7715 3.2768
Rlm_7717_7718 tree_7717 tree_7718 3.2768
Rlm_7721_7722 tree_7721 tree_7722 3.2768
Rlm_7724_7725 tree_7724 tree_7725 3.2768
Rlm_7727_7728 tree_7727 tree_7728 3.2768
Rlm_7731_7732 tree_7731 tree_7732 3.2768
Rlm_7734_7735 tree_7734 tree_7735 3.2768
Rlm_7737_7738 tree_7737 tree_7738 3.2768
Rlm_7741_7742 tree_7741 tree_7742 3.2768
Rlm_7744_7745 tree_7744 tree_7745 3.2768
Rlm_7747_7748 tree_7747 tree_7748 3.2768
Rlm_7751_7752 tree_7751 tree_7752 3.2768
Rlm_7754_7755 tree_7754 tree_7755 3.2768
Rlm_7757_7758 tree_7757 tree_7758 3.2768
Rlm_7761_7762 tree_7761 tree_7762 3.2768
Rlm_7764_7765 tree_7764 tree_7765 3.2768
Rlm_7767_7768 tree_7767 tree_7768 3.2768
Rlm_7771_7772 tree_7771 tree_7772 3.2768
Rlm_7774_7775 tree_7774 tree_7775 3.2768
Rlm_7777_7778 tree_7777 tree_7778 3.2768
Rlm_7781_7782 tree_7781 tree_7782 3.2768
Rlm_7784_7785 tree_7784 tree_7785 3.2768
Rlm_7787_7788 tree_7787 tree_7788 3.2768
Rlm_7791_7792 tree_7791 tree_7792 3.2768
Rlm_7794_7795 tree_7794 tree_7795 3.2768
Rlm_7797_7798 tree_7797 tree_7798 3.2768
Rlm_7801_7802 tree_7801 tree_7802 3.2768
Rlm_7804_7805 tree_7804 tree_7805 3.2768
Rlm_7807_7808 tree_7807 tree_7808 3.2768
Rlm_7811_7812 tree_7811 tree_7812 3.2768
Rlm_7814_7815 tree_7814 tree_7815 3.2768
Rlm_7817_7818 tree_7817 tree_7818 3.2768
Rlm_7821_7822 tree_7821 tree_7822 3.2768
Rlm_7824_7825 tree_7824 tree_7825 3.2768
Rlm_7827_7828 tree_7827 tree_7828 3.2768
Rlm_7831_7832 tree_7831 tree_7832 3.2768
Rlm_7834_7835 tree_7834 tree_7835 3.2768
Rlm_7837_7838 tree_7837 tree_7838 3.2768
Rlm_7841_7842 tree_7841 tree_7842 3.2768
Rlm_7844_7845 tree_7844 tree_7845 3.2768
Rlm_7847_7848 tree_7847 tree_7848 3.2768
Rlm_7851_7852 tree_7851 tree_7852 3.2768
Rlm_7854_7855 tree_7854 tree_7855 3.2768
Rlm_7857_7858 tree_7857 tree_7858 3.2768
Rlm_7861_7862 tree_7861 tree_7862 3.2768
Rlm_7864_7865 tree_7864 tree_7865 3.2768
Rlm_7867_7868 tree_7867 tree_7868 3.2768
Rlm_7871_7872 tree_7871 tree_7872 3.2768
Rlm_7874_7875 tree_7874 tree_7875 3.2768
Rlm_7877_7878 tree_7877 tree_7878 3.2768
Rlm_7881_7882 tree_7881 tree_7882 3.2768
Rlm_7884_7885 tree_7884 tree_7885 3.2768
Rlm_7887_7888 tree_7887 tree_7888 3.2768
Rlm_7891_7892 tree_7891 tree_7892 3.2768
Rlm_7894_7895 tree_7894 tree_7895 3.2768
Rlm_7897_7898 tree_7897 tree_7898 3.2768
Rlm_7901_7902 tree_7901 tree_7902 3.2768
Rlm_7904_7905 tree_7904 tree_7905 3.2768
Rlm_7907_7908 tree_7907 tree_7908 3.2768
Rlm_7911_7912 tree_7911 tree_7912 3.2768
Rlm_7914_7915 tree_7914 tree_7915 3.2768
Rlm_7917_7918 tree_7917 tree_7918 3.2768
Rlm_7921_7922 tree_7921 tree_7922 3.2768
Rlm_7924_7925 tree_7924 tree_7925 3.2768
Rlm_7927_7928 tree_7927 tree_7928 3.2768
Rlm_7931_7932 tree_7931 tree_7932 3.2768
Rlm_7934_7935 tree_7934 tree_7935 3.2768
Rlm_7937_7938 tree_7937 tree_7938 3.2768
Rlm_7941_7942 tree_7941 tree_7942 3.2768
Rlm_7944_7945 tree_7944 tree_7945 3.2768
Rlm_7947_7948 tree_7947 tree_7948 3.2768
Rlm_7951_7952 tree_7951 tree_7952 3.2768
Rlm_7954_7955 tree_7954 tree_7955 3.2768
Rlm_7957_7958 tree_7957 tree_7958 3.2768
Rlm_7961_7962 tree_7961 tree_7962 3.2768
Rlm_7964_7965 tree_7964 tree_7965 3.2768
Rlm_7967_7968 tree_7967 tree_7968 3.2768
Rlm_7971_7972 tree_7971 tree_7972 3.2768
Rlm_7974_7975 tree_7974 tree_7975 3.2768
Rlm_7977_7978 tree_7977 tree_7978 3.2768
Rlm_7981_7982 tree_7981 tree_7982 3.2768
Rlm_7984_7985 tree_7984 tree_7985 3.2768
Rlm_7987_7988 tree_7987 tree_7988 3.2768
Rlm_7991_7992 tree_7991 tree_7992 3.2768
Rlm_7994_7995 tree_7994 tree_7995 3.2768
Rlm_7997_7998 tree_7997 tree_7998 3.2768
Rlm_8001_8002 tree_8001 tree_8002 3.2768
Rlm_8004_8005 tree_8004 tree_8005 3.2768
Rlm_8007_8008 tree_8007 tree_8008 3.2768
Rlm_8011_8012 tree_8011 tree_8012 3.2768
Rlm_8014_8015 tree_8014 tree_8015 3.2768
Rlm_8017_8018 tree_8017 tree_8018 3.2768
Rlm_8021_8022 tree_8021 tree_8022 3.2768
Rlm_8024_8025 tree_8024 tree_8025 3.2768
Rlm_8027_8028 tree_8027 tree_8028 3.2768
Rlm_8031_8032 tree_8031 tree_8032 3.2768
Rlm_8034_8035 tree_8034 tree_8035 3.2768
Rlm_8037_8038 tree_8037 tree_8038 3.2768
Rlm_8041_8042 tree_8041 tree_8042 3.2768
Rlm_8044_8045 tree_8044 tree_8045 3.2768
Rlm_8047_8048 tree_8047 tree_8048 3.2768
Rlm_8051_8052 tree_8051 tree_8052 3.2768
Rlm_8054_8055 tree_8054 tree_8055 3.2768
Rlm_8057_8058 tree_8057 tree_8058 3.2768
Rlm_8061_8062 tree_8061 tree_8062 3.2768
Rlm_8064_8065 tree_8064 tree_8065 3.2768
Rlm_8067_8068 tree_8067 tree_8068 3.2768
Rlm_8071_8072 tree_8071 tree_8072 3.2768
Rlm_8074_8075 tree_8074 tree_8075 3.2768
Rlm_8077_8078 tree_8077 tree_8078 3.2768
Rlm_8081_8082 tree_8081 tree_8082 3.2768
Rlm_8084_8085 tree_8084 tree_8085 3.2768
Rlm_8087_8088 tree_8087 tree_8088 3.2768
Rlm_8091_8092 tree_8091 tree_8092 3.2768
Rlm_8094_8095 tree_8094 tree_8095 3.2768
Rlm_8097_8098 tree_8097 tree_8098 3.2768
Rlm_8101_8102 tree_8101 tree_8102 3.2768
Rlm_8104_8105 tree_8104 tree_8105 3.2768
Rlm_8107_8108 tree_8107 tree_8108 3.2768
Rlm_8111_8112 tree_8111 tree_8112 3.2768
Rlm_8114_8115 tree_8114 tree_8115 3.2768
Rlm_8117_8118 tree_8117 tree_8118 3.2768
Rlm_8121_8122 tree_8121 tree_8122 3.2768
Rlm_8124_8125 tree_8124 tree_8125 3.2768
Rlm_8127_8128 tree_8127 tree_8128 3.2768
Rlm_8131_8132 tree_8131 tree_8132 3.2768
Rlm_8134_8135 tree_8134 tree_8135 3.2768
Rlm_8137_8138 tree_8137 tree_8138 3.2768
Rlm_8141_8142 tree_8141 tree_8142 3.2768
Rlm_8144_8145 tree_8144 tree_8145 3.2768
Rlm_8147_8148 tree_8147 tree_8148 3.2768
Rlm_8151_8152 tree_8151 tree_8152 3.2768
Rlm_8154_8155 tree_8154 tree_8155 3.2768
Rlm_8157_8158 tree_8157 tree_8158 3.2768
Rlm_8161_8162 tree_8161 tree_8162 3.2768
Rlm_8164_8165 tree_8164 tree_8165 3.2768
Rlm_8167_8168 tree_8167 tree_8168 3.2768
Rlm_8171_8172 tree_8171 tree_8172 3.2768
Rlm_8174_8175 tree_8174 tree_8175 3.2768
Rlm_8177_8178 tree_8177 tree_8178 3.2768
Rlm_8181_8182 tree_8181 tree_8182 3.2768
Rlm_8184_8185 tree_8184 tree_8185 3.2768
Rlm_8187_8188 tree_8187 tree_8188 3.2768
Rlm_8191_8192 tree_8191 tree_8192 3.2768
Rlm_8194_8195 tree_8194 tree_8195 3.2768
Rlm_8197_8198 tree_8197 tree_8198 3.2768
Rlm_8201_8202 tree_8201 tree_8202 3.2768
Rlm_8204_8205 tree_8204 tree_8205 3.2768
Rlm_8207_8208 tree_8207 tree_8208 3.2768
Rlm_8211_8212 tree_8211 tree_8212 3.2768
Rlm_8214_8215 tree_8214 tree_8215 3.2768
Rlm_8217_8218 tree_8217 tree_8218 3.2768
Rlm_8221_8222 tree_8221 tree_8222 3.2768
Rlm_8224_8225 tree_8224 tree_8225 3.2768
Rlm_8227_8228 tree_8227 tree_8228 3.2768
Rlm_8231_8232 tree_8231 tree_8232 3.2768
Rlm_8234_8235 tree_8234 tree_8235 3.2768
Rlm_8237_8238 tree_8237 tree_8238 3.2768
Rlm_8241_8242 tree_8241 tree_8242 3.2768
Rlm_8244_8245 tree_8244 tree_8245 3.2768
Rlm_8247_8248 tree_8247 tree_8248 3.2768
Rlm_8251_8252 tree_8251 tree_8252 3.2768
Rlm_8254_8255 tree_8254 tree_8255 3.2768
Rlm_8257_8258 tree_8257 tree_8258 3.2768
Rlm_8261_8262 tree_8261 tree_8262 3.2768
Rlm_8264_8265 tree_8264 tree_8265 3.2768
Rlm_8267_8268 tree_8267 tree_8268 3.2768
Rlm_8271_8272 tree_8271 tree_8272 3.2768
Rlm_8274_8275 tree_8274 tree_8275 3.2768
Rlm_8277_8278 tree_8277 tree_8278 3.2768
Rlm_8281_8282 tree_8281 tree_8282 3.2768
Rlm_8284_8285 tree_8284 tree_8285 3.2768
Rlm_8287_8288 tree_8287 tree_8288 3.2768
Rlm_8291_8292 tree_8291 tree_8292 3.2768
Rlm_8294_8295 tree_8294 tree_8295 3.2768
Rlm_8297_8298 tree_8297 tree_8298 3.2768
Rlm_8301_8302 tree_8301 tree_8302 3.2768
Rlm_8304_8305 tree_8304 tree_8305 3.2768
Rlm_8307_8308 tree_8307 tree_8308 3.2768
Rlm_8311_8312 tree_8311 tree_8312 3.2768
Rlm_8314_8315 tree_8314 tree_8315 3.2768
Rlm_8317_8318 tree_8317 tree_8318 3.2768
Rlm_8321_8322 tree_8321 tree_8322 3.2768
Rlm_8324_8325 tree_8324 tree_8325 3.2768
Rlm_8327_8328 tree_8327 tree_8328 3.2768
Rlm_8331_8332 tree_8331 tree_8332 3.2768
Rlm_8334_8335 tree_8334 tree_8335 3.2768
Rlm_8337_8338 tree_8337 tree_8338 3.2768
Rlm_8341_8342 tree_8341 tree_8342 3.2768
Rlm_8344_8345 tree_8344 tree_8345 3.2768
Rlm_8347_8348 tree_8347 tree_8348 3.2768
Rlm_8351_8352 tree_8351 tree_8352 3.2768
Rlm_8354_8355 tree_8354 tree_8355 3.2768
Rlm_8357_8358 tree_8357 tree_8358 3.2768
Rlm_8361_8362 tree_8361 tree_8362 3.2768
Rlm_8364_8365 tree_8364 tree_8365 3.2768
Rlm_8367_8368 tree_8367 tree_8368 3.2768
Rlm_8371_8372 tree_8371 tree_8372 3.2768
Rlm_8374_8375 tree_8374 tree_8375 3.2768
Rlm_8377_8378 tree_8377 tree_8378 3.2768
Rlm_8381_8382 tree_8381 tree_8382 3.2768
Rlm_8384_8385 tree_8384 tree_8385 3.2768
Rlm_8387_8388 tree_8387 tree_8388 3.2768
Rlm_8391_8392 tree_8391 tree_8392 3.2768
Rlm_8394_8395 tree_8394 tree_8395 3.2768
Rlm_8397_8398 tree_8397 tree_8398 3.2768
Rlm_8401_8402 tree_8401 tree_8402 3.2768
Rlm_8404_8405 tree_8404 tree_8405 3.2768
Rlm_8407_8408 tree_8407 tree_8408 3.2768
Rlm_8411_8412 tree_8411 tree_8412 3.2768
Rlm_8414_8415 tree_8414 tree_8415 3.2768
Rlm_8417_8418 tree_8417 tree_8418 3.2768
Rlm_8421_8422 tree_8421 tree_8422 3.2768
Rlm_8424_8425 tree_8424 tree_8425 3.2768
Rlm_8427_8428 tree_8427 tree_8428 3.2768
Rlm_8431_8432 tree_8431 tree_8432 3.2768
Rlm_8434_8435 tree_8434 tree_8435 3.2768
Rlm_8437_8438 tree_8437 tree_8438 3.2768
Rlm_8441_8442 tree_8441 tree_8442 3.2768
Rlm_8444_8445 tree_8444 tree_8445 3.2768
Rlm_8447_8448 tree_8447 tree_8448 3.2768
Rlm_8451_8452 tree_8451 tree_8452 3.2768
Rlm_8454_8455 tree_8454 tree_8455 3.2768
Rlm_8457_8458 tree_8457 tree_8458 3.2768
Rlm_8461_8462 tree_8461 tree_8462 3.2768
Rlm_8464_8465 tree_8464 tree_8465 3.2768
Rlm_8467_8468 tree_8467 tree_8468 3.2768
Rlm_8471_8472 tree_8471 tree_8472 3.2768
Rlm_8474_8475 tree_8474 tree_8475 3.2768
Rlm_8477_8478 tree_8477 tree_8478 3.2768
Rlm_8481_8482 tree_8481 tree_8482 3.2768
Rlm_8484_8485 tree_8484 tree_8485 3.2768
Rlm_8487_8488 tree_8487 tree_8488 3.2768
Rlm_8491_8492 tree_8491 tree_8492 3.2768
Rlm_8494_8495 tree_8494 tree_8495 3.2768
Rlm_8497_8498 tree_8497 tree_8498 3.2768
Rlm_8501_8502 tree_8501 tree_8502 3.2768
Rlm_8504_8505 tree_8504 tree_8505 3.2768
Rlm_8507_8508 tree_8507 tree_8508 3.2768
Rlm_8511_8512 tree_8511 tree_8512 3.2768
Rlm_8514_8515 tree_8514 tree_8515 3.2768
Rlm_8517_8518 tree_8517 tree_8518 3.2768
Rlm_8521_8522 tree_8521 tree_8522 3.2768
Rlm_8524_8525 tree_8524 tree_8525 3.2768
Rlm_8527_8528 tree_8527 tree_8528 3.2768
Rlm_8531_8532 tree_8531 tree_8532 3.2768
Rlm_8534_8535 tree_8534 tree_8535 3.2768
Rlm_8537_8538 tree_8537 tree_8538 3.2768
Rlm_8541_8542 tree_8541 tree_8542 3.2768
Rlm_8544_8545 tree_8544 tree_8545 3.2768
Rlm_8547_8548 tree_8547 tree_8548 3.2768
Rlm_8551_8552 tree_8551 tree_8552 3.2768
Rlm_8554_8555 tree_8554 tree_8555 3.2768
Rlm_8557_8558 tree_8557 tree_8558 3.2768
Rlm_8561_8562 tree_8561 tree_8562 3.2768
Rlm_8564_8565 tree_8564 tree_8565 3.2768
Rlm_8567_8568 tree_8567 tree_8568 3.2768
Rlm_8571_8572 tree_8571 tree_8572 3.2768
Rlm_8574_8575 tree_8574 tree_8575 3.2768
Rlm_8577_8578 tree_8577 tree_8578 3.2768
Rlm_8581_8582 tree_8581 tree_8582 3.2768
Rlm_8584_8585 tree_8584 tree_8585 3.2768
Rlm_8587_8588 tree_8587 tree_8588 3.2768
Rlm_8591_8592 tree_8591 tree_8592 3.2768
Rlm_8594_8595 tree_8594 tree_8595 3.2768
Rlm_8597_8598 tree_8597 tree_8598 3.2768
Rlm_8601_8602 tree_8601 tree_8602 3.2768
Rlm_8604_8605 tree_8604 tree_8605 3.2768
Rlm_8607_8608 tree_8607 tree_8608 3.2768
Rlm_8611_8612 tree_8611 tree_8612 3.2768
Rlm_8614_8615 tree_8614 tree_8615 3.2768
Rlm_8617_8618 tree_8617 tree_8618 3.2768
Rlm_8621_8622 tree_8621 tree_8622 3.2768
Rlm_8624_8625 tree_8624 tree_8625 3.2768
Rlm_8627_8628 tree_8627 tree_8628 3.2768
Rlm_8631_8632 tree_8631 tree_8632 3.2768
Rlm_8634_8635 tree_8634 tree_8635 3.2768
Rlm_8637_8638 tree_8637 tree_8638 3.2768
Rlm_8641_8642 tree_8641 tree_8642 3.2768
Rlm_8644_8645 tree_8644 tree_8645 3.2768
Rlm_8647_8648 tree_8647 tree_8648 3.2768
Rlm_8651_8652 tree_8651 tree_8652 3.2768
Rlm_8654_8655 tree_8654 tree_8655 3.2768
Rlm_8657_8658 tree_8657 tree_8658 3.2768
Rlm_8661_8662 tree_8661 tree_8662 3.2768
Rlm_8664_8665 tree_8664 tree_8665 3.2768
Rlm_8667_8668 tree_8667 tree_8668 3.2768
Rlm_8671_8672 tree_8671 tree_8672 3.2768
Rlm_8674_8675 tree_8674 tree_8675 3.2768
Rlm_8677_8678 tree_8677 tree_8678 3.2768
Rlm_8681_8682 tree_8681 tree_8682 3.2768
Rlm_8684_8685 tree_8684 tree_8685 3.2768
Rlm_8687_8688 tree_8687 tree_8688 3.2768
Rlm_8691_8692 tree_8691 tree_8692 3.2768
Rlm_8694_8695 tree_8694 tree_8695 3.2768
Rlm_8697_8698 tree_8697 tree_8698 3.2768
Rlm_8701_8702 tree_8701 tree_8702 3.2768
Rlm_8704_8705 tree_8704 tree_8705 3.2768
Rlm_8707_8708 tree_8707 tree_8708 3.2768
Rlm_8711_8712 tree_8711 tree_8712 3.2768
Rlm_8714_8715 tree_8714 tree_8715 3.2768
Rlm_8717_8718 tree_8717 tree_8718 3.2768
Rlm_8721_8722 tree_8721 tree_8722 3.2768
Rlm_8724_8725 tree_8724 tree_8725 3.2768
Rlm_8727_8728 tree_8727 tree_8728 3.2768
Rlm_8731_8732 tree_8731 tree_8732 3.2768
Rlm_8734_8735 tree_8734 tree_8735 3.2768
Rlm_8737_8738 tree_8737 tree_8738 3.2768
Rlm_8741_8742 tree_8741 tree_8742 3.2768
Rlm_8744_8745 tree_8744 tree_8745 3.2768
Rlm_8747_8748 tree_8747 tree_8748 3.2768
Rlm_8751_8752 tree_8751 tree_8752 3.2768
Rlm_8754_8755 tree_8754 tree_8755 3.2768
Rlm_8757_8758 tree_8757 tree_8758 3.2768
Rlm_8761_8762 tree_8761 tree_8762 3.2768
Rlm_8764_8765 tree_8764 tree_8765 3.2768
Rlm_8767_8768 tree_8767 tree_8768 3.2768
Rlm_8771_8772 tree_8771 tree_8772 3.2768
Rlm_8774_8775 tree_8774 tree_8775 3.2768
Rlm_8777_8778 tree_8777 tree_8778 3.2768
Rlm_8781_8782 tree_8781 tree_8782 3.2768
Rlm_8784_8785 tree_8784 tree_8785 3.2768
Rlm_8787_8788 tree_8787 tree_8788 3.2768
Rlm_8791_8792 tree_8791 tree_8792 3.2768
Rlm_8794_8795 tree_8794 tree_8795 3.2768
Rlm_8797_8798 tree_8797 tree_8798 3.2768
Rlm_8801_8802 tree_8801 tree_8802 3.2768
Rlm_8804_8805 tree_8804 tree_8805 3.2768
Rlm_8807_8808 tree_8807 tree_8808 3.2768
Rlm_8811_8812 tree_8811 tree_8812 3.2768
Rlm_8814_8815 tree_8814 tree_8815 3.2768
Rlm_8817_8818 tree_8817 tree_8818 3.2768
Rlm_8821_8822 tree_8821 tree_8822 3.2768
Rlm_8824_8825 tree_8824 tree_8825 3.2768
Rlm_8827_8828 tree_8827 tree_8828 3.2768
Rlm_8831_8832 tree_8831 tree_8832 3.2768
Rlm_8834_8835 tree_8834 tree_8835 3.2768
Rlm_8837_8838 tree_8837 tree_8838 3.2768
Rlm_8841_8842 tree_8841 tree_8842 3.2768
Rlm_8844_8845 tree_8844 tree_8845 3.2768
Rlm_8847_8848 tree_8847 tree_8848 3.2768
Rlm_8851_8852 tree_8851 tree_8852 3.2768
Rlm_8854_8855 tree_8854 tree_8855 3.2768
Rlm_8857_8858 tree_8857 tree_8858 3.2768
Rlm_8861_8862 tree_8861 tree_8862 3.2768
Rlm_8864_8865 tree_8864 tree_8865 3.2768
Rlm_8867_8868 tree_8867 tree_8868 3.2768
Rlm_8871_8872 tree_8871 tree_8872 3.2768
Rlm_8874_8875 tree_8874 tree_8875 3.2768
Rlm_8877_8878 tree_8877 tree_8878 3.2768
Rlm_8881_8882 tree_8881 tree_8882 3.2768
Rlm_8884_8885 tree_8884 tree_8885 3.2768
Rlm_8887_8888 tree_8887 tree_8888 3.2768
Rlm_8891_8892 tree_8891 tree_8892 3.2768
Rlm_8894_8895 tree_8894 tree_8895 3.2768
Rlm_8897_8898 tree_8897 tree_8898 3.2768
Rlm_8901_8902 tree_8901 tree_8902 3.2768
Rlm_8904_8905 tree_8904 tree_8905 3.2768
Rlm_8907_8908 tree_8907 tree_8908 3.2768
Rlm_8911_8912 tree_8911 tree_8912 3.2768
Rlm_8914_8915 tree_8914 tree_8915 3.2768
Rlm_8917_8918 tree_8917 tree_8918 3.2768
Rlm_8921_8922 tree_8921 tree_8922 3.2768
Rlm_8924_8925 tree_8924 tree_8925 3.2768
Rlm_8927_8928 tree_8927 tree_8928 3.2768
Rlm_8931_8932 tree_8931 tree_8932 3.2768
Rlm_8934_8935 tree_8934 tree_8935 3.2768
Rlm_8937_8938 tree_8937 tree_8938 3.2768
Rlm_8941_8942 tree_8941 tree_8942 3.2768
Rlm_8944_8945 tree_8944 tree_8945 3.2768
Rlm_8947_8948 tree_8947 tree_8948 3.2768
Rlm_8951_8952 tree_8951 tree_8952 3.2768
Rlm_8954_8955 tree_8954 tree_8955 3.2768
Rlm_8957_8958 tree_8957 tree_8958 3.2768
Rlm_8961_8962 tree_8961 tree_8962 3.2768
Rlm_8964_8965 tree_8964 tree_8965 3.2768
Rlm_8967_8968 tree_8967 tree_8968 3.2768
Rlm_8971_8972 tree_8971 tree_8972 3.2768
Rlm_8974_8975 tree_8974 tree_8975 3.2768
Rlm_8977_8978 tree_8977 tree_8978 3.2768
Rlm_8981_8982 tree_8981 tree_8982 3.2768
Rlm_8984_8985 tree_8984 tree_8985 3.2768
Rlm_8987_8988 tree_8987 tree_8988 3.2768
Rlm_8991_8992 tree_8991 tree_8992 3.2768
Rlm_8994_8995 tree_8994 tree_8995 3.2768
Rlm_8997_8998 tree_8997 tree_8998 3.2768
Rlm_9001_9002 tree_9001 tree_9002 3.2768
Rlm_9004_9005 tree_9004 tree_9005 3.2768
Rlm_9007_9008 tree_9007 tree_9008 3.2768
Rlm_9011_9012 tree_9011 tree_9012 3.2768
Rlm_9014_9015 tree_9014 tree_9015 3.2768
Rlm_9017_9018 tree_9017 tree_9018 3.2768
Rlm_9021_9022 tree_9021 tree_9022 3.2768
Rlm_9024_9025 tree_9024 tree_9025 3.2768
Rlm_9027_9028 tree_9027 tree_9028 3.2768
Rlm_9031_9032 tree_9031 tree_9032 3.2768
Rlm_9034_9035 tree_9034 tree_9035 3.2768
Rlm_9037_9038 tree_9037 tree_9038 3.2768
Rlm_9041_9042 tree_9041 tree_9042 3.2768
Rlm_9044_9045 tree_9044 tree_9045 3.2768
Rlm_9047_9048 tree_9047 tree_9048 3.2768
Rlm_9051_9052 tree_9051 tree_9052 3.2768
Rlm_9054_9055 tree_9054 tree_9055 3.2768
Rlm_9057_9058 tree_9057 tree_9058 3.2768
Rlm_9061_9062 tree_9061 tree_9062 3.2768
Rlm_9064_9065 tree_9064 tree_9065 3.2768
Rlm_9067_9068 tree_9067 tree_9068 3.2768
Rlm_9071_9072 tree_9071 tree_9072 3.2768
Rlm_9074_9075 tree_9074 tree_9075 3.2768
Rlm_9077_9078 tree_9077 tree_9078 3.2768
Rlm_9081_9082 tree_9081 tree_9082 3.2768
Rlm_9084_9085 tree_9084 tree_9085 3.2768
Rlm_9087_9088 tree_9087 tree_9088 3.2768
Rlm_9091_9092 tree_9091 tree_9092 3.2768
Rlm_9094_9095 tree_9094 tree_9095 3.2768
Rlm_9097_9098 tree_9097 tree_9098 3.2768
Rlm_9101_9102 tree_9101 tree_9102 3.2768
Rlm_9104_9105 tree_9104 tree_9105 3.2768
Rlm_9107_9108 tree_9107 tree_9108 3.2768
Rlm_9111_9112 tree_9111 tree_9112 3.2768
Rlm_9114_9115 tree_9114 tree_9115 3.2768
Rlm_9117_9118 tree_9117 tree_9118 3.2768
Rlm_9121_9122 tree_9121 tree_9122 3.2768
Rlm_9124_9125 tree_9124 tree_9125 3.2768
Rlm_9127_9128 tree_9127 tree_9128 3.2768
Rlm_9131_9132 tree_9131 tree_9132 3.2768
Rlm_9134_9135 tree_9134 tree_9135 3.2768
Rlm_9137_9138 tree_9137 tree_9138 3.2768
Rlm_9141_9142 tree_9141 tree_9142 3.2768
Rlm_9144_9145 tree_9144 tree_9145 3.2768
Rlm_9147_9148 tree_9147 tree_9148 3.2768
Rlm_9151_9152 tree_9151 tree_9152 3.2768
Rlm_9154_9155 tree_9154 tree_9155 3.2768
Rlm_9157_9158 tree_9157 tree_9158 3.2768
Rlm_9161_9162 tree_9161 tree_9162 3.2768
Rlm_9164_9165 tree_9164 tree_9165 3.2768
Rlm_9167_9168 tree_9167 tree_9168 3.2768
Rlm_9171_9172 tree_9171 tree_9172 3.2768
Rlm_9174_9175 tree_9174 tree_9175 3.2768
Rlm_9177_9178 tree_9177 tree_9178 3.2768
Rlm_9181_9182 tree_9181 tree_9182 3.2768
Rlm_9184_9185 tree_9184 tree_9185 3.2768
Rlm_9187_9188 tree_9187 tree_9188 3.2768
Rlm_9191_9192 tree_9191 tree_9192 3.2768
Rlm_9194_9195 tree_9194 tree_9195 3.2768
Rlm_9197_9198 tree_9197 tree_9198 3.2768
Rlm_9201_9202 tree_9201 tree_9202 3.2768
Rlm_9204_9205 tree_9204 tree_9205 3.2768
Rlm_9207_9208 tree_9207 tree_9208 3.2768
Rlm_9211_9212 tree_9211 tree_9212 3.2768
Rlm_9214_9215 tree_9214 tree_9215 3.2768
Rlm_9217_9218 tree_9217 tree_9218 3.2768
Rlm_9221_9222 tree_9221 tree_9222 3.2768
Rlm_9224_9225 tree_9224 tree_9225 3.2768
Rlm_9227_9228 tree_9227 tree_9228 3.2768
Rlm_9231_9232 tree_9231 tree_9232 3.2768
Rlm_9234_9235 tree_9234 tree_9235 3.2768
Rlm_9237_9238 tree_9237 tree_9238 3.2768
Rlm_9241_9242 tree_9241 tree_9242 3.2768
Rlm_9244_9245 tree_9244 tree_9245 3.2768
Rlm_9247_9248 tree_9247 tree_9248 3.2768
Rlm_9251_9252 tree_9251 tree_9252 3.2768
Rlm_9254_9255 tree_9254 tree_9255 3.2768
Rlm_9257_9258 tree_9257 tree_9258 3.2768
Rlm_9261_9262 tree_9261 tree_9262 3.2768
Rlm_9264_9265 tree_9264 tree_9265 3.2768
Rlm_9267_9268 tree_9267 tree_9268 3.2768
Rlm_9271_9272 tree_9271 tree_9272 3.2768
Rlm_9274_9275 tree_9274 tree_9275 3.2768
Rlm_9277_9278 tree_9277 tree_9278 3.2768
Rlm_9281_9282 tree_9281 tree_9282 3.2768
Rlm_9284_9285 tree_9284 tree_9285 3.2768
Rlm_9287_9288 tree_9287 tree_9288 3.2768
Rlm_9291_9292 tree_9291 tree_9292 3.2768
Rlm_9294_9295 tree_9294 tree_9295 3.2768
Rlm_9297_9298 tree_9297 tree_9298 3.2768
Rlm_9301_9302 tree_9301 tree_9302 3.2768
Rlm_9304_9305 tree_9304 tree_9305 3.2768
Rlm_9307_9308 tree_9307 tree_9308 3.2768
Rlm_9311_9312 tree_9311 tree_9312 3.2768
Rlm_9314_9315 tree_9314 tree_9315 3.2768
Rlm_9317_9318 tree_9317 tree_9318 3.2768
Rlm_9321_9322 tree_9321 tree_9322 3.2768
Rlm_9324_9325 tree_9324 tree_9325 3.2768
Rlm_9327_9328 tree_9327 tree_9328 3.2768
Rlm_9331_9332 tree_9331 tree_9332 3.2768
Rlm_9334_9335 tree_9334 tree_9335 3.2768
Rlm_9337_9338 tree_9337 tree_9338 3.2768
Rlm_9341_9342 tree_9341 tree_9342 3.2768
Rlm_9344_9345 tree_9344 tree_9345 3.2768
Rlm_9347_9348 tree_9347 tree_9348 3.2768
Rlm_9351_9352 tree_9351 tree_9352 3.2768
Rlm_9354_9355 tree_9354 tree_9355 3.2768
Rlm_9357_9358 tree_9357 tree_9358 3.2768
Rlm_9361_9362 tree_9361 tree_9362 3.2768
Rlm_9364_9365 tree_9364 tree_9365 3.2768
Rlm_9367_9368 tree_9367 tree_9368 3.2768
Rlm_9371_9372 tree_9371 tree_9372 3.2768
Rlm_9374_9375 tree_9374 tree_9375 3.2768
Rlm_9377_9378 tree_9377 tree_9378 3.2768
Rlm_9381_9382 tree_9381 tree_9382 3.2768
Rlm_9384_9385 tree_9384 tree_9385 3.2768
Rlm_9387_9388 tree_9387 tree_9388 3.2768
Rlm_9391_9392 tree_9391 tree_9392 3.2768
Rlm_9394_9395 tree_9394 tree_9395 3.2768
Rlm_9397_9398 tree_9397 tree_9398 3.2768
Rlm_9401_9402 tree_9401 tree_9402 3.2768
Rlm_9404_9405 tree_9404 tree_9405 3.2768
Rlm_9407_9408 tree_9407 tree_9408 3.2768
Rlm_9411_9412 tree_9411 tree_9412 3.2768
Rlm_9414_9415 tree_9414 tree_9415 3.2768
Rlm_9417_9418 tree_9417 tree_9418 3.2768
Rlm_9421_9422 tree_9421 tree_9422 3.2768
Rlm_9424_9425 tree_9424 tree_9425 3.2768
Rlm_9427_9428 tree_9427 tree_9428 3.2768
Rlm_9431_9432 tree_9431 tree_9432 3.2768
Rlm_9434_9435 tree_9434 tree_9435 3.2768
Rlm_9437_9438 tree_9437 tree_9438 3.2768
Rlm_9441_9442 tree_9441 tree_9442 3.2768
Rlm_9444_9445 tree_9444 tree_9445 3.2768
Rlm_9447_9448 tree_9447 tree_9448 3.2768
Rlm_9451_9452 tree_9451 tree_9452 3.2768
Rlm_9454_9455 tree_9454 tree_9455 3.2768
Rlm_9457_9458 tree_9457 tree_9458 3.2768
Rlm_9461_9462 tree_9461 tree_9462 3.2768
Rlm_9464_9465 tree_9464 tree_9465 3.2768
Rlm_9467_9468 tree_9467 tree_9468 3.2768
Rlm_9471_9472 tree_9471 tree_9472 3.2768
Rlm_9474_9475 tree_9474 tree_9475 3.2768
Rlm_9477_9478 tree_9477 tree_9478 3.2768
Rlm_9481_9482 tree_9481 tree_9482 3.2768
Rlm_9484_9485 tree_9484 tree_9485 3.2768
Rlm_9487_9488 tree_9487 tree_9488 3.2768
Rlm_9491_9492 tree_9491 tree_9492 3.2768
Rlm_9494_9495 tree_9494 tree_9495 3.2768
Rlm_9497_9498 tree_9497 tree_9498 3.2768
Rlm_9501_9502 tree_9501 tree_9502 3.2768
Rlm_9504_9505 tree_9504 tree_9505 3.2768
Rlm_9507_9508 tree_9507 tree_9508 3.2768
Rlm_9511_9512 tree_9511 tree_9512 3.2768
Rlm_9514_9515 tree_9514 tree_9515 3.2768
Rlm_9517_9518 tree_9517 tree_9518 3.2768
Rlm_9521_9522 tree_9521 tree_9522 3.2768
Rlm_9524_9525 tree_9524 tree_9525 3.2768
Rlm_9527_9528 tree_9527 tree_9528 3.2768
Rlm_9531_9532 tree_9531 tree_9532 3.2768
Rlm_9534_9535 tree_9534 tree_9535 3.2768
Rlm_9537_9538 tree_9537 tree_9538 3.2768
Rlm_9541_9542 tree_9541 tree_9542 3.2768
Rlm_9544_9545 tree_9544 tree_9545 3.2768
Rlm_9547_9548 tree_9547 tree_9548 3.2768
Rlm_9551_9552 tree_9551 tree_9552 3.2768
Rlm_9554_9555 tree_9554 tree_9555 3.2768
Rlm_9557_9558 tree_9557 tree_9558 3.2768
Rlm_9561_9562 tree_9561 tree_9562 3.2768
Rlm_9564_9565 tree_9564 tree_9565 3.2768
Rlm_9567_9568 tree_9567 tree_9568 3.2768
Rlm_9571_9572 tree_9571 tree_9572 3.2768
Rlm_9574_9575 tree_9574 tree_9575 3.2768
Rlm_9577_9578 tree_9577 tree_9578 3.2768
Rlm_9581_9582 tree_9581 tree_9582 3.2768
Rlm_9584_9585 tree_9584 tree_9585 3.2768
Rlm_9587_9588 tree_9587 tree_9588 3.2768
Rlm_9591_9592 tree_9591 tree_9592 3.2768
Rlm_9594_9595 tree_9594 tree_9595 3.2768
Rlm_9597_9598 tree_9597 tree_9598 3.2768
Rlm_9601_9602 tree_9601 tree_9602 3.2768
Rlm_9604_9605 tree_9604 tree_9605 3.2768
Rlm_9607_9608 tree_9607 tree_9608 3.2768
Rlm_9611_9612 tree_9611 tree_9612 3.2768
Rlm_9614_9615 tree_9614 tree_9615 3.2768
Rlm_9617_9618 tree_9617 tree_9618 3.2768
Rlm_9621_9622 tree_9621 tree_9622 3.2768
Rlm_9624_9625 tree_9624 tree_9625 3.2768
Rlm_9627_9628 tree_9627 tree_9628 3.2768
Rlm_9631_9632 tree_9631 tree_9632 3.2768
Rlm_9634_9635 tree_9634 tree_9635 3.2768
Rlm_9637_9638 tree_9637 tree_9638 3.2768
Rlm_9641_9642 tree_9641 tree_9642 3.2768
Rlm_9644_9645 tree_9644 tree_9645 3.2768
Rlm_9647_9648 tree_9647 tree_9648 3.2768
Rlm_9651_9652 tree_9651 tree_9652 3.2768
Rlm_9654_9655 tree_9654 tree_9655 3.2768
Rlm_9657_9658 tree_9657 tree_9658 3.2768
Rlm_9661_9662 tree_9661 tree_9662 3.2768
Rlm_9664_9665 tree_9664 tree_9665 3.2768
Rlm_9667_9668 tree_9667 tree_9668 3.2768
Rlm_9671_9672 tree_9671 tree_9672 3.2768
Rlm_9674_9675 tree_9674 tree_9675 3.2768
Rlm_9677_9678 tree_9677 tree_9678 3.2768
Rlm_9681_9682 tree_9681 tree_9682 3.2768
Rlm_9684_9685 tree_9684 tree_9685 3.2768
Rlm_9687_9688 tree_9687 tree_9688 3.2768
Rlm_9691_9692 tree_9691 tree_9692 3.2768
Rlm_9694_9695 tree_9694 tree_9695 3.2768
Rlm_9697_9698 tree_9697 tree_9698 3.2768
Rlm_9701_9702 tree_9701 tree_9702 3.2768
Rlm_9704_9705 tree_9704 tree_9705 3.2768
Rlm_9707_9708 tree_9707 tree_9708 3.2768
Rlm_9711_9712 tree_9711 tree_9712 3.2768
Rlm_9714_9715 tree_9714 tree_9715 3.2768
Rlm_9717_9718 tree_9717 tree_9718 3.2768
Rlm_9721_9722 tree_9721 tree_9722 3.2768
Rlm_9724_9725 tree_9724 tree_9725 3.2768
Rlm_9727_9728 tree_9727 tree_9728 3.2768
Rlm_9731_9732 tree_9731 tree_9732 3.2768
Rlm_9734_9735 tree_9734 tree_9735 3.2768
Rlm_9737_9738 tree_9737 tree_9738 3.2768
Rlm_9741_9742 tree_9741 tree_9742 3.2768
Rlm_9744_9745 tree_9744 tree_9745 3.2768
Rlm_9747_9748 tree_9747 tree_9748 3.2768
Rlm_9751_9752 tree_9751 tree_9752 3.2768
Rlm_9754_9755 tree_9754 tree_9755 3.2768
Rlm_9757_9758 tree_9757 tree_9758 3.2768
Rlm_9761_9762 tree_9761 tree_9762 3.2768
Rlm_9764_9765 tree_9764 tree_9765 3.2768
Rlm_9767_9768 tree_9767 tree_9768 3.2768
Rlm_9771_9772 tree_9771 tree_9772 3.2768
Rlm_9774_9775 tree_9774 tree_9775 3.2768
Rlm_9777_9778 tree_9777 tree_9778 3.2768
Rlm_9781_9782 tree_9781 tree_9782 3.2768
Rlm_9784_9785 tree_9784 tree_9785 3.2768
Rlm_9787_9788 tree_9787 tree_9788 3.2768
Rlm_9791_9792 tree_9791 tree_9792 3.2768
Rlm_9794_9795 tree_9794 tree_9795 3.2768
Rlm_9797_9798 tree_9797 tree_9798 3.2768
Rlm_9801_9802 tree_9801 tree_9802 3.2768
Rlm_9804_9805 tree_9804 tree_9805 3.2768
Rlm_9807_9808 tree_9807 tree_9808 3.2768
Rlm_9811_9812 tree_9811 tree_9812 3.2768
Rlm_9814_9815 tree_9814 tree_9815 3.2768
Rlm_9817_9818 tree_9817 tree_9818 3.2768
Rlm_9821_9822 tree_9821 tree_9822 3.2768
Rlm_9824_9825 tree_9824 tree_9825 3.2768
Rlm_9827_9828 tree_9827 tree_9828 3.2768
Rlm_9831_9832 tree_9831 tree_9832 3.2768
Rlm_9834_9835 tree_9834 tree_9835 3.2768
Rlm_9837_9838 tree_9837 tree_9838 3.2768
Rlm_9841_9842 tree_9841 tree_9842 3.2768
Rlm_9844_9845 tree_9844 tree_9845 3.2768
Rlm_9847_9848 tree_9847 tree_9848 3.2768
Rlm_9851_9852 tree_9851 tree_9852 3.2768
Rlm_9854_9855 tree_9854 tree_9855 3.2768
Rlm_9857_9858 tree_9857 tree_9858 3.2768
Rlm_9861_9862 tree_9861 tree_9862 3.2768
Rlm_9864_9865 tree_9864 tree_9865 3.2768
Rlm_9867_9868 tree_9867 tree_9868 3.2768
Rlm_9871_9872 tree_9871 tree_9872 3.2768
Rlm_9874_9875 tree_9874 tree_9875 3.2768
Rlm_9877_9878 tree_9877 tree_9878 3.2768
Rlm_9881_9882 tree_9881 tree_9882 3.2768
Rlm_9884_9885 tree_9884 tree_9885 3.2768
Rlm_9887_9888 tree_9887 tree_9888 3.2768
Rlm_9891_9892 tree_9891 tree_9892 3.2768
Rlm_9894_9895 tree_9894 tree_9895 3.2768
Rlm_9897_9898 tree_9897 tree_9898 3.2768
Rlm_9901_9902 tree_9901 tree_9902 3.2768
Rlm_9904_9905 tree_9904 tree_9905 3.2768
Rlm_9907_9908 tree_9907 tree_9908 3.2768
Rlm_9911_9912 tree_9911 tree_9912 3.2768
Rlm_9914_9915 tree_9914 tree_9915 3.2768
Rlm_9917_9918 tree_9917 tree_9918 3.2768
Rlm_9921_9922 tree_9921 tree_9922 3.2768
Rlm_9924_9925 tree_9924 tree_9925 3.2768
Rlm_9927_9928 tree_9927 tree_9928 3.2768
Rlm_9931_9932 tree_9931 tree_9932 3.2768
Rlm_9934_9935 tree_9934 tree_9935 3.2768
Rlm_9937_9938 tree_9937 tree_9938 3.2768
Rlm_9941_9942 tree_9941 tree_9942 3.2768
Rlm_9944_9945 tree_9944 tree_9945 3.2768
Rlm_9947_9948 tree_9947 tree_9948 3.2768
Rlm_9951_9952 tree_9951 tree_9952 3.2768
Rlm_9954_9955 tree_9954 tree_9955 3.2768
Rlm_9957_9958 tree_9957 tree_9958 3.2768
Rlm_9961_9962 tree_9961 tree_9962 3.2768
Rlm_9964_9965 tree_9964 tree_9965 3.2768
Rlm_9967_9968 tree_9967 tree_9968 3.2768
Rlm_9971_9972 tree_9971 tree_9972 3.2768
Rlm_9974_9975 tree_9974 tree_9975 3.2768
Rlm_9977_9978 tree_9977 tree_9978 3.2768
Rlm_9981_9982 tree_9981 tree_9982 3.2768
Rlm_9984_9985 tree_9984 tree_9985 3.2768
Rlm_9987_9988 tree_9987 tree_9988 3.2768
Rlm_9991_9992 tree_9991 tree_9992 3.2768
Rlm_9994_9995 tree_9994 tree_9995 3.2768
Rlm_9997_9998 tree_9997 tree_9998 3.2768
Rlm_10001_10002 tree_10001 tree_10002 3.2768
Rlm_10004_10005 tree_10004 tree_10005 3.2768
Rlm_10007_10008 tree_10007 tree_10008 3.2768
Rlm_10011_10012 tree_10011 tree_10012 3.2768
Rlm_10014_10015 tree_10014 tree_10015 3.2768
Rlm_10017_10018 tree_10017 tree_10018 3.2768
Rlm_10021_10022 tree_10021 tree_10022 3.2768
Rlm_10024_10025 tree_10024 tree_10025 3.2768
Rlm_10027_10028 tree_10027 tree_10028 3.2768
Rlm_10031_10032 tree_10031 tree_10032 3.2768
Rlm_10034_10035 tree_10034 tree_10035 3.2768
Rlm_10037_10038 tree_10037 tree_10038 3.2768
Rlm_10041_10042 tree_10041 tree_10042 3.2768
Rlm_10044_10045 tree_10044 tree_10045 3.2768
Rlm_10047_10048 tree_10047 tree_10048 3.2768
Rlm_10051_10052 tree_10051 tree_10052 3.2768
Rlm_10054_10055 tree_10054 tree_10055 3.2768
Rlm_10057_10058 tree_10057 tree_10058 3.2768
Rlm_10061_10062 tree_10061 tree_10062 3.2768
Rlm_10064_10065 tree_10064 tree_10065 3.2768
Rlm_10067_10068 tree_10067 tree_10068 3.2768
Rlm_10071_10072 tree_10071 tree_10072 3.2768
Rlm_10074_10075 tree_10074 tree_10075 3.2768
Rlm_10077_10078 tree_10077 tree_10078 3.2768
Rlm_10081_10082 tree_10081 tree_10082 3.2768
Rlm_10084_10085 tree_10084 tree_10085 3.2768
Rlm_10087_10088 tree_10087 tree_10088 3.2768
Rlm_10091_10092 tree_10091 tree_10092 3.2768
Rlm_10094_10095 tree_10094 tree_10095 3.2768
Rlm_10097_10098 tree_10097 tree_10098 3.2768
Rlm_10101_10102 tree_10101 tree_10102 3.2768
Rlm_10104_10105 tree_10104 tree_10105 3.2768
Rlm_10107_10108 tree_10107 tree_10108 3.2768
Rlm_10111_10112 tree_10111 tree_10112 3.2768
Rlm_10114_10115 tree_10114 tree_10115 3.2768
Rlm_10117_10118 tree_10117 tree_10118 3.2768
Rlm_10121_10122 tree_10121 tree_10122 3.2768
Rlm_10124_10125 tree_10124 tree_10125 3.2768
Rlm_10127_10128 tree_10127 tree_10128 3.2768
Rlm_10131_10132 tree_10131 tree_10132 3.2768
Rlm_10134_10135 tree_10134 tree_10135 3.2768
Rlm_10137_10138 tree_10137 tree_10138 3.2768
Rlm_10141_10142 tree_10141 tree_10142 3.2768
Rlm_10144_10145 tree_10144 tree_10145 3.2768
Rlm_10147_10148 tree_10147 tree_10148 3.2768
Rlm_10151_10152 tree_10151 tree_10152 3.2768
Rlm_10154_10155 tree_10154 tree_10155 3.2768
Rlm_10157_10158 tree_10157 tree_10158 3.2768
Rlm_10161_10162 tree_10161 tree_10162 3.2768
Rlm_10164_10165 tree_10164 tree_10165 3.2768
Rlm_10167_10168 tree_10167 tree_10168 3.2768
Rlm_10171_10172 tree_10171 tree_10172 3.2768
Rlm_10174_10175 tree_10174 tree_10175 3.2768
Rlm_10177_10178 tree_10177 tree_10178 3.2768
Rlm_10181_10182 tree_10181 tree_10182 3.2768
Rlm_10184_10185 tree_10184 tree_10185 3.2768
Rlm_10187_10188 tree_10187 tree_10188 3.2768
Rlm_10191_10192 tree_10191 tree_10192 3.2768
Rlm_10194_10195 tree_10194 tree_10195 3.2768
Rlm_10197_10198 tree_10197 tree_10198 3.2768
Rlm_10201_10202 tree_10201 tree_10202 3.2768
Rlm_10204_10205 tree_10204 tree_10205 3.2768
Rlm_10207_10208 tree_10207 tree_10208 3.2768
Rlm_10211_10212 tree_10211 tree_10212 3.2768
Rlm_10214_10215 tree_10214 tree_10215 3.2768
Rlm_10217_10218 tree_10217 tree_10218 3.2768
Rlm_10221_10222 tree_10221 tree_10222 3.2768
Rlm_10224_10225 tree_10224 tree_10225 3.2768
Rlm_10227_10228 tree_10227 tree_10228 3.2768
Rlm_10231_10232 tree_10231 tree_10232 3.2768
Rlm_10234_10235 tree_10234 tree_10235 3.2768
Rlm_10237_10238 tree_10237 tree_10238 3.2768
Rlm_10241_10242 tree_10241 tree_10242 3.2768
Rlm_10244_10245 tree_10244 tree_10245 3.2768
Rlm_10247_10248 tree_10247 tree_10248 3.2768
Rlm_10251_10252 tree_10251 tree_10252 3.2768
Rlm_10254_10255 tree_10254 tree_10255 3.2768
Rlm_10257_10258 tree_10257 tree_10258 3.2768
Rlm_10261_10262 tree_10261 tree_10262 3.2768
Rlm_10264_10265 tree_10264 tree_10265 3.2768
Rlm_10267_10268 tree_10267 tree_10268 3.2768
Rlm_10271_10272 tree_10271 tree_10272 3.2768
Rlm_10274_10275 tree_10274 tree_10275 3.2768
Rlm_10277_10278 tree_10277 tree_10278 3.2768
Rlm_10281_10282 tree_10281 tree_10282 3.2768
Rlm_10284_10285 tree_10284 tree_10285 3.2768
Rlm_10287_10288 tree_10287 tree_10288 3.2768
Rlm_10291_10292 tree_10291 tree_10292 3.2768
Rlm_10294_10295 tree_10294 tree_10295 3.2768
Rlm_10297_10298 tree_10297 tree_10298 3.2768
Rlm_10301_10302 tree_10301 tree_10302 3.2768
Rlm_10304_10305 tree_10304 tree_10305 3.2768
Rlm_10307_10308 tree_10307 tree_10308 3.2768
Rlm_10311_10312 tree_10311 tree_10312 3.2768
Rlm_10314_10315 tree_10314 tree_10315 3.2768
Rlm_10317_10318 tree_10317 tree_10318 3.2768
Rlm_10321_10322 tree_10321 tree_10322 3.2768
Rlm_10324_10325 tree_10324 tree_10325 3.2768
Rlm_10327_10328 tree_10327 tree_10328 3.2768
Rlm_10331_10332 tree_10331 tree_10332 3.2768
Rlm_10334_10335 tree_10334 tree_10335 3.2768
Rlm_10337_10338 tree_10337 tree_10338 3.2768
Rlm_10341_10342 tree_10341 tree_10342 3.2768
Rlm_10344_10345 tree_10344 tree_10345 3.2768
Rlm_10347_10348 tree_10347 tree_10348 3.2768
Rlm_10351_10352 tree_10351 tree_10352 3.2768
Rlm_10354_10355 tree_10354 tree_10355 3.2768
Rlm_10357_10358 tree_10357 tree_10358 3.2768
Rlm_10361_10362 tree_10361 tree_10362 3.2768
Rlm_10364_10365 tree_10364 tree_10365 3.2768
Rlm_10367_10368 tree_10367 tree_10368 3.2768
Rlm_10371_10372 tree_10371 tree_10372 3.2768
Rlm_10374_10375 tree_10374 tree_10375 3.2768
Rlm_10377_10378 tree_10377 tree_10378 3.2768
Rlm_10381_10382 tree_10381 tree_10382 3.2768
Rlm_10384_10385 tree_10384 tree_10385 3.2768
Rlm_10387_10388 tree_10387 tree_10388 3.2768
Rlm_10391_10392 tree_10391 tree_10392 3.2768
Rlm_10394_10395 tree_10394 tree_10395 3.2768
Rlm_10397_10398 tree_10397 tree_10398 3.2768
Rlm_10401_10402 tree_10401 tree_10402 3.2768
Rlm_10404_10405 tree_10404 tree_10405 3.2768
Rlm_10407_10408 tree_10407 tree_10408 3.2768
Rlm_10411_10412 tree_10411 tree_10412 3.2768
Rlm_10414_10415 tree_10414 tree_10415 3.2768
Rlm_10417_10418 tree_10417 tree_10418 3.2768
Rlm_10421_10422 tree_10421 tree_10422 3.2768
Rlm_10424_10425 tree_10424 tree_10425 3.2768
Rlm_10427_10428 tree_10427 tree_10428 3.2768
Rlm_10431_10432 tree_10431 tree_10432 3.2768
Rlm_10434_10435 tree_10434 tree_10435 3.2768
Rlm_10437_10438 tree_10437 tree_10438 3.2768
Rlm_10441_10442 tree_10441 tree_10442 3.2768
Rlm_10444_10445 tree_10444 tree_10445 3.2768
Rlm_10447_10448 tree_10447 tree_10448 3.2768
Rlm_10451_10452 tree_10451 tree_10452 3.2768
Rlm_10454_10455 tree_10454 tree_10455 3.2768
Rlm_10457_10458 tree_10457 tree_10458 3.2768
Rlm_10461_10462 tree_10461 tree_10462 3.2768
Rlm_10464_10465 tree_10464 tree_10465 3.2768
Rlm_10467_10468 tree_10467 tree_10468 3.2768
Rlm_10471_10472 tree_10471 tree_10472 3.2768
Rlm_10474_10475 tree_10474 tree_10475 3.2768
Rlm_10477_10478 tree_10477 tree_10478 3.2768
Rlm_10481_10482 tree_10481 tree_10482 3.2768
Rlm_10484_10485 tree_10484 tree_10485 3.2768
Rlm_10487_10488 tree_10487 tree_10488 3.2768
Rlm_10491_10492 tree_10491 tree_10492 3.2768
Rlm_10494_10495 tree_10494 tree_10495 3.2768
Rlm_10497_10498 tree_10497 tree_10498 3.2768
Rlm_10501_10502 tree_10501 tree_10502 3.2768
Rlm_10504_10505 tree_10504 tree_10505 3.2768
Rlm_10507_10508 tree_10507 tree_10508 3.2768
Rlm_10511_10512 tree_10511 tree_10512 3.2768
Rlm_10514_10515 tree_10514 tree_10515 3.2768
Rlm_10517_10518 tree_10517 tree_10518 3.2768
Rlm_10521_10522 tree_10521 tree_10522 3.2768
Rlm_10524_10525 tree_10524 tree_10525 3.2768
Rlm_10527_10528 tree_10527 tree_10528 3.2768
Rlm_10531_10532 tree_10531 tree_10532 3.2768
Rlm_10534_10535 tree_10534 tree_10535 3.2768
Rlm_10537_10538 tree_10537 tree_10538 3.2768
Rlm_10541_10542 tree_10541 tree_10542 3.2768
Rlm_10544_10545 tree_10544 tree_10545 3.2768
Rlm_10547_10548 tree_10547 tree_10548 3.2768
Rlm_10551_10552 tree_10551 tree_10552 3.2768
Rlm_10554_10555 tree_10554 tree_10555 3.2768
Rlm_10557_10558 tree_10557 tree_10558 3.2768
Rlm_10561_10562 tree_10561 tree_10562 3.2768
Rlm_10564_10565 tree_10564 tree_10565 3.2768
Rlm_10567_10568 tree_10567 tree_10568 3.2768
Rlm_10571_10572 tree_10571 tree_10572 3.2768
Rlm_10574_10575 tree_10574 tree_10575 3.2768
Rlm_10577_10578 tree_10577 tree_10578 3.2768
Rlm_10581_10582 tree_10581 tree_10582 3.2768
Rlm_10584_10585 tree_10584 tree_10585 3.2768
Rlm_10587_10588 tree_10587 tree_10588 3.2768
Rlm_10591_10592 tree_10591 tree_10592 3.2768
Rlm_10594_10595 tree_10594 tree_10595 3.2768
Rlm_10597_10598 tree_10597 tree_10598 3.2768
Rlm_10601_10602 tree_10601 tree_10602 3.2768
Rlm_10604_10605 tree_10604 tree_10605 3.2768
Rlm_10607_10608 tree_10607 tree_10608 3.2768
Rlm_10611_10612 tree_10611 tree_10612 3.2768
Rlm_10614_10615 tree_10614 tree_10615 3.2768
Rlm_10617_10618 tree_10617 tree_10618 3.2768
Rlm_10621_10622 tree_10621 tree_10622 3.2768
Rlm_10624_10625 tree_10624 tree_10625 3.2768
Rlm_10627_10628 tree_10627 tree_10628 3.2768
Rlm_10631_10632 tree_10631 tree_10632 3.2768
Rlm_10634_10635 tree_10634 tree_10635 3.2768
Rlm_10637_10638 tree_10637 tree_10638 3.2768
Rlm_10641_10642 tree_10641 tree_10642 3.2768
Rlm_10644_10645 tree_10644 tree_10645 3.2768
Rlm_10647_10648 tree_10647 tree_10648 3.2768
Rlm_10651_10652 tree_10651 tree_10652 3.2768
Rlm_10654_10655 tree_10654 tree_10655 3.2768
Rlm_10657_10658 tree_10657 tree_10658 3.2768
Rlm_10661_10662 tree_10661 tree_10662 3.2768
Rlm_10664_10665 tree_10664 tree_10665 3.2768
Rlm_10667_10668 tree_10667 tree_10668 3.2768
Rlm_10671_10672 tree_10671 tree_10672 3.2768
Rlm_10674_10675 tree_10674 tree_10675 3.2768
Rlm_10677_10678 tree_10677 tree_10678 3.2768
Rlm_10681_10682 tree_10681 tree_10682 3.2768
Rlm_10684_10685 tree_10684 tree_10685 3.2768
Rlm_10687_10688 tree_10687 tree_10688 3.2768
Rlm_10691_10692 tree_10691 tree_10692 3.2768
Rlm_10694_10695 tree_10694 tree_10695 3.2768
Rlm_10697_10698 tree_10697 tree_10698 3.2768
Rlm_10701_10702 tree_10701 tree_10702 3.2768
Rlm_10704_10705 tree_10704 tree_10705 3.2768
Rlm_10707_10708 tree_10707 tree_10708 3.2768
Rlm_10711_10712 tree_10711 tree_10712 3.2768
Rlm_10714_10715 tree_10714 tree_10715 3.2768
Rlm_10717_10718 tree_10717 tree_10718 3.2768
Rlm_10721_10722 tree_10721 tree_10722 3.2768
Rlm_10724_10725 tree_10724 tree_10725 3.2768
Rlm_10727_10728 tree_10727 tree_10728 3.2768
Rlm_10731_10732 tree_10731 tree_10732 3.2768
Rlm_10734_10735 tree_10734 tree_10735 3.2768
Rlm_10737_10738 tree_10737 tree_10738 3.2768
Rlm_10741_10742 tree_10741 tree_10742 3.2768
Rlm_10744_10745 tree_10744 tree_10745 3.2768
Rlm_10747_10748 tree_10747 tree_10748 3.2768
Rlm_10751_10752 tree_10751 tree_10752 3.2768
Rlm_10754_10755 tree_10754 tree_10755 3.2768
Rlm_10757_10758 tree_10757 tree_10758 3.2768
Rlm_10761_10762 tree_10761 tree_10762 3.2768
Rlm_10764_10765 tree_10764 tree_10765 3.2768
Rlm_10767_10768 tree_10767 tree_10768 3.2768
Rlm_10771_10772 tree_10771 tree_10772 3.2768
Rlm_10774_10775 tree_10774 tree_10775 3.2768
Rlm_10777_10778 tree_10777 tree_10778 3.2768
Rlm_10781_10782 tree_10781 tree_10782 3.2768
Rlm_10784_10785 tree_10784 tree_10785 3.2768
Rlm_10787_10788 tree_10787 tree_10788 3.2768
Rlm_10791_10792 tree_10791 tree_10792 3.2768
Rlm_10794_10795 tree_10794 tree_10795 3.2768
Rlm_10797_10798 tree_10797 tree_10798 3.2768
Rlm_10801_10802 tree_10801 tree_10802 3.2768
Rlm_10804_10805 tree_10804 tree_10805 3.2768
Rlm_10807_10808 tree_10807 tree_10808 3.2768
Rlm_10811_10812 tree_10811 tree_10812 3.2768
Rlm_10814_10815 tree_10814 tree_10815 3.2768
Rlm_10817_10818 tree_10817 tree_10818 3.2768
Rlm_10821_10822 tree_10821 tree_10822 3.2768
Rlm_10824_10825 tree_10824 tree_10825 3.2768
Rlm_10827_10828 tree_10827 tree_10828 3.2768
Rlm_10831_10832 tree_10831 tree_10832 3.2768
Rlm_10834_10835 tree_10834 tree_10835 3.2768
Rlm_10837_10838 tree_10837 tree_10838 3.2768
Rlm_10841_10842 tree_10841 tree_10842 3.2768
Rlm_10844_10845 tree_10844 tree_10845 3.2768
Rlm_10847_10848 tree_10847 tree_10848 3.2768
Rlm_10851_10852 tree_10851 tree_10852 3.2768
Rlm_10854_10855 tree_10854 tree_10855 3.2768
Rlm_10857_10858 tree_10857 tree_10858 3.2768
Rlm_10861_10862 tree_10861 tree_10862 3.2768
Rlm_10864_10865 tree_10864 tree_10865 3.2768
Rlm_10867_10868 tree_10867 tree_10868 3.2768
Rlm_10871_10872 tree_10871 tree_10872 3.2768
Rlm_10874_10875 tree_10874 tree_10875 3.2768
Rlm_10877_10878 tree_10877 tree_10878 3.2768
Rlm_10881_10882 tree_10881 tree_10882 3.2768
Rlm_10884_10885 tree_10884 tree_10885 3.2768
Rlm_10887_10888 tree_10887 tree_10888 3.2768
Rlm_10891_10892 tree_10891 tree_10892 3.2768
Rlm_10894_10895 tree_10894 tree_10895 3.2768
Rlm_10897_10898 tree_10897 tree_10898 3.2768
Rlm_10901_10902 tree_10901 tree_10902 3.2768
Rlm_10904_10905 tree_10904 tree_10905 3.2768
Rlm_10907_10908 tree_10907 tree_10908 3.2768
Rlm_10911_10912 tree_10911 tree_10912 3.2768
Rlm_10914_10915 tree_10914 tree_10915 3.2768
Rlm_10917_10918 tree_10917 tree_10918 3.2768
Rlm_10921_10922 tree_10921 tree_10922 3.2768
Rlm_10924_10925 tree_10924 tree_10925 3.2768
Rlm_10927_10928 tree_10927 tree_10928 3.2768
Rlm_10931_10932 tree_10931 tree_10932 3.2768
Rlm_10934_10935 tree_10934 tree_10935 3.2768
Rlm_10937_10938 tree_10937 tree_10938 3.2768
Rlm_10941_10942 tree_10941 tree_10942 3.2768
Rlm_10944_10945 tree_10944 tree_10945 3.2768
Rlm_10947_10948 tree_10947 tree_10948 3.2768
Rlm_10951_10952 tree_10951 tree_10952 3.2768
Rlm_10954_10955 tree_10954 tree_10955 3.2768
Rlm_10957_10958 tree_10957 tree_10958 3.2768
Rlm_10961_10962 tree_10961 tree_10962 3.2768
Rlm_10964_10965 tree_10964 tree_10965 3.2768
Rlm_10967_10968 tree_10967 tree_10968 3.2768
Rlm_10971_10972 tree_10971 tree_10972 3.2768
Rlm_10974_10975 tree_10974 tree_10975 3.2768
Rlm_10977_10978 tree_10977 tree_10978 3.2768
Rlm_10981_10982 tree_10981 tree_10982 3.2768
Rlm_10984_10985 tree_10984 tree_10985 3.2768
Rlm_10987_10988 tree_10987 tree_10988 3.2768
Rlm_10991_10992 tree_10991 tree_10992 3.2768
Rlm_10994_10995 tree_10994 tree_10995 3.2768
Rlm_10997_10998 tree_10997 tree_10998 3.2768
Rlm_11001_11002 tree_11001 tree_11002 3.2768
Rlm_11004_11005 tree_11004 tree_11005 3.2768
Rlm_11007_11008 tree_11007 tree_11008 3.2768
Rlm_11011_11012 tree_11011 tree_11012 3.2768
Rlm_11014_11015 tree_11014 tree_11015 3.2768
Rlm_11017_11018 tree_11017 tree_11018 3.2768
Rlm_11021_11022 tree_11021 tree_11022 3.2768
Rlm_11024_11025 tree_11024 tree_11025 3.2768
Rlm_11027_11028 tree_11027 tree_11028 3.2768
Rlm_11031_11032 tree_11031 tree_11032 3.2768
Rlm_11034_11035 tree_11034 tree_11035 3.2768
Rlm_11037_11038 tree_11037 tree_11038 3.2768
Rlm_11041_11042 tree_11041 tree_11042 3.2768
Rlm_11044_11045 tree_11044 tree_11045 3.2768
Rlm_11047_11048 tree_11047 tree_11048 3.2768
Rlm_11051_11052 tree_11051 tree_11052 3.2768
Rlm_11054_11055 tree_11054 tree_11055 3.2768
Rlm_11057_11058 tree_11057 tree_11058 3.2768
Rlm_11061_11062 tree_11061 tree_11062 3.2768
Rlm_11064_11065 tree_11064 tree_11065 3.2768
Rlm_11067_11068 tree_11067 tree_11068 3.2768
Rlm_11071_11072 tree_11071 tree_11072 3.2768
Rlm_11074_11075 tree_11074 tree_11075 3.2768
Rlm_11077_11078 tree_11077 tree_11078 3.2768
Rlm_11081_11082 tree_11081 tree_11082 3.2768
Rlm_11084_11085 tree_11084 tree_11085 3.2768
Rlm_11087_11088 tree_11087 tree_11088 3.2768
Rlm_11091_11092 tree_11091 tree_11092 3.2768
Rlm_11094_11095 tree_11094 tree_11095 3.2768
Rlm_11097_11098 tree_11097 tree_11098 3.2768
Rlm_11101_11102 tree_11101 tree_11102 3.2768
Rlm_11104_11105 tree_11104 tree_11105 3.2768
Rlm_11107_11108 tree_11107 tree_11108 3.2768
Ccpl_1111_1361 tree_1111 tree_1361 2e-15
Ccpl_1361_1611 tree_1361 tree_1611 2e-15
Ccpl_1611_1861 tree_1611 tree_1861 2e-15
Ccpl_1861_2111 tree_1861 tree_2111 2e-15
Ccpl_2111_2361 tree_2111 tree_2361 2e-15
Ccpl_2361_2611 tree_2361 tree_2611 2e-15
Ccpl_2611_2861 tree_2611 tree_2861 2e-15
Ccpl_2861_3111 tree_2861 tree_3111 2e-15
Ccpl_3111_3361 tree_3111 tree_3361 2e-15
Ccpl_3361_3611 tree_3361 tree_3611 2e-15
Ccpl_3611_3861 tree_3611 tree_3861 2e-15
Ccpl_3861_4111 tree_3861 tree_4111 2e-15
Ccpl_4111_4361 tree_4111 tree_4361 2e-15
Ccpl_4361_4611 tree_4361 tree_4611 2e-15
Ccpl_4611_4861 tree_4611 tree_4861 2e-15
Ccpl_4861_5111 tree_4861 tree_5111 2e-15
Ccpl_5111_5361 tree_5111 tree_5361 2e-15
Ccpl_5361_5611 tree_5361 tree_5611 2e-15
Ccpl_5611_5861 tree_5611 tree_5861 2e-15
Ccpl_5861_6111 tree_5861 tree_6111 2e-15
Ccpl_6111_6361 tree_6111 tree_6361 2e-15
Ccpl_6361_6611 tree_6361 tree_6611 2e-15
Ccpl_6611_6861 tree_6611 tree_6861 2e-15
Ccpl_6861_7111 tree_6861 tree_7111 2e-15
Ccpl_7111_7361 tree_7111 tree_7361 2e-15
Ccpl_7361_7611 tree_7361 tree_7611 2e-15
Ccpl_7611_7861 tree_7611 tree_7861 2e-15
Ccpl_7861_8111 tree_7861 tree_8111 2e-15
Ccpl_8111_8361 tree_8111 tree_8361 2e-15
Ccpl_8361_8611 tree_8361 tree_8611 2e-15
Ccpl_8611_8861 tree_8611 tree_8861 2e-15
Ccpl_8861_9111 tree_8861 tree_9111 2e-15
Ccpl_9111_9361 tree_9111 tree_9361 2e-15
Ccpl_9361_9611 tree_9361 tree_9611 2e-15
Ccpl_9611_9861 tree_9611 tree_9861 2e-15
Ccpl_9861_10111 tree_9861 tree_10111 2e-15
Ccpl_10111_10361 tree_10111 tree_10361 2e-15
Ccpl_10361_10611 tree_10361 tree_10611 2e-15
Ccpl_10611_10861 tree_10611 tree_10861 2e-15

.tran 10n 25.0u 0 uic
.options reltol=1e-3 abstol=1e-9 vntol=1e-6 klu

.control
set filetype=ascii
rusage cputime
run
rusage cputime
meas tran vout_avg_final AVG v(vout) FROM=22.5u TO=25.0u
meas tran vout_max_final MAX v(vout) FROM=22.5u TO=25.0u
meas tran vout_min_final MIN v(vout) FROM=22.5u TO=25.0u
let vout_ripple = vout_max_final - vout_min_final
meas tran duty_meas AVG v(pwm) FROM=11.25u TO=12.5u
meas tran wave_t1 find v(vout) at=6.25u
meas tran wave_t2 find v(vout) at=12.5u
meas tran wave_t3 find v(vout) at=18.75u
meas tran wave_t4 find v(vout) at=25.0u
meas tran wave_sw_t1 find v(sw) at=12.5u
meas tran wave_mesh_far find v(tree_11110) at=25.0u
print vout_avg_final vout_max_final vout_min_final vout_ripple duty_meas wave_t1 wave_t2 wave_t3 wave_t4 wave_sw_t1 wave_mesh_far
rusage cputime
wrdata $HOME/Work/data/ngspice_augmentation/accel/bench/e_pex_tree/wave.txt v(vout) v(sw) i(l1)
quit
.endc
.end
