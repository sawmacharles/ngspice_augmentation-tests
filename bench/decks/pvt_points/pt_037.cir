* c_pvt_base point 037/50 -- vin_v=12 gon_scale=1.0 temp=85
* (ngspice_augmentation card #467, plan T9.1, bench task 1c; generated by
* bench/gen_pvt.py -- do not hand-edit, regenerate instead). Power
* stage/compensator as refs/r3_vm_buck.cir (see that file for the design
* derivation), trimmed to 300.0us and with the loop-gain probe dropped.
.param vin_v=12 gon_scale=1.0
.temp 85
.param fs=500k tclk={1/fs}
.param lval=10u rdcr=10m cval=100u esrval=10m rload=3.3
.param ra=2300 rb=1000 vref=1
.param r1=10k r2=27.51k r3=101.7 c1=36.35p c2=2.299n c3=6.261n
.param vramp=2
.param gm_oa=1000 ro_oa=100 co_oa=100p
.param gon=100 goff=1e-6 ksw=30 kc=30

Vin vin 0 DC {vin_v}

Bhs vin sw I = (V(vin)-V(sw)) * ({goff}+({gon}*{gon_scale}-{goff})*0.5*(1+tanh({ksw}*(V(pwm)-0.5))))
Bls sw 0   I = V(sw)              * ({goff}+({gon}*{gon_scale}-{goff})*0.5*(1+tanh({ksw}*(0.5-V(pwm)))))

Csw sw 0 100p
L1 sw swl {lval} IC=0
Rdcr swl vout {rdcr}
Resr vout cx {esrval}
Cout cx 0 {cval} IC=0
Rload vout 0 {rload}

Ra vout fbnode {ra}
Rb fbnode 0 {rb}

Vrefsrc vrefnode 0 DC {vref}
Goa opout 0 vrefnode compin {gm_oa}
Roa opout 0 {ro_oa}
Coa opout 0 {co_oa}

R1in fbnode compin {r1}
R3in fbnode n3 {r3}
C3in n3 compin {c3}
C1f compin opout {c1}
R2f compin n2 {r2}
C2f n2 opout {c2}

Vramp ramp 0 PULSE(0 {vramp} 0 {0.97*tclk} {0.03*tclk} 1n {tclk})
Bcmp pwm 0 V = 0.5*(1+tanh({kc}*(V(opout)-V(ramp))))

.tran 20n 300.0u 0 uic
.options reltol=1e-3

.control
set filetype=ascii
run
meas tran vout_avg_final AVG v(vout) FROM=290.01u TO=300.0u
meas tran vout_max_final MAX v(vout) FROM=290.01u TO=300.0u
meas tran vout_min_final MIN v(vout) FROM=290.01u TO=300.0u
let vout_ripple = vout_max_final - vout_min_final
meas tran wave_mid find v(vout) at=150.0u
meas tran wave_end find v(vout) at=300.0u
print vout_avg_final vout_max_final vout_min_final vout_ripple wave_mid wave_end
.endc
.end
