* g_ad_stress -- forward-mode AD coverage stress deck (ngspice_augmentation
* card #486, plan T9.4, round 4; generated by bench/gen_ad_stress.py -- do
* not hand-edit, regenerate instead). One B-source per PT_*/PTF_* node type
* and operator src/spicelib/parser/inpptree.c's PTdifferentiate() handles
* (see that script's own header for why literal-constant expressions, e.g.
* tests/regression/parser/bxpressn-1.cir, do NOT exercise this: they fold
* away at parse time before ever reaching the runtime evaluator). Every
* argument is a PWL-ramped voltage (not a literal), so every B-source is a
* real PT_VAR-rooted tree with a live gradient. Synthetic, not derived
* from any real design -- synthetic coverage only.
* run: ngspice -b <this file> (writes nothing outside
*  ~/Work/data/ngspice_augmentation/accel/bench/g_ad_stress/, never into the
*  repo)

Vw   vw   0 PWL(0 -3.7    4m 3.7)
Vtan vtan 0 PWL(0 -1.2    4m 1.2)
Vu   vu   0 PWL(0 -0.95   4m 0.95)
Vh   vh   0 PWL(0 1.05    4m 4.0)
Vp   vp   0 PWL(0 0.05    4m 5.0)
Va   va   0 PWL(0 0.5     4m 3.0)
Vb   vb   0 PWL(0 -2.0    4m 3.0)
Vc   vc   0 PWL(0 -3.0    4m 3.0)
Vpwlx vpwlx 0 PWL(0 -12   4m 22)

* nodeset: ngspice's default Newton initial guess is 0V for every node,
* which is OUT OF DOMAIN for acosh (x>=1) -- without a nodeset, the very
* first Newton trial at t=0 evaluates acosh's derivative formula
* (1/sqrt(u^2-1)) at u=0, hitting sqrt(-1), which forces gmin/source-
* stepping fallback and (found by actually running this deck, not assumed)
* still fails to find an operating point at all on THIS fork's unmodified
* baseline (aaba50ba3f49-s37) even with that fallback -- a pre-existing
* ngspice limitation for any acosh(V(node))-shaped B-source with a poor
* initial guess, not something this round's AD patch introduced (confirmed
* by reproducing it with the same expression on the baseline binary
* directly). nodeset every ramp's t=0 value so Newton starts in-domain and
* this stays a clean, converging correctness deck rather than an
* accidental op-point-finder stress test (that is a different, real
* research question -- see the round-4 report -- not this deck's job).
.nodeset v(vw)=-3.7 v(vtan)=-1.2 v(vu)=-0.95 v(vh)=1.05 v(vp)=0.05
+ v(va)=0.5 v(vb)=-2.0 v(vc)=-3.0 v(vpwlx)=-12

* abs: PTF_ABS
Babs out_abs 0 V = abs(V(vw))

* sgn: PTF_SGN
Bsgn out_sgn 0 V = sgn(V(vw))

* acos: PTF_ACOS
Bacos out_acos 0 V = acos(V(vu))

* acosh: PTF_ACOSH
Bacosh out_acosh 0 V = acosh(V(vh))

* asin: PTF_ASIN
Basin out_asin 0 V = asin(V(vu))

* asinh: PTF_ASINH
Basinh out_asinh 0 V = asinh(V(vw))

* atan: PTF_ATAN
Batan out_atan 0 V = atan(V(vw))

* atanh: PTF_ATANH
Batanh out_atanh 0 V = atanh(V(vu))

* cos: PTF_COS
Bcos out_cos 0 V = cos(V(vw))

* cosh: PTF_COSH
Bcosh out_cosh 0 V = cosh(V(vw))

* exp: PTF_EXP
Bexp out_exp 0 V = exp(V(vw))

* ln: PTF_LOG (via 'ln')
Bln out_ln 0 V = ln(V(vp))

* log: PTF_LOG (via 'log')
Blog out_log 0 V = log(V(vp))

* log10: PTF_LOG10
Blog10 out_log10 0 V = log10(V(vp))

* sin: PTF_SIN
Bsin out_sin 0 V = sin(V(vw))

* sinh: PTF_SINH
Bsinh out_sinh 0 V = sinh(V(vw))

* sqrt: PTF_SQRT
Bsqrt out_sqrt 0 V = sqrt(V(vp))

* tan: PTF_TAN
Btan out_tan 0 V = tan(V(vtan))

* tanh: PTF_TANH
Btanh out_tanh 0 V = tanh(V(vw))

* ustep: PTF_USTEP (via 'u')
Bustep out_ustep 0 V = u(V(vw))

* uramp: PTF_URAMP
Buramp out_uramp 0 V = uramp(V(vw))

* ceil: PTF_CEIL
Bceil out_ceil 0 V = ceil(V(vw))

* floor: PTF_FLOOR
Bfloor out_floor 0 V = floor(V(vw))

* nint: PTF_NINT
Bnint out_nint 0 V = nint(V(vw))

* uminus: PTF_UMINUS (unary '-')
Buminus out_uminus 0 V = -V(vw)

* ustep2: PTF_USTEP2 (via 'u2')
Bustep2 out_ustep2 0 V = u2(V(vw))

* pwl: PTF_PWL (its own derivative -- PTF_PWL_DERIVATIVE -- is exercised internally computing this entry's gradient; a DIRECT user call to pwl_derivative(...) is not a supported form in the baseline either -- PT_mkfnode() only special-cases PTF_PWL/PTF_DDT's own 'prepare_PTF_*' comma-list-to-data step, never PTF_PWL_DERIVATIVE's -- confirmed pre-existing on aaba50ba3f49-s37 before this round's patch, not attempted here, see the round-4 report)
Bpwl out_pwl 0 V = pwl(V(vpwlx), -10,-8, 2,4, 12,9, 22,19)

* eq0: PTF_EQ0
Beq0 out_eq0 0 V = eq0(V(vc))

* ne0: PTF_NE0
Bne0 out_ne0 0 V = ne0(V(vc))

* gt0: PTF_GT0
Bgt0 out_gt0 0 V = gt0(V(vc))

* lt0: PTF_LT0
Blt0 out_lt0 0 V = lt0(V(vc))

* ge0: PTF_GE0
Bge0 out_ge0 0 V = ge0(V(vc))

* le0: PTF_LE0
Ble0 out_le0 0 V = le0(V(vc))

* pow_bconst: PTF_POW, b-constant branch
Bpow_bconst out_pow_bconst 0 V = pow(V(va),2)

* pow_aconst: PTF_POW, a-constant branch
Bpow_aconst out_pow_aconst 0 V = pow(2,V(vb))

* pow_general: PTF_POW, general branch
Bpow_general out_pow_general 0 V = pow(V(va),V(vb))

* pwr_bconst: PTF_PWR, b-constant branch
Bpwr_bconst out_pwr_bconst 0 V = pwr(V(va),3)

* pwr_general: PTF_PWR, general branch
Bpwr_general out_pwr_general 0 V = pwr(V(va),V(vb))

* min: PTF_MIN
Bmin out_min 0 V = min(V(va),V(vb))

* max: PTF_MAX
Bmax out_max 0 V = max(V(va),V(vb))

* ddt: PTF_DDT
Bddt out_ddt 0 V = ddt(V(vw))

* caret_bconst: PT_POWER '^', b-constant branch
Bcaret_bconst out_caret_bconst 0 V = V(va)^2

* caret_aconst: PT_POWER '^', a-constant branch
Bcaret_aconst out_caret_aconst 0 V = 2^V(vb)

* caret_general: PT_POWER '^', general branch
Bcaret_general out_caret_general 0 V = V(va)^V(vb)

* tern: PT_TERN ('?:')
Btern out_tern 0 V = V(vc) > 0 ? sin(V(vw)) : cos(V(vw))

* ternfcn: PT_TERN (explicit ternary_fcn)
Bternfcn out_ternfcn 0 V = ternary_fcn(V(vc), V(va), V(vb))

* cmp_eq: eq0(a-b) via '=='
Bcmp_eq out_cmp_eq 0 V = V(va) == V(vb)

* cmp_ne: ne0(a-b) via '!='
Bcmp_ne out_cmp_ne 0 V = V(va) != V(vb)

* cmp_gt: gt0(a-b) via '>'
Bcmp_gt out_cmp_gt 0 V = V(va) > V(vb)

* cmp_lt: lt0(a-b) via '<'
Bcmp_lt out_cmp_lt 0 V = V(va) < V(vb)

* cmp_ge: ge0(a-b) via '>='
Bcmp_ge out_cmp_ge 0 V = V(va) >= V(vb)

* cmp_le: le0(a-b) via '<='
Bcmp_le out_cmp_le 0 V = V(va) <= V(vb)

* booland: eq0(eq0+eq0) via '&&'
Bbooland out_booland 0 V = V(va) && V(vb)

* boolor: ne0(ne0+ne0) via '||'
Bboolor out_boolor 0 V = V(va) || V(vb)

* boolnot: eq0(x) via '!'
Bboolnot out_boolnot 0 V = !V(vc)

* ptime: PT_TIME
Bptime out_ptime 0 V = time*1000

* ptemper: PT_TEMPERATURE
Bptemper out_ptemper 0 V = temper

* compound: mixed PT_PLUS/MINUS/TIMES/DIVIDE/POWER + nested funcs, 4 controlling variables
Bcompound out_compound 0 V = tanh(2*(V(va)-V(vb)))*sin(V(vw)) + sqrt(abs(V(vc))) - V(va)^2/exp(0.1*V(vb))

.tran 10u 4m 0
.options reltol=1e-6

.control
set filetype=binary
rusage cputime
run
rusage cputime

meas tran abs_t0p4 find v(out_abs) at=0.4m
meas tran abs_t1p2 find v(out_abs) at=1.2m
meas tran abs_t2p0 find v(out_abs) at=2.0m
meas tran abs_t2p8 find v(out_abs) at=2.8m
meas tran abs_t3p6 find v(out_abs) at=3.6m
meas tran sgn_t0p4 find v(out_sgn) at=0.4m
meas tran sgn_t1p2 find v(out_sgn) at=1.2m
meas tran sgn_t2p0 find v(out_sgn) at=2.0m
meas tran sgn_t2p8 find v(out_sgn) at=2.8m
meas tran sgn_t3p6 find v(out_sgn) at=3.6m
meas tran acos_t0p4 find v(out_acos) at=0.4m
meas tran acos_t1p2 find v(out_acos) at=1.2m
meas tran acos_t2p0 find v(out_acos) at=2.0m
meas tran acos_t2p8 find v(out_acos) at=2.8m
meas tran acos_t3p6 find v(out_acos) at=3.6m
meas tran acosh_t0p4 find v(out_acosh) at=0.4m
meas tran acosh_t1p2 find v(out_acosh) at=1.2m
meas tran acosh_t2p0 find v(out_acosh) at=2.0m
meas tran acosh_t2p8 find v(out_acosh) at=2.8m
meas tran acosh_t3p6 find v(out_acosh) at=3.6m
meas tran asin_t0p4 find v(out_asin) at=0.4m
meas tran asin_t1p2 find v(out_asin) at=1.2m
meas tran asin_t2p0 find v(out_asin) at=2.0m
meas tran asin_t2p8 find v(out_asin) at=2.8m
meas tran asin_t3p6 find v(out_asin) at=3.6m
meas tran asinh_t0p4 find v(out_asinh) at=0.4m
meas tran asinh_t1p2 find v(out_asinh) at=1.2m
meas tran asinh_t2p0 find v(out_asinh) at=2.0m
meas tran asinh_t2p8 find v(out_asinh) at=2.8m
meas tran asinh_t3p6 find v(out_asinh) at=3.6m
meas tran atan_t0p4 find v(out_atan) at=0.4m
meas tran atan_t1p2 find v(out_atan) at=1.2m
meas tran atan_t2p0 find v(out_atan) at=2.0m
meas tran atan_t2p8 find v(out_atan) at=2.8m
meas tran atan_t3p6 find v(out_atan) at=3.6m
meas tran atanh_t0p4 find v(out_atanh) at=0.4m
meas tran atanh_t1p2 find v(out_atanh) at=1.2m
meas tran atanh_t2p0 find v(out_atanh) at=2.0m
meas tran atanh_t2p8 find v(out_atanh) at=2.8m
meas tran atanh_t3p6 find v(out_atanh) at=3.6m
meas tran cos_t0p4 find v(out_cos) at=0.4m
meas tran cos_t1p2 find v(out_cos) at=1.2m
meas tran cos_t2p0 find v(out_cos) at=2.0m
meas tran cos_t2p8 find v(out_cos) at=2.8m
meas tran cos_t3p6 find v(out_cos) at=3.6m
meas tran cosh_t0p4 find v(out_cosh) at=0.4m
meas tran cosh_t1p2 find v(out_cosh) at=1.2m
meas tran cosh_t2p0 find v(out_cosh) at=2.0m
meas tran cosh_t2p8 find v(out_cosh) at=2.8m
meas tran cosh_t3p6 find v(out_cosh) at=3.6m
meas tran exp_t0p4 find v(out_exp) at=0.4m
meas tran exp_t1p2 find v(out_exp) at=1.2m
meas tran exp_t2p0 find v(out_exp) at=2.0m
meas tran exp_t2p8 find v(out_exp) at=2.8m
meas tran exp_t3p6 find v(out_exp) at=3.6m
meas tran ln_t0p4 find v(out_ln) at=0.4m
meas tran ln_t1p2 find v(out_ln) at=1.2m
meas tran ln_t2p0 find v(out_ln) at=2.0m
meas tran ln_t2p8 find v(out_ln) at=2.8m
meas tran ln_t3p6 find v(out_ln) at=3.6m
meas tran log_t0p4 find v(out_log) at=0.4m
meas tran log_t1p2 find v(out_log) at=1.2m
meas tran log_t2p0 find v(out_log) at=2.0m
meas tran log_t2p8 find v(out_log) at=2.8m
meas tran log_t3p6 find v(out_log) at=3.6m
meas tran log10_t0p4 find v(out_log10) at=0.4m
meas tran log10_t1p2 find v(out_log10) at=1.2m
meas tran log10_t2p0 find v(out_log10) at=2.0m
meas tran log10_t2p8 find v(out_log10) at=2.8m
meas tran log10_t3p6 find v(out_log10) at=3.6m
meas tran sin_t0p4 find v(out_sin) at=0.4m
meas tran sin_t1p2 find v(out_sin) at=1.2m
meas tran sin_t2p0 find v(out_sin) at=2.0m
meas tran sin_t2p8 find v(out_sin) at=2.8m
meas tran sin_t3p6 find v(out_sin) at=3.6m
meas tran sinh_t0p4 find v(out_sinh) at=0.4m
meas tran sinh_t1p2 find v(out_sinh) at=1.2m
meas tran sinh_t2p0 find v(out_sinh) at=2.0m
meas tran sinh_t2p8 find v(out_sinh) at=2.8m
meas tran sinh_t3p6 find v(out_sinh) at=3.6m
meas tran sqrt_t0p4 find v(out_sqrt) at=0.4m
meas tran sqrt_t1p2 find v(out_sqrt) at=1.2m
meas tran sqrt_t2p0 find v(out_sqrt) at=2.0m
meas tran sqrt_t2p8 find v(out_sqrt) at=2.8m
meas tran sqrt_t3p6 find v(out_sqrt) at=3.6m
meas tran tan_t0p4 find v(out_tan) at=0.4m
meas tran tan_t1p2 find v(out_tan) at=1.2m
meas tran tan_t2p0 find v(out_tan) at=2.0m
meas tran tan_t2p8 find v(out_tan) at=2.8m
meas tran tan_t3p6 find v(out_tan) at=3.6m
meas tran tanh_t0p4 find v(out_tanh) at=0.4m
meas tran tanh_t1p2 find v(out_tanh) at=1.2m
meas tran tanh_t2p0 find v(out_tanh) at=2.0m
meas tran tanh_t2p8 find v(out_tanh) at=2.8m
meas tran tanh_t3p6 find v(out_tanh) at=3.6m
meas tran ustep_t0p4 find v(out_ustep) at=0.4m
meas tran ustep_t1p2 find v(out_ustep) at=1.2m
meas tran ustep_t2p0 find v(out_ustep) at=2.0m
meas tran ustep_t2p8 find v(out_ustep) at=2.8m
meas tran ustep_t3p6 find v(out_ustep) at=3.6m
meas tran uramp_t0p4 find v(out_uramp) at=0.4m
meas tran uramp_t1p2 find v(out_uramp) at=1.2m
meas tran uramp_t2p0 find v(out_uramp) at=2.0m
meas tran uramp_t2p8 find v(out_uramp) at=2.8m
meas tran uramp_t3p6 find v(out_uramp) at=3.6m
meas tran ceil_t0p4 find v(out_ceil) at=0.4m
meas tran ceil_t1p2 find v(out_ceil) at=1.2m
meas tran ceil_t2p0 find v(out_ceil) at=2.0m
meas tran ceil_t2p8 find v(out_ceil) at=2.8m
meas tran ceil_t3p6 find v(out_ceil) at=3.6m
meas tran floor_t0p4 find v(out_floor) at=0.4m
meas tran floor_t1p2 find v(out_floor) at=1.2m
meas tran floor_t2p0 find v(out_floor) at=2.0m
meas tran floor_t2p8 find v(out_floor) at=2.8m
meas tran floor_t3p6 find v(out_floor) at=3.6m
meas tran nint_t0p4 find v(out_nint) at=0.4m
meas tran nint_t1p2 find v(out_nint) at=1.2m
meas tran nint_t2p0 find v(out_nint) at=2.0m
meas tran nint_t2p8 find v(out_nint) at=2.8m
meas tran nint_t3p6 find v(out_nint) at=3.6m
meas tran uminus_t0p4 find v(out_uminus) at=0.4m
meas tran uminus_t1p2 find v(out_uminus) at=1.2m
meas tran uminus_t2p0 find v(out_uminus) at=2.0m
meas tran uminus_t2p8 find v(out_uminus) at=2.8m
meas tran uminus_t3p6 find v(out_uminus) at=3.6m
meas tran ustep2_t0p4 find v(out_ustep2) at=0.4m
meas tran ustep2_t1p2 find v(out_ustep2) at=1.2m
meas tran ustep2_t2p0 find v(out_ustep2) at=2.0m
meas tran ustep2_t2p8 find v(out_ustep2) at=2.8m
meas tran ustep2_t3p6 find v(out_ustep2) at=3.6m
meas tran pwl_t0p4 find v(out_pwl) at=0.4m
meas tran pwl_t1p2 find v(out_pwl) at=1.2m
meas tran pwl_t2p0 find v(out_pwl) at=2.0m
meas tran pwl_t2p8 find v(out_pwl) at=2.8m
meas tran pwl_t3p6 find v(out_pwl) at=3.6m
meas tran eq0_t0p4 find v(out_eq0) at=0.4m
meas tran eq0_t1p2 find v(out_eq0) at=1.2m
meas tran eq0_t2p0 find v(out_eq0) at=2.0m
meas tran eq0_t2p8 find v(out_eq0) at=2.8m
meas tran eq0_t3p6 find v(out_eq0) at=3.6m
meas tran ne0_t0p4 find v(out_ne0) at=0.4m
meas tran ne0_t1p2 find v(out_ne0) at=1.2m
meas tran ne0_t2p0 find v(out_ne0) at=2.0m
meas tran ne0_t2p8 find v(out_ne0) at=2.8m
meas tran ne0_t3p6 find v(out_ne0) at=3.6m
meas tran gt0_t0p4 find v(out_gt0) at=0.4m
meas tran gt0_t1p2 find v(out_gt0) at=1.2m
meas tran gt0_t2p0 find v(out_gt0) at=2.0m
meas tran gt0_t2p8 find v(out_gt0) at=2.8m
meas tran gt0_t3p6 find v(out_gt0) at=3.6m
meas tran lt0_t0p4 find v(out_lt0) at=0.4m
meas tran lt0_t1p2 find v(out_lt0) at=1.2m
meas tran lt0_t2p0 find v(out_lt0) at=2.0m
meas tran lt0_t2p8 find v(out_lt0) at=2.8m
meas tran lt0_t3p6 find v(out_lt0) at=3.6m
meas tran ge0_t0p4 find v(out_ge0) at=0.4m
meas tran ge0_t1p2 find v(out_ge0) at=1.2m
meas tran ge0_t2p0 find v(out_ge0) at=2.0m
meas tran ge0_t2p8 find v(out_ge0) at=2.8m
meas tran ge0_t3p6 find v(out_ge0) at=3.6m
meas tran le0_t0p4 find v(out_le0) at=0.4m
meas tran le0_t1p2 find v(out_le0) at=1.2m
meas tran le0_t2p0 find v(out_le0) at=2.0m
meas tran le0_t2p8 find v(out_le0) at=2.8m
meas tran le0_t3p6 find v(out_le0) at=3.6m
meas tran pow_bconst_t0p4 find v(out_pow_bconst) at=0.4m
meas tran pow_bconst_t1p2 find v(out_pow_bconst) at=1.2m
meas tran pow_bconst_t2p0 find v(out_pow_bconst) at=2.0m
meas tran pow_bconst_t2p8 find v(out_pow_bconst) at=2.8m
meas tran pow_bconst_t3p6 find v(out_pow_bconst) at=3.6m
meas tran pow_aconst_t0p4 find v(out_pow_aconst) at=0.4m
meas tran pow_aconst_t1p2 find v(out_pow_aconst) at=1.2m
meas tran pow_aconst_t2p0 find v(out_pow_aconst) at=2.0m
meas tran pow_aconst_t2p8 find v(out_pow_aconst) at=2.8m
meas tran pow_aconst_t3p6 find v(out_pow_aconst) at=3.6m
meas tran pow_general_t0p4 find v(out_pow_general) at=0.4m
meas tran pow_general_t1p2 find v(out_pow_general) at=1.2m
meas tran pow_general_t2p0 find v(out_pow_general) at=2.0m
meas tran pow_general_t2p8 find v(out_pow_general) at=2.8m
meas tran pow_general_t3p6 find v(out_pow_general) at=3.6m
meas tran pwr_bconst_t0p4 find v(out_pwr_bconst) at=0.4m
meas tran pwr_bconst_t1p2 find v(out_pwr_bconst) at=1.2m
meas tran pwr_bconst_t2p0 find v(out_pwr_bconst) at=2.0m
meas tran pwr_bconst_t2p8 find v(out_pwr_bconst) at=2.8m
meas tran pwr_bconst_t3p6 find v(out_pwr_bconst) at=3.6m
meas tran pwr_general_t0p4 find v(out_pwr_general) at=0.4m
meas tran pwr_general_t1p2 find v(out_pwr_general) at=1.2m
meas tran pwr_general_t2p0 find v(out_pwr_general) at=2.0m
meas tran pwr_general_t2p8 find v(out_pwr_general) at=2.8m
meas tran pwr_general_t3p6 find v(out_pwr_general) at=3.6m
meas tran min_t0p4 find v(out_min) at=0.4m
meas tran min_t1p2 find v(out_min) at=1.2m
meas tran min_t2p0 find v(out_min) at=2.0m
meas tran min_t2p8 find v(out_min) at=2.8m
meas tran min_t3p6 find v(out_min) at=3.6m
meas tran max_t0p4 find v(out_max) at=0.4m
meas tran max_t1p2 find v(out_max) at=1.2m
meas tran max_t2p0 find v(out_max) at=2.0m
meas tran max_t2p8 find v(out_max) at=2.8m
meas tran max_t3p6 find v(out_max) at=3.6m
meas tran ddt_t0p4 find v(out_ddt) at=0.4m
meas tran ddt_t1p2 find v(out_ddt) at=1.2m
meas tran ddt_t2p0 find v(out_ddt) at=2.0m
meas tran ddt_t2p8 find v(out_ddt) at=2.8m
meas tran ddt_t3p6 find v(out_ddt) at=3.6m
meas tran caret_bconst_t0p4 find v(out_caret_bconst) at=0.4m
meas tran caret_bconst_t1p2 find v(out_caret_bconst) at=1.2m
meas tran caret_bconst_t2p0 find v(out_caret_bconst) at=2.0m
meas tran caret_bconst_t2p8 find v(out_caret_bconst) at=2.8m
meas tran caret_bconst_t3p6 find v(out_caret_bconst) at=3.6m
meas tran caret_aconst_t0p4 find v(out_caret_aconst) at=0.4m
meas tran caret_aconst_t1p2 find v(out_caret_aconst) at=1.2m
meas tran caret_aconst_t2p0 find v(out_caret_aconst) at=2.0m
meas tran caret_aconst_t2p8 find v(out_caret_aconst) at=2.8m
meas tran caret_aconst_t3p6 find v(out_caret_aconst) at=3.6m
meas tran caret_general_t0p4 find v(out_caret_general) at=0.4m
meas tran caret_general_t1p2 find v(out_caret_general) at=1.2m
meas tran caret_general_t2p0 find v(out_caret_general) at=2.0m
meas tran caret_general_t2p8 find v(out_caret_general) at=2.8m
meas tran caret_general_t3p6 find v(out_caret_general) at=3.6m
meas tran tern_t0p4 find v(out_tern) at=0.4m
meas tran tern_t1p2 find v(out_tern) at=1.2m
meas tran tern_t2p0 find v(out_tern) at=2.0m
meas tran tern_t2p8 find v(out_tern) at=2.8m
meas tran tern_t3p6 find v(out_tern) at=3.6m
meas tran ternfcn_t0p4 find v(out_ternfcn) at=0.4m
meas tran ternfcn_t1p2 find v(out_ternfcn) at=1.2m
meas tran ternfcn_t2p0 find v(out_ternfcn) at=2.0m
meas tran ternfcn_t2p8 find v(out_ternfcn) at=2.8m
meas tran ternfcn_t3p6 find v(out_ternfcn) at=3.6m
meas tran cmp_eq_t0p4 find v(out_cmp_eq) at=0.4m
meas tran cmp_eq_t1p2 find v(out_cmp_eq) at=1.2m
meas tran cmp_eq_t2p0 find v(out_cmp_eq) at=2.0m
meas tran cmp_eq_t2p8 find v(out_cmp_eq) at=2.8m
meas tran cmp_eq_t3p6 find v(out_cmp_eq) at=3.6m
meas tran cmp_ne_t0p4 find v(out_cmp_ne) at=0.4m
meas tran cmp_ne_t1p2 find v(out_cmp_ne) at=1.2m
meas tran cmp_ne_t2p0 find v(out_cmp_ne) at=2.0m
meas tran cmp_ne_t2p8 find v(out_cmp_ne) at=2.8m
meas tran cmp_ne_t3p6 find v(out_cmp_ne) at=3.6m
meas tran cmp_gt_t0p4 find v(out_cmp_gt) at=0.4m
meas tran cmp_gt_t1p2 find v(out_cmp_gt) at=1.2m
meas tran cmp_gt_t2p0 find v(out_cmp_gt) at=2.0m
meas tran cmp_gt_t2p8 find v(out_cmp_gt) at=2.8m
meas tran cmp_gt_t3p6 find v(out_cmp_gt) at=3.6m
meas tran cmp_lt_t0p4 find v(out_cmp_lt) at=0.4m
meas tran cmp_lt_t1p2 find v(out_cmp_lt) at=1.2m
meas tran cmp_lt_t2p0 find v(out_cmp_lt) at=2.0m
meas tran cmp_lt_t2p8 find v(out_cmp_lt) at=2.8m
meas tran cmp_lt_t3p6 find v(out_cmp_lt) at=3.6m
meas tran cmp_ge_t0p4 find v(out_cmp_ge) at=0.4m
meas tran cmp_ge_t1p2 find v(out_cmp_ge) at=1.2m
meas tran cmp_ge_t2p0 find v(out_cmp_ge) at=2.0m
meas tran cmp_ge_t2p8 find v(out_cmp_ge) at=2.8m
meas tran cmp_ge_t3p6 find v(out_cmp_ge) at=3.6m
meas tran cmp_le_t0p4 find v(out_cmp_le) at=0.4m
meas tran cmp_le_t1p2 find v(out_cmp_le) at=1.2m
meas tran cmp_le_t2p0 find v(out_cmp_le) at=2.0m
meas tran cmp_le_t2p8 find v(out_cmp_le) at=2.8m
meas tran cmp_le_t3p6 find v(out_cmp_le) at=3.6m
meas tran booland_t0p4 find v(out_booland) at=0.4m
meas tran booland_t1p2 find v(out_booland) at=1.2m
meas tran booland_t2p0 find v(out_booland) at=2.0m
meas tran booland_t2p8 find v(out_booland) at=2.8m
meas tran booland_t3p6 find v(out_booland) at=3.6m
meas tran boolor_t0p4 find v(out_boolor) at=0.4m
meas tran boolor_t1p2 find v(out_boolor) at=1.2m
meas tran boolor_t2p0 find v(out_boolor) at=2.0m
meas tran boolor_t2p8 find v(out_boolor) at=2.8m
meas tran boolor_t3p6 find v(out_boolor) at=3.6m
meas tran boolnot_t0p4 find v(out_boolnot) at=0.4m
meas tran boolnot_t1p2 find v(out_boolnot) at=1.2m
meas tran boolnot_t2p0 find v(out_boolnot) at=2.0m
meas tran boolnot_t2p8 find v(out_boolnot) at=2.8m
meas tran boolnot_t3p6 find v(out_boolnot) at=3.6m
meas tran ptime_t0p4 find v(out_ptime) at=0.4m
meas tran ptime_t1p2 find v(out_ptime) at=1.2m
meas tran ptime_t2p0 find v(out_ptime) at=2.0m
meas tran ptime_t2p8 find v(out_ptime) at=2.8m
meas tran ptime_t3p6 find v(out_ptime) at=3.6m
meas tran ptemper_t0p4 find v(out_ptemper) at=0.4m
meas tran ptemper_t1p2 find v(out_ptemper) at=1.2m
meas tran ptemper_t2p0 find v(out_ptemper) at=2.0m
meas tran ptemper_t2p8 find v(out_ptemper) at=2.8m
meas tran ptemper_t3p6 find v(out_ptemper) at=3.6m
meas tran compound_t0p4 find v(out_compound) at=0.4m
meas tran compound_t1p2 find v(out_compound) at=1.2m
meas tran compound_t2p0 find v(out_compound) at=2.0m
meas tran compound_t2p8 find v(out_compound) at=2.8m
meas tran compound_t3p6 find v(out_compound) at=3.6m
rusage cputime
quit
.endc
.end
