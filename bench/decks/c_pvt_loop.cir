* c_pvt_loop -- single-process 50-point PVT campaign (ngspice_augmentation
* card #467, plan T9.1, bench task 1c; generated by bench/gen_pvt.py -- do
* not hand-edit, regenerate instead). Same 50-point grid and same base
* circuit as bench/decks/pvt_points/pt_NN.cir (the separate-process form of
* this benchmark), run instead as one ngspice session: 'alterparam' each
* .param, 'reset' to re-elaborate, 'tran' again, per point -- this is the
* other half of the (a) many-short-points vs single-process-loop comparison
* the archived ngspice_accel project's S-A work made for parse/setup cost
* (see research/transient-acceleration.md).
.param vin_v=10 gon_scale=0.7
.temp 0
.param fs=500k tclk={1/fs}
.param lval=10u rdcr=10m cval=100u esrval=10m rload=3.3
.param ra=2300 rb=1000 vref=1
.param r1=10k r2=27.51k r3=101.7 c1=36.35p c2=2.299n c3=6.261n
.param vramp=2
.param gm_oa=1000 ro_oa=100 co_oa=100p
.param gon=100 goff=1e-6 ksw=30 kc=30

Vin vin 0 DC {vin_v}

Bhs vin sw I = (V(vin)-V(sw)) * ({goff}+({gon}*{gon_scale}-{goff})*0.5*(1+tanh({ksw}*(V(pwm)-0.5))))
Bls sw 0   I = V(sw)              * ({goff}+({gon}*{gon_scale}-{goff})*0.5*(1+tanh({ksw}*(0.5-V(pwm)))))

Csw sw 0 100p
L1 sw swl {lval} IC=0
Rdcr swl vout {rdcr}
Resr vout cx {esrval}
Cout cx 0 {cval} IC=0
Rload vout 0 {rload}

Ra vout fbnode {ra}
Rb fbnode 0 {rb}

Vrefsrc vrefnode 0 DC {vref}
Goa opout 0 vrefnode compin {gm_oa}
Roa opout 0 {ro_oa}
Coa opout 0 {co_oa}

R1in fbnode compin {r1}
R3in fbnode n3 {r3}
C3in n3 compin {c3}
C1f compin opout {c1}
R2f compin n2 {r2}
C2f n2 opout {c2}

Vramp ramp 0 PULSE(0 {vramp} 0 {0.97*tclk} {0.03*tclk} 1n {tclk})
Bcmp pwm 0 V = 0.5*(1+tanh({kc}*(V(opout)-V(ramp))))

.tran 20n 300.0u 0 uic
.options reltol=1e-3

.control
set filetype=ascii
rusage cputime

* --- point 000: vin_v=10 gon_scale=0.7 temp=0 ---
alterparam vin_v = 10
alterparam gon_scale = 0.7
option temp = 0
reset
run
meas tran p000_vout_avg AVG v(vout) FROM=290.01u TO=300.0u
meas tran p000_vout_ripple PP v(vout) FROM=290.01u TO=300.0u
meas tran p000_wave_mid find v(vout) at=150.0u
meas tran p000_wave_end find v(vout) at=300.0u

* --- point 001: vin_v=10 gon_scale=0.85 temp=0 ---
alterparam vin_v = 10
alterparam gon_scale = 0.85
option temp = 0
reset
run
meas tran p001_vout_avg AVG v(vout) FROM=290.01u TO=300.0u
meas tran p001_vout_ripple PP v(vout) FROM=290.01u TO=300.0u
meas tran p001_wave_mid find v(vout) at=150.0u
meas tran p001_wave_end find v(vout) at=300.0u

* --- point 002: vin_v=10 gon_scale=1.0 temp=0 ---
alterparam vin_v = 10
alterparam gon_scale = 1.0
option temp = 0
reset
run
meas tran p002_vout_avg AVG v(vout) FROM=290.01u TO=300.0u
meas tran p002_vout_ripple PP v(vout) FROM=290.01u TO=300.0u
meas tran p002_wave_mid find v(vout) at=150.0u
meas tran p002_wave_end find v(vout) at=300.0u

* --- point 003: vin_v=10 gon_scale=1.15 temp=0 ---
alterparam vin_v = 10
alterparam gon_scale = 1.15
option temp = 0
reset
run
meas tran p003_vout_avg AVG v(vout) FROM=290.01u TO=300.0u
meas tran p003_vout_ripple PP v(vout) FROM=290.01u TO=300.0u
meas tran p003_wave_mid find v(vout) at=150.0u
meas tran p003_wave_end find v(vout) at=300.0u

* --- point 004: vin_v=10 gon_scale=1.3 temp=0 ---
alterparam vin_v = 10
alterparam gon_scale = 1.3
option temp = 0
reset
run
meas tran p004_vout_avg AVG v(vout) FROM=290.01u TO=300.0u
meas tran p004_vout_ripple PP v(vout) FROM=290.01u TO=300.0u
meas tran p004_wave_mid find v(vout) at=150.0u
meas tran p004_wave_end find v(vout) at=300.0u

* --- point 005: vin_v=11 gon_scale=0.7 temp=0 ---
alterparam vin_v = 11
alterparam gon_scale = 0.7
option temp = 0
reset
run
meas tran p005_vout_avg AVG v(vout) FROM=290.01u TO=300.0u
meas tran p005_vout_ripple PP v(vout) FROM=290.01u TO=300.0u
meas tran p005_wave_mid find v(vout) at=150.0u
meas tran p005_wave_end find v(vout) at=300.0u

* --- point 006: vin_v=11 gon_scale=0.85 temp=0 ---
alterparam vin_v = 11
alterparam gon_scale = 0.85
option temp = 0
reset
run
meas tran p006_vout_avg AVG v(vout) FROM=290.01u TO=300.0u
meas tran p006_vout_ripple PP v(vout) FROM=290.01u TO=300.0u
meas tran p006_wave_mid find v(vout) at=150.0u
meas tran p006_wave_end find v(vout) at=300.0u

* --- point 007: vin_v=11 gon_scale=1.0 temp=0 ---
alterparam vin_v = 11
alterparam gon_scale = 1.0
option temp = 0
reset
run
meas tran p007_vout_avg AVG v(vout) FROM=290.01u TO=300.0u
meas tran p007_vout_ripple PP v(vout) FROM=290.01u TO=300.0u
meas tran p007_wave_mid find v(vout) at=150.0u
meas tran p007_wave_end find v(vout) at=300.0u

* --- point 008: vin_v=11 gon_scale=1.15 temp=0 ---
alterparam vin_v = 11
alterparam gon_scale = 1.15
option temp = 0
reset
run
meas tran p008_vout_avg AVG v(vout) FROM=290.01u TO=300.0u
meas tran p008_vout_ripple PP v(vout) FROM=290.01u TO=300.0u
meas tran p008_wave_mid find v(vout) at=150.0u
meas tran p008_wave_end find v(vout) at=300.0u

* --- point 009: vin_v=11 gon_scale=1.3 temp=0 ---
alterparam vin_v = 11
alterparam gon_scale = 1.3
option temp = 0
reset
run
meas tran p009_vout_avg AVG v(vout) FROM=290.01u TO=300.0u
meas tran p009_vout_ripple PP v(vout) FROM=290.01u TO=300.0u
meas tran p009_wave_mid find v(vout) at=150.0u
meas tran p009_wave_end find v(vout) at=300.0u

* --- point 010: vin_v=12 gon_scale=0.7 temp=0 ---
alterparam vin_v = 12
alterparam gon_scale = 0.7
option temp = 0
reset
run
meas tran p010_vout_avg AVG v(vout) FROM=290.01u TO=300.0u
meas tran p010_vout_ripple PP v(vout) FROM=290.01u TO=300.0u
meas tran p010_wave_mid find v(vout) at=150.0u
meas tran p010_wave_end find v(vout) at=300.0u

* --- point 011: vin_v=12 gon_scale=0.85 temp=0 ---
alterparam vin_v = 12
alterparam gon_scale = 0.85
option temp = 0
reset
run
meas tran p011_vout_avg AVG v(vout) FROM=290.01u TO=300.0u
meas tran p011_vout_ripple PP v(vout) FROM=290.01u TO=300.0u
meas tran p011_wave_mid find v(vout) at=150.0u
meas tran p011_wave_end find v(vout) at=300.0u

* --- point 012: vin_v=12 gon_scale=1.0 temp=0 ---
alterparam vin_v = 12
alterparam gon_scale = 1.0
option temp = 0
reset
run
meas tran p012_vout_avg AVG v(vout) FROM=290.01u TO=300.0u
meas tran p012_vout_ripple PP v(vout) FROM=290.01u TO=300.0u
meas tran p012_wave_mid find v(vout) at=150.0u
meas tran p012_wave_end find v(vout) at=300.0u

* --- point 013: vin_v=12 gon_scale=1.15 temp=0 ---
alterparam vin_v = 12
alterparam gon_scale = 1.15
option temp = 0
reset
run
meas tran p013_vout_avg AVG v(vout) FROM=290.01u TO=300.0u
meas tran p013_vout_ripple PP v(vout) FROM=290.01u TO=300.0u
meas tran p013_wave_mid find v(vout) at=150.0u
meas tran p013_wave_end find v(vout) at=300.0u

* --- point 014: vin_v=12 gon_scale=1.3 temp=0 ---
alterparam vin_v = 12
alterparam gon_scale = 1.3
option temp = 0
reset
run
meas tran p014_vout_avg AVG v(vout) FROM=290.01u TO=300.0u
meas tran p014_vout_ripple PP v(vout) FROM=290.01u TO=300.0u
meas tran p014_wave_mid find v(vout) at=150.0u
meas tran p014_wave_end find v(vout) at=300.0u

* --- point 015: vin_v=13 gon_scale=0.7 temp=0 ---
alterparam vin_v = 13
alterparam gon_scale = 0.7
option temp = 0
reset
run
meas tran p015_vout_avg AVG v(vout) FROM=290.01u TO=300.0u
meas tran p015_vout_ripple PP v(vout) FROM=290.01u TO=300.0u
meas tran p015_wave_mid find v(vout) at=150.0u
meas tran p015_wave_end find v(vout) at=300.0u

* --- point 016: vin_v=13 gon_scale=0.85 temp=0 ---
alterparam vin_v = 13
alterparam gon_scale = 0.85
option temp = 0
reset
run
meas tran p016_vout_avg AVG v(vout) FROM=290.01u TO=300.0u
meas tran p016_vout_ripple PP v(vout) FROM=290.01u TO=300.0u
meas tran p016_wave_mid find v(vout) at=150.0u
meas tran p016_wave_end find v(vout) at=300.0u

* --- point 017: vin_v=13 gon_scale=1.0 temp=0 ---
alterparam vin_v = 13
alterparam gon_scale = 1.0
option temp = 0
reset
run
meas tran p017_vout_avg AVG v(vout) FROM=290.01u TO=300.0u
meas tran p017_vout_ripple PP v(vout) FROM=290.01u TO=300.0u
meas tran p017_wave_mid find v(vout) at=150.0u
meas tran p017_wave_end find v(vout) at=300.0u

* --- point 018: vin_v=13 gon_scale=1.15 temp=0 ---
alterparam vin_v = 13
alterparam gon_scale = 1.15
option temp = 0
reset
run
meas tran p018_vout_avg AVG v(vout) FROM=290.01u TO=300.0u
meas tran p018_vout_ripple PP v(vout) FROM=290.01u TO=300.0u
meas tran p018_wave_mid find v(vout) at=150.0u
meas tran p018_wave_end find v(vout) at=300.0u

* --- point 019: vin_v=13 gon_scale=1.3 temp=0 ---
alterparam vin_v = 13
alterparam gon_scale = 1.3
option temp = 0
reset
run
meas tran p019_vout_avg AVG v(vout) FROM=290.01u TO=300.0u
meas tran p019_vout_ripple PP v(vout) FROM=290.01u TO=300.0u
meas tran p019_wave_mid find v(vout) at=150.0u
meas tran p019_wave_end find v(vout) at=300.0u

* --- point 020: vin_v=14 gon_scale=0.7 temp=0 ---
alterparam vin_v = 14
alterparam gon_scale = 0.7
option temp = 0
reset
run
meas tran p020_vout_avg AVG v(vout) FROM=290.01u TO=300.0u
meas tran p020_vout_ripple PP v(vout) FROM=290.01u TO=300.0u
meas tran p020_wave_mid find v(vout) at=150.0u
meas tran p020_wave_end find v(vout) at=300.0u

* --- point 021: vin_v=14 gon_scale=0.85 temp=0 ---
alterparam vin_v = 14
alterparam gon_scale = 0.85
option temp = 0
reset
run
meas tran p021_vout_avg AVG v(vout) FROM=290.01u TO=300.0u
meas tran p021_vout_ripple PP v(vout) FROM=290.01u TO=300.0u
meas tran p021_wave_mid find v(vout) at=150.0u
meas tran p021_wave_end find v(vout) at=300.0u

* --- point 022: vin_v=14 gon_scale=1.0 temp=0 ---
alterparam vin_v = 14
alterparam gon_scale = 1.0
option temp = 0
reset
run
meas tran p022_vout_avg AVG v(vout) FROM=290.01u TO=300.0u
meas tran p022_vout_ripple PP v(vout) FROM=290.01u TO=300.0u
meas tran p022_wave_mid find v(vout) at=150.0u
meas tran p022_wave_end find v(vout) at=300.0u

* --- point 023: vin_v=14 gon_scale=1.15 temp=0 ---
alterparam vin_v = 14
alterparam gon_scale = 1.15
option temp = 0
reset
run
meas tran p023_vout_avg AVG v(vout) FROM=290.01u TO=300.0u
meas tran p023_vout_ripple PP v(vout) FROM=290.01u TO=300.0u
meas tran p023_wave_mid find v(vout) at=150.0u
meas tran p023_wave_end find v(vout) at=300.0u

* --- point 024: vin_v=14 gon_scale=1.3 temp=0 ---
alterparam vin_v = 14
alterparam gon_scale = 1.3
option temp = 0
reset
run
meas tran p024_vout_avg AVG v(vout) FROM=290.01u TO=300.0u
meas tran p024_vout_ripple PP v(vout) FROM=290.01u TO=300.0u
meas tran p024_wave_mid find v(vout) at=150.0u
meas tran p024_wave_end find v(vout) at=300.0u

* --- point 025: vin_v=10 gon_scale=0.7 temp=85 ---
alterparam vin_v = 10
alterparam gon_scale = 0.7
option temp = 85
reset
run
meas tran p025_vout_avg AVG v(vout) FROM=290.01u TO=300.0u
meas tran p025_vout_ripple PP v(vout) FROM=290.01u TO=300.0u
meas tran p025_wave_mid find v(vout) at=150.0u
meas tran p025_wave_end find v(vout) at=300.0u

* --- point 026: vin_v=10 gon_scale=0.85 temp=85 ---
alterparam vin_v = 10
alterparam gon_scale = 0.85
option temp = 85
reset
run
meas tran p026_vout_avg AVG v(vout) FROM=290.01u TO=300.0u
meas tran p026_vout_ripple PP v(vout) FROM=290.01u TO=300.0u
meas tran p026_wave_mid find v(vout) at=150.0u
meas tran p026_wave_end find v(vout) at=300.0u

* --- point 027: vin_v=10 gon_scale=1.0 temp=85 ---
alterparam vin_v = 10
alterparam gon_scale = 1.0
option temp = 85
reset
run
meas tran p027_vout_avg AVG v(vout) FROM=290.01u TO=300.0u
meas tran p027_vout_ripple PP v(vout) FROM=290.01u TO=300.0u
meas tran p027_wave_mid find v(vout) at=150.0u
meas tran p027_wave_end find v(vout) at=300.0u

* --- point 028: vin_v=10 gon_scale=1.15 temp=85 ---
alterparam vin_v = 10
alterparam gon_scale = 1.15
option temp = 85
reset
run
meas tran p028_vout_avg AVG v(vout) FROM=290.01u TO=300.0u
meas tran p028_vout_ripple PP v(vout) FROM=290.01u TO=300.0u
meas tran p028_wave_mid find v(vout) at=150.0u
meas tran p028_wave_end find v(vout) at=300.0u

* --- point 029: vin_v=10 gon_scale=1.3 temp=85 ---
alterparam vin_v = 10
alterparam gon_scale = 1.3
option temp = 85
reset
run
meas tran p029_vout_avg AVG v(vout) FROM=290.01u TO=300.0u
meas tran p029_vout_ripple PP v(vout) FROM=290.01u TO=300.0u
meas tran p029_wave_mid find v(vout) at=150.0u
meas tran p029_wave_end find v(vout) at=300.0u

* --- point 030: vin_v=11 gon_scale=0.7 temp=85 ---
alterparam vin_v = 11
alterparam gon_scale = 0.7
option temp = 85
reset
run
meas tran p030_vout_avg AVG v(vout) FROM=290.01u TO=300.0u
meas tran p030_vout_ripple PP v(vout) FROM=290.01u TO=300.0u
meas tran p030_wave_mid find v(vout) at=150.0u
meas tran p030_wave_end find v(vout) at=300.0u

* --- point 031: vin_v=11 gon_scale=0.85 temp=85 ---
alterparam vin_v = 11
alterparam gon_scale = 0.85
option temp = 85
reset
run
meas tran p031_vout_avg AVG v(vout) FROM=290.01u TO=300.0u
meas tran p031_vout_ripple PP v(vout) FROM=290.01u TO=300.0u
meas tran p031_wave_mid find v(vout) at=150.0u
meas tran p031_wave_end find v(vout) at=300.0u

* --- point 032: vin_v=11 gon_scale=1.0 temp=85 ---
alterparam vin_v = 11
alterparam gon_scale = 1.0
option temp = 85
reset
run
meas tran p032_vout_avg AVG v(vout) FROM=290.01u TO=300.0u
meas tran p032_vout_ripple PP v(vout) FROM=290.01u TO=300.0u
meas tran p032_wave_mid find v(vout) at=150.0u
meas tran p032_wave_end find v(vout) at=300.0u

* --- point 033: vin_v=11 gon_scale=1.15 temp=85 ---
alterparam vin_v = 11
alterparam gon_scale = 1.15
option temp = 85
reset
run
meas tran p033_vout_avg AVG v(vout) FROM=290.01u TO=300.0u
meas tran p033_vout_ripple PP v(vout) FROM=290.01u TO=300.0u
meas tran p033_wave_mid find v(vout) at=150.0u
meas tran p033_wave_end find v(vout) at=300.0u

* --- point 034: vin_v=11 gon_scale=1.3 temp=85 ---
alterparam vin_v = 11
alterparam gon_scale = 1.3
option temp = 85
reset
run
meas tran p034_vout_avg AVG v(vout) FROM=290.01u TO=300.0u
meas tran p034_vout_ripple PP v(vout) FROM=290.01u TO=300.0u
meas tran p034_wave_mid find v(vout) at=150.0u
meas tran p034_wave_end find v(vout) at=300.0u

* --- point 035: vin_v=12 gon_scale=0.7 temp=85 ---
alterparam vin_v = 12
alterparam gon_scale = 0.7
option temp = 85
reset
run
meas tran p035_vout_avg AVG v(vout) FROM=290.01u TO=300.0u
meas tran p035_vout_ripple PP v(vout) FROM=290.01u TO=300.0u
meas tran p035_wave_mid find v(vout) at=150.0u
meas tran p035_wave_end find v(vout) at=300.0u

* --- point 036: vin_v=12 gon_scale=0.85 temp=85 ---
alterparam vin_v = 12
alterparam gon_scale = 0.85
option temp = 85
reset
run
meas tran p036_vout_avg AVG v(vout) FROM=290.01u TO=300.0u
meas tran p036_vout_ripple PP v(vout) FROM=290.01u TO=300.0u
meas tran p036_wave_mid find v(vout) at=150.0u
meas tran p036_wave_end find v(vout) at=300.0u

* --- point 037: vin_v=12 gon_scale=1.0 temp=85 ---
alterparam vin_v = 12
alterparam gon_scale = 1.0
option temp = 85
reset
run
meas tran p037_vout_avg AVG v(vout) FROM=290.01u TO=300.0u
meas tran p037_vout_ripple PP v(vout) FROM=290.01u TO=300.0u
meas tran p037_wave_mid find v(vout) at=150.0u
meas tran p037_wave_end find v(vout) at=300.0u

* --- point 038: vin_v=12 gon_scale=1.15 temp=85 ---
alterparam vin_v = 12
alterparam gon_scale = 1.15
option temp = 85
reset
run
meas tran p038_vout_avg AVG v(vout) FROM=290.01u TO=300.0u
meas tran p038_vout_ripple PP v(vout) FROM=290.01u TO=300.0u
meas tran p038_wave_mid find v(vout) at=150.0u
meas tran p038_wave_end find v(vout) at=300.0u

* --- point 039: vin_v=12 gon_scale=1.3 temp=85 ---
alterparam vin_v = 12
alterparam gon_scale = 1.3
option temp = 85
reset
run
meas tran p039_vout_avg AVG v(vout) FROM=290.01u TO=300.0u
meas tran p039_vout_ripple PP v(vout) FROM=290.01u TO=300.0u
meas tran p039_wave_mid find v(vout) at=150.0u
meas tran p039_wave_end find v(vout) at=300.0u

* --- point 040: vin_v=13 gon_scale=0.7 temp=85 ---
alterparam vin_v = 13
alterparam gon_scale = 0.7
option temp = 85
reset
run
meas tran p040_vout_avg AVG v(vout) FROM=290.01u TO=300.0u
meas tran p040_vout_ripple PP v(vout) FROM=290.01u TO=300.0u
meas tran p040_wave_mid find v(vout) at=150.0u
meas tran p040_wave_end find v(vout) at=300.0u

* --- point 041: vin_v=13 gon_scale=0.85 temp=85 ---
alterparam vin_v = 13
alterparam gon_scale = 0.85
option temp = 85
reset
run
meas tran p041_vout_avg AVG v(vout) FROM=290.01u TO=300.0u
meas tran p041_vout_ripple PP v(vout) FROM=290.01u TO=300.0u
meas tran p041_wave_mid find v(vout) at=150.0u
meas tran p041_wave_end find v(vout) at=300.0u

* --- point 042: vin_v=13 gon_scale=1.0 temp=85 ---
alterparam vin_v = 13
alterparam gon_scale = 1.0
option temp = 85
reset
run
meas tran p042_vout_avg AVG v(vout) FROM=290.01u TO=300.0u
meas tran p042_vout_ripple PP v(vout) FROM=290.01u TO=300.0u
meas tran p042_wave_mid find v(vout) at=150.0u
meas tran p042_wave_end find v(vout) at=300.0u

* --- point 043: vin_v=13 gon_scale=1.15 temp=85 ---
alterparam vin_v = 13
alterparam gon_scale = 1.15
option temp = 85
reset
run
meas tran p043_vout_avg AVG v(vout) FROM=290.01u TO=300.0u
meas tran p043_vout_ripple PP v(vout) FROM=290.01u TO=300.0u
meas tran p043_wave_mid find v(vout) at=150.0u
meas tran p043_wave_end find v(vout) at=300.0u

* --- point 044: vin_v=13 gon_scale=1.3 temp=85 ---
alterparam vin_v = 13
alterparam gon_scale = 1.3
option temp = 85
reset
run
meas tran p044_vout_avg AVG v(vout) FROM=290.01u TO=300.0u
meas tran p044_vout_ripple PP v(vout) FROM=290.01u TO=300.0u
meas tran p044_wave_mid find v(vout) at=150.0u
meas tran p044_wave_end find v(vout) at=300.0u

* --- point 045: vin_v=14 gon_scale=0.7 temp=85 ---
alterparam vin_v = 14
alterparam gon_scale = 0.7
option temp = 85
reset
run
meas tran p045_vout_avg AVG v(vout) FROM=290.01u TO=300.0u
meas tran p045_vout_ripple PP v(vout) FROM=290.01u TO=300.0u
meas tran p045_wave_mid find v(vout) at=150.0u
meas tran p045_wave_end find v(vout) at=300.0u

* --- point 046: vin_v=14 gon_scale=0.85 temp=85 ---
alterparam vin_v = 14
alterparam gon_scale = 0.85
option temp = 85
reset
run
meas tran p046_vout_avg AVG v(vout) FROM=290.01u TO=300.0u
meas tran p046_vout_ripple PP v(vout) FROM=290.01u TO=300.0u
meas tran p046_wave_mid find v(vout) at=150.0u
meas tran p046_wave_end find v(vout) at=300.0u

* --- point 047: vin_v=14 gon_scale=1.0 temp=85 ---
alterparam vin_v = 14
alterparam gon_scale = 1.0
option temp = 85
reset
run
meas tran p047_vout_avg AVG v(vout) FROM=290.01u TO=300.0u
meas tran p047_vout_ripple PP v(vout) FROM=290.01u TO=300.0u
meas tran p047_wave_mid find v(vout) at=150.0u
meas tran p047_wave_end find v(vout) at=300.0u

* --- point 048: vin_v=14 gon_scale=1.15 temp=85 ---
alterparam vin_v = 14
alterparam gon_scale = 1.15
option temp = 85
reset
run
meas tran p048_vout_avg AVG v(vout) FROM=290.01u TO=300.0u
meas tran p048_vout_ripple PP v(vout) FROM=290.01u TO=300.0u
meas tran p048_wave_mid find v(vout) at=150.0u
meas tran p048_wave_end find v(vout) at=300.0u

* --- point 049: vin_v=14 gon_scale=1.3 temp=85 ---
alterparam vin_v = 14
alterparam gon_scale = 1.3
option temp = 85
reset
run
meas tran p049_vout_avg AVG v(vout) FROM=290.01u TO=300.0u
meas tran p049_vout_ripple PP v(vout) FROM=290.01u TO=300.0u
meas tran p049_wave_mid find v(vout) at=150.0u
meas tran p049_wave_end find v(vout) at=300.0u

rusage cputime
quit
.endc
.end
