* xspice_dig_fdiv_lut: digital/hybrid XSPICE models under .pss (card #551); STATEFILE is replaced by the test
Vclk clk 0 PULSE(0 1 0 5n 5n 495n 1u)
Vone one 0 DC 1
Vzero zero 0 DC 0
Abr [clk one zero] [dclk dhi dlo] adc1
.model adc1 adc_bridge(in_low=0.3 in_high=0.7)
At1 dhi dclk dlo dlo dq1 dq1n tf
At2 dhi dq1n dlo dlo dq2 dq2n tf
.model tf d_tff(clk_delay=1n set_delay=1n reset_delay=1n ic=0)
Afd dclk fo mfd
.model mfd d_fdiv(div_factor=4 high_cycles=2 i_count=0 rise_delay=2n fall_delay=2n)
Alut [dq1 dq2] yl mlut
.model mlut d_lut(rise_delay=2n fall_delay=2n table_values "0110")
Ast [dhi] dclk dlo [st1 st0] mst
.model mst d_state(state_file = "STATEFILE" reset_state=0 clk_delay=2n reset_delay=1n)
Abo [fo yl st1 st0] [a0 a1 a2 a3] dac1
Rd0 a0 out 1k
Rd1 a1 out 1.9k
Rd2 a2 out 3.3k
Rd3 a3 out 6.2k
.model dac1 dac_bridge(out_low=0 out_high=1 t_rise=50n t_fall=50n)
Co out 0 100p
Rl out 0 10k
