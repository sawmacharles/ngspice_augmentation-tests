* xspice_an_capacitor: XSPICE code model 'capacitor' in a periodic circuit (card #551); tests/test_xspice.py appends .options/.pss/.tran
Vin in 0 PULSE(0 1 0 100n 100n 4.9u 10u)
Rs in o1 1k
A1 o1 0 m
.model m capacitoric(c=100p)
Rl o1 out 1k
Co out 0 100p
