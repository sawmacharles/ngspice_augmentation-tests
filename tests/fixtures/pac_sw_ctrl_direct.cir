Reader507 task4: open-loop ideal-switch buck, .pac solver=td control-to-output
Vin vin 0 DC 12
Vramp vramp 0 PULSE(0 1 0 2u 1n 1n 2u)
Vctrl vctrl 0 DC 0.5 AC 1
.model SWMOD SW(vt=0 vh=0 ron=0.05 roff=1e6)
S1 vin sw vctrl vramp SWMOD
D1 0 sw DMOD
.model DMOD D(IS=1e-14 RS=0.02 N=1.05)
L1 sw vout 10u
Resr vout voutc 0.01
Cout voutc 0 100u IC=6
Rload vout 0 5
.pac 500k 0 vout 200 1 25 1e-6 lin 2 1000 248744 method="shoot" solver="td"
.control
run
display
print vout
.endc
.end
