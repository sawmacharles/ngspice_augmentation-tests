* buckp_noline: tra_buckp with the line replaced by a 1 uOhm short (engine baseline on the same switching deck)
* lossless line (TRA, Z0 5 ohm, TD 0.3 us); the input source carries the small-signal injection (line-to-output)
.param vin_v=12 fs=500k tclk={1/fs} duty=0.45
.param lval=4.7u rdcr=20m cval=4.7u esrval=20m rload=3.3 cl=100n
.param td=0.3u z0=5
Vin vin 0 DC {vin_v} AC 1
Shs vin sw drv 0 SWMOD
.model SWMOD SW(vt=0.5 vh=0.05 ron=10m roff=1Meg)
D1 0 sw DMOD
.model DMOD D(IS=1e-9 RS=0.05 N=1.05 CJO=0 VJ=0.7 M=0.5 TT=0)
L1 sw swl {lval} IC=0
Rdcr swl vout {rdcr}
Resr vout cx {esrval}
Cout cx 0 {cval} IC=0
Rshort vout vl 1u
Rload vl 0 {rload}
Cl vl 0 {cl}
Vdrv drv 0 PULSE(0 1 0 5n 5n {duty*tclk-5n} {tclk})
