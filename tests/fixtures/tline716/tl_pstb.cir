* tl_pstb: single-pole transconductance loop (as tests/fixtures/pstb_linear.cir) whose output reaches the feedback divider
* through a lossless line (Z0 1k, TD 20 ns, mismatched at both ends); an unrelated 100 kHz drive gives the PSS its period
.param gm=10m ro=100k co=10p r1=100k r2=100k cn=2p td=20n z0=1k
Vclk clk 0 PULSE(0 1 0 1n 1n 5u 10u)
Rclk clk clkgnd 1k
Cclk clkgnd 0 1n
Vp vp 0 DC 0.1 AC 0
G1 0 o vp vn {gm}
Ro o 0 {ro}
Co o 0 {co}
T1 o 0 ol 0 Z0={z0} TD={td}
R1 ol fb {r1}
R2 fb 0 {r2}
Vprobe fb vn DC 0
Cn vn 0 {cn}
