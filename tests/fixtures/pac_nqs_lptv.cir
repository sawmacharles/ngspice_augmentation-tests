* pac_nqs_lptv.cir -- BSIM4 common-source stage with a NON-QUASI-STATIC channel (trnqsmod=1, W 40u / L 20u: charge-relaxation time ~0.1 us)
* driven by a large 1 MHz local oscillator on its gate (the device swings from near cut-off into strong conduction), small signal
* injected at Vin (DC 0.9 V, AC 1).  Card #559 item 2: the periodic small-signal response through the relaxing channel charge
* (a linear periodically time-varying system with a hidden relaxation state) against the perturbed periodic steady state.
* {nq} = trnqsmod (1 = NQS channel, 0 = quasi-static, the same deck).  Body only, no .control block.
.param nq=1 lo=0.35
.model nch4 nmos level=54 version=4.8.2 mobmod=0 capmod=2 igcmod=0 igbmod=0 rdsmod=0 rbodymod=0 rgatemod=0 acnqsmod=0 trnqsmod={nq}
+ toxe=3e-9 toxp=3e-9 toxm=3e-9 vth0=0.5 k1=0.4 k2=0 k3=0 w0=2.5e-6 u0=300 vsat=1.1e5 cgso=2e-10 cgdo=2e-10 cgbo=1e-11
+ cgsl=1e-10 cgdl=1e-10 cf=1e-10 cjs=1e-3 cjd=1e-3 cjswd=1e-10 cjswgd=1e-10 xpart=0
Vdd vdd 0 3
Vin in 0 DC 0.9 AC 1
Vlo in1 in SIN(0 {lo} 1Meg)
Rs in1 g 100
M1 out g 0 0 nch4 w=40u l=20u as=4p ad=4p ps=10u pd=10u
Rd vdd out 20k
Cl out 0 50f
.end
