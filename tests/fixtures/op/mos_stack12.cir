* op_mos_stack12: twelve series NMOS (level 3, body at ground) from a 3.3 V rail to ground, all gates at 3.3 V
* Hard for DC OP because: NAND12-like pull-down stack: body effect grows up the stack, the intermediate nodes start at 0 with most devices deep in saturation and cut off
* (card #637 corpus, generated by tools/gen_opcorpus.py -- edit the generator, not the deck)
Vdd vdd 0 3.3
Vg g 0 3.3
M0 vdd g x0 0 n3 w=6u l=0.35u
M1 x0 g x1 0 n3 w=6u l=0.35u
M2 x1 g x2 0 n3 w=6u l=0.35u
M3 x2 g x3 0 n3 w=6u l=0.35u
M4 x3 g x4 0 n3 w=6u l=0.35u
M5 x4 g x5 0 n3 w=6u l=0.35u
M6 x5 g x6 0 n3 w=6u l=0.35u
M7 x6 g x7 0 n3 w=6u l=0.35u
M8 x7 g x8 0 n3 w=6u l=0.35u
M9 x8 g x9 0 n3 w=6u l=0.35u
M10 x9 g x10 0 n3 w=6u l=0.35u
M11 x10 g 0 0 n3 w=6u l=0.35u
.model n3 nmos level=3 vto=0.5 uo=400 tox=4e-9 theta=0.15 vmax=1.5e5 eta=0.02 kappa=0.1
+ gamma=0.5 phi=0.8 nsub=3e17 xj=0.15u ld=0.02u cgso=3e-10 cgdo=3e-10 cj=1e-3 mj=0.5 cjsw=2e-10
.op
.end
