* op_ring5: 5-stage ring oscillator (level 1) -- the DC OP is the metastable all-stages-at-trip point
* Hard for DC OP because: odd inverter ring has a single DC solution at the trip voltage where every stage has gain > 1 (unstable, but a DC root); Newton can bounce between rails
* (card #637 corpus, generated by tools/gen_opcorpus.py -- edit the generator, not the deck)
Vdd vdd 0 1.8
M1n s1 s0 0 0 n1 w=1u l=0.18u
M1p s1 s0 vdd vdd p1 w=2.5u l=0.18u
M2n s2 s1 0 0 n1 w=1u l=0.18u
M2p s2 s1 vdd vdd p1 w=2.5u l=0.18u
M3n s3 s2 0 0 n1 w=1u l=0.18u
M3p s3 s2 vdd vdd p1 w=2.5u l=0.18u
M4n s4 s3 0 0 n1 w=1u l=0.18u
M4p s4 s3 vdd vdd p1 w=2.5u l=0.18u
M5n s0 s4 0 0 n1 w=1u l=0.18u
M5p s0 s4 vdd vdd p1 w=2.5u l=0.18u
.model n1 nmos level=1 vto=0.5 kp=200u lambda=0.05 gamma=0.4 phi=0.7 cbd=5f cbs=5f
.model p1 pmos level=1 vto=-0.5 kp=70u lambda=0.06 gamma=0.4 phi=0.7 cbd=5f cbs=5f
.op
.end
