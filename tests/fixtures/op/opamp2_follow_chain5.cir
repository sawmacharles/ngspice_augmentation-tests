* op_opamp2_follow_chain5: five two-stage Miller opamps (BSIM3) cascaded as unity-gain followers, input 0.9 V
* Hard for DC OP because: five nested high-gain (1e5) feedback loops, each with an output at a rail until its own loop closes; 55 transistors
* (card #637 corpus, generated by tools/gen_opcorpus.py -- edit the generator, not the deck)
Vdd vdd 0 1.8
Vin in0 0 0.9
Ib vdd bias 20u
Mb bias bias 0 0 nb3 w=4u l=0.5u
Mt0 tail0 bias 0 0 nb3 w=16u l=0.5u
M1_0 d1_0 in0 tail0 0 nb3 w=20u l=0.5u
M2_0 d2_0 o0 tail0 0 nb3 w=20u l=0.5u
M3_0 d1_0 d1_0 vdd vdd pb3 w=20u l=0.5u
M4_0 d2_0 d1_0 vdd vdd pb3 w=20u l=0.5u
M6_0 o0 d2_0 vdd vdd pb3 w=60u l=0.5u
M7_0 o0 bias 0 0 nb3 w=64u l=0.5u
Cc0 d2_0 o0 1p
Mt1 tail1 bias 0 0 nb3 w=16u l=0.5u
M1_1 d1_1 o0 tail1 0 nb3 w=20u l=0.5u
M2_1 d2_1 o1 tail1 0 nb3 w=20u l=0.5u
M3_1 d1_1 d1_1 vdd vdd pb3 w=20u l=0.5u
M4_1 d2_1 d1_1 vdd vdd pb3 w=20u l=0.5u
M6_1 o1 d2_1 vdd vdd pb3 w=60u l=0.5u
M7_1 o1 bias 0 0 nb3 w=64u l=0.5u
Cc1 d2_1 o1 1p
Mt2 tail2 bias 0 0 nb3 w=16u l=0.5u
M1_2 d1_2 o1 tail2 0 nb3 w=20u l=0.5u
M2_2 d2_2 o2 tail2 0 nb3 w=20u l=0.5u
M3_2 d1_2 d1_2 vdd vdd pb3 w=20u l=0.5u
M4_2 d2_2 d1_2 vdd vdd pb3 w=20u l=0.5u
M6_2 o2 d2_2 vdd vdd pb3 w=60u l=0.5u
M7_2 o2 bias 0 0 nb3 w=64u l=0.5u
Cc2 d2_2 o2 1p
Mt3 tail3 bias 0 0 nb3 w=16u l=0.5u
M1_3 d1_3 o2 tail3 0 nb3 w=20u l=0.5u
M2_3 d2_3 o3 tail3 0 nb3 w=20u l=0.5u
M3_3 d1_3 d1_3 vdd vdd pb3 w=20u l=0.5u
M4_3 d2_3 d1_3 vdd vdd pb3 w=20u l=0.5u
M6_3 o3 d2_3 vdd vdd pb3 w=60u l=0.5u
M7_3 o3 bias 0 0 nb3 w=64u l=0.5u
Cc3 d2_3 o3 1p
Mt4 tail4 bias 0 0 nb3 w=16u l=0.5u
M1_4 d1_4 o3 tail4 0 nb3 w=20u l=0.5u
M2_4 d2_4 o4 tail4 0 nb3 w=20u l=0.5u
M3_4 d1_4 d1_4 vdd vdd pb3 w=20u l=0.5u
M4_4 d2_4 d1_4 vdd vdd pb3 w=20u l=0.5u
M6_4 o4 d2_4 vdd vdd pb3 w=60u l=0.5u
M7_4 o4 bias 0 0 nb3 w=64u l=0.5u
Cc4 d2_4 o4 1p
.model nb3 nmos level=8 version=3.3.0 tox=4.1e-9 vth0=0.45 k1=0.55 k2=0 u0=300 vsat=1.0e5
+ nch=1.7e17 xj=1.5e-7 pclm=1.2 rdsw=150 cgso=3e-10 cgdo=3e-10 cj=1e-3 mj=0.5 cjsw=2e-10 nfactor=1.2 voff=-0.1
.model pb3 pmos level=8 version=3.3.0 tox=4.1e-9 vth0=-0.45 k1=0.55 k2=0 u0=90 vsat=0.9e5
+ nch=1.7e17 xj=1.5e-7 pclm=1.2 rdsw=300 cgso=3e-10 cgdo=3e-10 cj=1e-3 mj=0.5 cjsw=2e-10 nfactor=1.2 voff=-0.1
.op
.end
