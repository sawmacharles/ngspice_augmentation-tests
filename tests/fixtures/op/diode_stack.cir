* op_diode_stack: 20 diodes in series across 100 V through 1 ohm
* Hard for DC OP because: I = ~60 A: every junction sits ~1.1 V on a 1e-14 A saturation current; the exponent overflows if Newton is not limited
* (card #637 corpus, generated by tools/gen_opcorpus.py -- edit the generator, not the deck)
V1 n0 0 100
R1 n0 n1 1
D1 n1 n2 dm
D2 n2 n3 dm
D3 n3 n4 dm
D4 n4 n5 dm
D5 n5 n6 dm
D6 n6 n7 dm
D7 n7 n8 dm
D8 n8 n9 dm
D9 n9 n10 dm
D10 n10 n11 dm
D11 n11 n12 dm
D12 n12 n13 dm
D13 n13 n14 dm
D14 n14 n15 dm
D15 n15 n16 dm
D16 n16 n17 dm
D17 n17 n18 dm
D18 n18 n19 dm
D19 n19 n20 dm
D20 n20 0 dm
.model dm d is=1e-14 n=1 rs=0.5 cjo=1p
.op
.end
