* op_diode_stack_200v: 40 diodes in series across 200 V through 0.1 ohm
* Hard for DC OP because: currents of ~1500 A at about 1.2 V per junction; per-junction step limiting is taxed (5 V of drive per junction at the start)
* (card #637 corpus, generated by tools/gen_opcorpus.py -- edit the generator, not the deck)
V1 n0 0 200
R1 n0 n1 0.1
D1 n1 n2 dm
D2 n2 n3 dm
D3 n3 n4 dm
D4 n4 n5 dm
D5 n5 n6 dm
D6 n6 n7 dm
D7 n7 n8 dm
D8 n8 n9 dm
D9 n9 n10 dm
D10 n10 n11 dm
D11 n11 n12 dm
D12 n12 n13 dm
D13 n13 n14 dm
D14 n14 n15 dm
D15 n15 n16 dm
D16 n16 n17 dm
D17 n17 n18 dm
D18 n18 n19 dm
D19 n19 n20 dm
D20 n20 n21 dm
D21 n21 n22 dm
D22 n22 n23 dm
D23 n23 n24 dm
D24 n24 n25 dm
D25 n25 n26 dm
D26 n26 n27 dm
D27 n27 n28 dm
D28 n28 n29 dm
D29 n29 n30 dm
D30 n30 n31 dm
D31 n31 n32 dm
D32 n32 n33 dm
D33 n33 n34 dm
D34 n34 n35 dm
D35 n35 n36 dm
D36 n36 n37 dm
D37 n37 n38 dm
D38 n38 n39 dm
D39 n39 n40 dm
D40 n40 0 dm
.model dm d is=1e-14 n=1 rs=0.5 cjo=1p
.op
.end
