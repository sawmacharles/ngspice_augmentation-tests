* op_opamp2_ol: two-stage Miller CMOS opamp (BSIM3), open loop, inputs both at mid supply
* Hard for DC OP because: gain ~1e5 with no DC feedback: output must sit on a rail, the first stage a few mV from balance; tiny input changes move everything
* (card #637 corpus, generated by tools/gen_opcorpus.py -- edit the generator, not the deck)
Vdd vdd 0 1.8
Vp inp 0 0.9
Vn inn 0 0.9
Ib vdd bias 20u
Mb bias bias 0 0 nb3 w=4u l=0.5u
Mt tail bias 0 0 nb3 w=16u l=0.5u
M1 d1 inp tail 0 nb3 w=20u l=0.5u
M2 d2 inn tail 0 nb3 w=20u l=0.5u
M3 d1 d1 vdd vdd pb3 w=20u l=0.5u
M4 d2 d1 vdd vdd pb3 w=20u l=0.5u
M6 out d2 vdd vdd pb3 w=60u l=0.5u
M7 out bias 0 0 nb3 w=64u l=0.5u
Cc d2 out 1p
.model nb3 nmos level=8 version=3.3.0 tox=4.1e-9 vth0=0.45 k1=0.55 k2=0 u0=300 vsat=1.0e5
+ nch=1.7e17 xj=1.5e-7 pclm=1.2 rdsw=150 cgso=3e-10 cgdo=3e-10 cj=1e-3 mj=0.5 cjsw=2e-10 nfactor=1.2 voff=-0.1
.model pb3 pmos level=8 version=3.3.0 tox=4.1e-9 vth0=-0.45 k1=0.55 k2=0 u0=90 vsat=0.9e5
+ nch=1.7e17 xj=1.5e-7 pclm=1.2 rdsw=300 cgso=3e-10 cgdo=3e-10 cj=1e-3 mj=0.5 cjsw=2e-10 nfactor=1.2 voff=-0.1
.op
.end
