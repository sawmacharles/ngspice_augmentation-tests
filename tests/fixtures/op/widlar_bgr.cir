* op_widlar_bgr: Widlar-style PTAT bandgap: PNP mirror forcing equal currents into 8x and 1x NPNs (emitter resistor on the 8x), Vref = Vbe + I*R
* Hard for DC OP because: self-biased loop with a zero-current root; no startup circuit
* (card #637 corpus, generated by tools/gen_opcorpus.py -- edit the generator, not the deck)
Vcc vcc 0 5
Q3 c1 c1 vcc qp
Q4 c2 c1 vcc qp
Q5 vref c1 vcc qp
Q1 c1 c2 e1 qn area=8
Q2 c2 c2 0 qn
R1 e1 0 3k
R2 vref v6 5k
Q6 v6 v6 0 qn
.model qn npn is=1e-16 bf=150 br=2 vaf=80 var=15 ikf=5m ikr=1m rb=100 rbm=30 re=2 rc=30
+ cje=0.5p cjc=0.3p tf=20p ne=1.5 ise=1e-15 nc=2 isc=1e-14
.model qp pnp is=2e-16 bf=50 br=1 vaf=50 var=10 ikf=1m ikr=0.5m rb=200 rbm=60 re=5 rc=50
+ cje=0.8p cjc=0.5p tf=60p ne=1.5 ise=2e-15
.op
.end
