* op_translinear: translinear multiplier/divider: Iout = I1*I2/I3 with four NPNs, currents 1 uA..1 mA
* Hard for DC OP because: Vbe loop with exponentials; currents spanning decades; each current source forces a node with only exponential devices
* (card #637 corpus, generated by tools/gen_opcorpus.py -- edit the generator, not the deck)
Vcc vcc 0 5
I1 0 a DC 10u
I2 0 bb DC 100u
I3 0 x DC 1u
Q1 a a 0 qn
Q2 bb bb a qn
Q4 x x 0 qn
Q3 out bb x qn
Rl vcc out 1k
.model qn npn is=1e-16 bf=150 br=2 vaf=80 var=15 ikf=5m ikr=1m rb=100 rbm=30 re=2 rc=30
+ cje=0.5p cjc=0.3p tf=20p ne=1.5 ise=1e-15 nc=2 isc=1e-14
.op
.end
