* op_analog_block50: chain of 10 five-transistor OTAs wired as unity followers (50 BSIM4), random widths (seed 637)
* Hard for DC OP because: 50 transistors with ~1 mV-class stage gains cascaded by feedback inside each stage; moderate size, mixed regions, bias mirror from a current source
* (card #637 corpus, generated by tools/gen_opcorpus.py -- edit the generator, not the deck)
Vdd vdd 0 1.8
Vin in0 0 0.9
Ib vdd bias 20u
Mb bias bias 0 0 nb4 w=4u l=1u
Mt0 tl0 bias 0 0 nb4 w=5.2u l=1u
M1_0 d1_0 in0 tl0 0 nb4 w=9.9u l=0.36u
M2_0 o0 o0 tl0 0 nb4 w=9.9u l=0.36u
M3_0 d1_0 d1_0 vdd vdd pb4 w=12.3u l=0.36u
M4_0 o0 d1_0 vdd vdd pb4 w=12.3u l=0.36u
Mt1 tl1 bias 0 0 nb4 w=5.1u l=1u
M1_1 d1_1 o0 tl1 0 nb4 w=9.4u l=0.36u
M2_1 o1 o1 tl1 0 nb4 w=9.4u l=0.36u
M3_1 d1_1 d1_1 vdd vdd pb4 w=18.7u l=0.36u
M4_1 o1 d1_1 vdd vdd pb4 w=18.7u l=0.36u
Mt2 tl2 bias 0 0 nb4 w=10.2u l=1u
M1_2 d1_2 o1 tl2 0 nb4 w=12.6u l=0.36u
M2_2 o2 o2 tl2 0 nb4 w=12.6u l=0.36u
M3_2 d1_2 d1_2 vdd vdd pb4 w=8.6u l=0.36u
M4_2 o2 d1_2 vdd vdd pb4 w=8.6u l=0.36u
Mt3 tl3 bias 0 0 nb4 w=9.5u l=1u
M1_3 d1_3 o2 tl3 0 nb4 w=14.8u l=0.36u
M2_3 o3 o3 tl3 0 nb4 w=14.8u l=0.36u
M3_3 d1_3 d1_3 vdd vdd pb4 w=22.2u l=0.36u
M4_3 o3 d1_3 vdd vdd pb4 w=22.2u l=0.36u
Mt4 tl4 bias 0 0 nb4 w=7.1u l=1u
M1_4 d1_4 o3 tl4 0 nb4 w=7.1u l=0.36u
M2_4 o4 o4 tl4 0 nb4 w=7.1u l=0.36u
M3_4 d1_4 d1_4 vdd vdd pb4 w=15.6u l=0.36u
M4_4 o4 d1_4 vdd vdd pb4 w=15.6u l=0.36u
Mt5 tl5 bias 0 0 nb4 w=12.0u l=1u
M1_5 d1_5 o4 tl5 0 nb4 w=14.0u l=0.36u
M2_5 o5 o5 tl5 0 nb4 w=14.0u l=0.36u
M3_5 d1_5 d1_5 vdd vdd pb4 w=11.9u l=0.36u
M4_5 o5 d1_5 vdd vdd pb4 w=11.9u l=0.36u
Mt6 tl6 bias 0 0 nb4 w=11.7u l=1u
M1_6 d1_6 o5 tl6 0 nb4 w=10.2u l=0.36u
M2_6 o6 o6 tl6 0 nb4 w=10.2u l=0.36u
M3_6 d1_6 d1_6 vdd vdd pb4 w=22.6u l=0.36u
M4_6 o6 d1_6 vdd vdd pb4 w=22.6u l=0.36u
Mt7 tl7 bias 0 0 nb4 w=4.2u l=1u
M1_7 d1_7 o6 tl7 0 nb4 w=14.9u l=0.36u
M2_7 o7 o7 tl7 0 nb4 w=14.9u l=0.36u
M3_7 d1_7 d1_7 vdd vdd pb4 w=9.8u l=0.36u
M4_7 o7 d1_7 vdd vdd pb4 w=9.8u l=0.36u
Mt8 tl8 bias 0 0 nb4 w=6.2u l=1u
M1_8 d1_8 o7 tl8 0 nb4 w=7.6u l=0.36u
M2_8 o8 o8 tl8 0 nb4 w=7.6u l=0.36u
M3_8 d1_8 d1_8 vdd vdd pb4 w=10.3u l=0.36u
M4_8 o8 d1_8 vdd vdd pb4 w=10.3u l=0.36u
Mt9 tl9 bias 0 0 nb4 w=5.8u l=1u
M1_9 d1_9 o8 tl9 0 nb4 w=11.3u l=0.36u
M2_9 o9 o9 tl9 0 nb4 w=11.3u l=0.36u
M3_9 d1_9 d1_9 vdd vdd pb4 w=22.9u l=0.36u
M4_9 o9 d1_9 vdd vdd pb4 w=22.9u l=0.36u
.model nb4 nmos level=54 version=4.8.2
+ mobmod=0 capmod=0 igcmod=0 igbmod=0 rdsmod=0 rbodymod=0 rgatemod=0 acnqsmod=0
+ toxe=4e-9 toxp=4e-9 toxm=4e-9 vth0=0.45 k1=0.4 k2=0 k3=0 w0=2.5e-6 u0=300 vsat=1.1e5
+ cgso=2e-10 cgdo=2e-10 cgbo=0 cf=0 cjs=1e-4 cjd=1e-4 cjswd=1e-10 cjswgd=1e-10
.model pb4 pmos level=54 version=4.8.2
+ mobmod=0 capmod=0 igcmod=0 igbmod=0 rdsmod=0 rbodymod=0 rgatemod=0 acnqsmod=0
+ toxe=4e-9 toxp=4e-9 toxm=4e-9 vth0=-0.45 k1=0.4 k2=0 k3=0 w0=2.5e-6 u0=100 vsat=1.0e5
+ cgso=2e-10 cgdo=2e-10 cgbo=0 cf=0 cjs=1e-4 cjd=1e-4 cjswd=1e-10 cjswgd=1e-10
.op
.end
