* op_jfet_isrc: self-biased JFET current source: Rs from source to ground, gate grounded, drain on 15 V
* Hard for DC OP because: pinch-off nonlinearity with source degeneration; the zero-current point is a root only for Rs->inf, convergence depends on the vgs limiting
* (card #637 corpus, generated by tools/gen_opcorpus.py -- edit the generator, not the deck)
Vdd vdd 0 15
J1 d 0 s jn
Rs s 0 1k
Rd vdd d 2k
.model jn njf vto=-2.5 beta=1.5m lambda=0.02 rd=10 rs=10
.op
.end
