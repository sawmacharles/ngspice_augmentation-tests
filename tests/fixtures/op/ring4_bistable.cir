* op_ring4_bistable: 4-stage inverter ring (even): two stable states plus a metastable one
* Hard for DC OP because: positive-feedback loop of 4 high-gain stages; start from 0 sits on a symmetric point of the basin boundary
* (card #637 corpus, generated by tools/gen_opcorpus.py -- edit the generator, not the deck)
Vdd vdd 0 1.8
M1n s1 s0 0 0 n1 w=1u l=0.18u
M1p s1 s0 vdd vdd p1 w=2.5u l=0.18u
M2n s2 s1 0 0 n1 w=1u l=0.18u
M2p s2 s1 vdd vdd p1 w=2.5u l=0.18u
M3n s3 s2 0 0 n1 w=1u l=0.18u
M3p s3 s2 vdd vdd p1 w=2.5u l=0.18u
M4n s0 s3 0 0 n1 w=1u l=0.18u
M4p s0 s3 vdd vdd p1 w=2.5u l=0.18u
.model n1 nmos level=1 vto=0.5 kp=200u lambda=0.05 gamma=0.4 phi=0.7 cbd=5f cbs=5f
.model p1 pmos level=1 vto=-0.5 kp=70u lambda=0.06 gamma=0.4 phi=0.7 cbd=5f cbs=5f
.op
.end
