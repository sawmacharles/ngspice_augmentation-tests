* op_bsrc_exp: diode written as I = 1e-15*(exp(V/0.026)-1) in a B-source, fed from 5 V through 1 ohm, in series with a second exp device
* Hard for DC OP because: exp() of an unlimited voltage: first Newton step overshoots to thousands of volts unless damped (no pnjlim for B-sources)
* (card #637 corpus, generated by tools/gen_opcorpus.py -- edit the generator, not the deck)
V1 in 0 5
R1 in a 1
Bd1 a b I=1e-15*(exp((V(a)-V(b))/0.026)-1)
Bd2 b 0 I=1e-15*(exp(V(b)/0.026)-1)
.op
.end
