* op_tanh_hopfield14_g3: 14-unit Hopfield-style network of tanh B-sources (gain 3) with random +-1.5 couplings (seed 6371)
* Hard for DC OP because: dense recurrent tanh network: many fixed points, many saturated flat regions where the Newton derivative vanishes
* (card #637 corpus, generated by tools/gen_opcorpus.py -- edit the generator, not the deck)
Vb vb 0 0.1
Bh0 h0 0 V=tanh(3*(-1.446*V(h2)+0.326*V(h3)+-0.351*V(h4)+-0.307*V(h5)+0.148*V(h6)+0.486*V(h7)+0.245*V(h8)+0.449*V(h9)+1.209*V(h10)+0.693*V(h11)+-1.273*V(h12)+-0.952*V(h13)+-0.117))
Rh0 h0 0 1Meg
Bh1 h1 0 V=tanh(3*(-1.249*V(h0)+-0.208*V(h2)+-1.066*V(h3)+0.1*V(h4)+-1.496*V(h6)+-0.808*V(h7)+-0.964*V(h8)+0.405*V(h9)+0.346*V(h10)+-0.6*V(h13)+-0.095))
Rh1 h1 0 1Meg
Bh2 h2 0 V=tanh(3*(0.066*V(h3)+-0.152*V(h4)+-1.435*V(h6)+0.352*V(h7)+-0.947*V(h9)+0.931*V(h11)+1.27*V(h12)+0.175))
Rh2 h2 0 1Meg
Bh3 h3 0 V=tanh(3*(-1.26*V(h2)+0.358*V(h4)+1.337*V(h5)+1.386*V(h6)+1.463*V(h9)+-0.913*V(h11)+-0.688*V(h13)+0.014))
Rh3 h3 0 1Meg
Bh4 h4 0 V=tanh(3*(0.334*V(h1)+0.357*V(h2)+1.461*V(h5)+-0.933*V(h6)+0.405*V(h7)+0.42*V(h9)+-0.66*V(h10)+0.008))
Rh4 h4 0 1Meg
Bh5 h5 0 V=tanh(3*(-0.981*V(h1)+-0.004*V(h2)+-0.782*V(h8)+-0.432*V(h10)+0.625*V(h11)+-0.294*V(h12)+-0.193))
Rh5 h5 0 1Meg
Bh6 h6 0 V=tanh(3*(-1.404*V(h1)+0.781*V(h2)+1.134*V(h7)+-0.628*V(h9)+-1.341*V(h10)+-0.49*V(h11)+-0.324*V(h12)+1.019*V(h13)+0.078))
Rh6 h6 0 1Meg
Bh7 h7 0 V=tanh(3*(0.785*V(h1)+0.64*V(h6)+1.485*V(h8)+-0.722*V(h10)+0.884*V(h11)+-0.702*V(h12)+0.377*V(h13)+-0.115))
Rh7 h7 0 1Meg
Bh8 h8 0 V=tanh(3*(1.081*V(h1)+-0.845*V(h2)+-0.202*V(h3)+-0.323*V(h5)+-0.954*V(h6)+0.05*V(h7)+1.447*V(h10)+0.096))
Rh8 h8 0 1Meg
Bh9 h9 0 V=tanh(3*(-1.054*V(h3)+-0.116*V(h4)+0.078*V(h8)+0.464*V(h12)+-0.157))
Rh9 h9 0 1Meg
Bh10 h10 0 V=tanh(3*(0.29*V(h0)+-0.87*V(h1)+1.208*V(h4)+-1.107*V(h5)+0.175*V(h12)+0.206*V(h13)+-0.095))
Rh10 h10 0 1Meg
Bh11 h11 0 V=tanh(3*(-1.368*V(h0)+-0.776*V(h2)+0.263*V(h3)+0.395*V(h5)+1.182*V(h8)+0.044*V(h12)+-0.071))
Rh11 h11 0 1Meg
Bh12 h12 0 V=tanh(3*(-1.16*V(h1)+0.887*V(h3)+-0.174*V(h7)+-0.207*V(h9)+0.307*V(h10)+-0.255*V(h13)+0.035))
Rh12 h12 0 1Meg
Bh13 h13 0 V=tanh(3*(-0.962*V(h0)+0.368*V(h2)+1.082*V(h3)+-1.153*V(h5)+0.985*V(h7)+-0.196))
Rh13 h13 0 1Meg
.op
.end
