* op_bjt_exp_loop: BJT stage whose base current is a B-source exp() of the input voltage (times a (1+V(b)) factor), 5 V rail
* Hard for DC OP because: unlimited exp() in the base drive on top of a limited BJT junction; the two exponentials multiply
* (card #637 corpus, generated by tools/gen_opcorpus.py -- edit the generator, not the deck)
Vcc vcc 0 5
Vin in 0 0.5
Bb vcc b I=1e-12*(exp(V(in)/0.0259)-1)*(1+V(b))
Rb b e1 10
Q1 c1 b e1 qn
Rc vcc c1 100
Re e1 0 10
Ce c1 0 1p
.model qn npn is=1e-16 bf=150 br=2 vaf=80 var=15 ikf=5m ikr=1m rb=100 rbm=30 re=2 rc=30
+ cje=0.5p cjc=0.3p tf=20p ne=1.5 ise=1e-15 nc=2 isc=1e-14
.op
.end
