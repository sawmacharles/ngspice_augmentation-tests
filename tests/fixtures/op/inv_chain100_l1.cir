* op_inv_chain100_l1: 100-stage CMOS inverter chain (level 1, lambda 0.05), input near the trip point
* Hard for DC OP because: level-1 inverters have a steep transfer and no leakage; 100 stages give ~1e100 gain and 100 coupled switching points
* (card #637 corpus, generated by tools/gen_opcorpus.py -- edit the generator, not the deck)
Vdd vdd 0 1.8
Vin s0 0 0.82
M1n s1 s0 0 0 n1 w=1u l=0.18u
M1p s1 s0 vdd vdd p1 w=2.5u l=0.18u
M2n s2 s1 0 0 n1 w=1u l=0.18u
M2p s2 s1 vdd vdd p1 w=2.5u l=0.18u
M3n s3 s2 0 0 n1 w=1u l=0.18u
M3p s3 s2 vdd vdd p1 w=2.5u l=0.18u
M4n s4 s3 0 0 n1 w=1u l=0.18u
M4p s4 s3 vdd vdd p1 w=2.5u l=0.18u
M5n s5 s4 0 0 n1 w=1u l=0.18u
M5p s5 s4 vdd vdd p1 w=2.5u l=0.18u
M6n s6 s5 0 0 n1 w=1u l=0.18u
M6p s6 s5 vdd vdd p1 w=2.5u l=0.18u
M7n s7 s6 0 0 n1 w=1u l=0.18u
M7p s7 s6 vdd vdd p1 w=2.5u l=0.18u
M8n s8 s7 0 0 n1 w=1u l=0.18u
M8p s8 s7 vdd vdd p1 w=2.5u l=0.18u
M9n s9 s8 0 0 n1 w=1u l=0.18u
M9p s9 s8 vdd vdd p1 w=2.5u l=0.18u
M10n s10 s9 0 0 n1 w=1u l=0.18u
M10p s10 s9 vdd vdd p1 w=2.5u l=0.18u
M11n s11 s10 0 0 n1 w=1u l=0.18u
M11p s11 s10 vdd vdd p1 w=2.5u l=0.18u
M12n s12 s11 0 0 n1 w=1u l=0.18u
M12p s12 s11 vdd vdd p1 w=2.5u l=0.18u
M13n s13 s12 0 0 n1 w=1u l=0.18u
M13p s13 s12 vdd vdd p1 w=2.5u l=0.18u
M14n s14 s13 0 0 n1 w=1u l=0.18u
M14p s14 s13 vdd vdd p1 w=2.5u l=0.18u
M15n s15 s14 0 0 n1 w=1u l=0.18u
M15p s15 s14 vdd vdd p1 w=2.5u l=0.18u
M16n s16 s15 0 0 n1 w=1u l=0.18u
M16p s16 s15 vdd vdd p1 w=2.5u l=0.18u
M17n s17 s16 0 0 n1 w=1u l=0.18u
M17p s17 s16 vdd vdd p1 w=2.5u l=0.18u
M18n s18 s17 0 0 n1 w=1u l=0.18u
M18p s18 s17 vdd vdd p1 w=2.5u l=0.18u
M19n s19 s18 0 0 n1 w=1u l=0.18u
M19p s19 s18 vdd vdd p1 w=2.5u l=0.18u
M20n s20 s19 0 0 n1 w=1u l=0.18u
M20p s20 s19 vdd vdd p1 w=2.5u l=0.18u
M21n s21 s20 0 0 n1 w=1u l=0.18u
M21p s21 s20 vdd vdd p1 w=2.5u l=0.18u
M22n s22 s21 0 0 n1 w=1u l=0.18u
M22p s22 s21 vdd vdd p1 w=2.5u l=0.18u
M23n s23 s22 0 0 n1 w=1u l=0.18u
M23p s23 s22 vdd vdd p1 w=2.5u l=0.18u
M24n s24 s23 0 0 n1 w=1u l=0.18u
M24p s24 s23 vdd vdd p1 w=2.5u l=0.18u
M25n s25 s24 0 0 n1 w=1u l=0.18u
M25p s25 s24 vdd vdd p1 w=2.5u l=0.18u
M26n s26 s25 0 0 n1 w=1u l=0.18u
M26p s26 s25 vdd vdd p1 w=2.5u l=0.18u
M27n s27 s26 0 0 n1 w=1u l=0.18u
M27p s27 s26 vdd vdd p1 w=2.5u l=0.18u
M28n s28 s27 0 0 n1 w=1u l=0.18u
M28p s28 s27 vdd vdd p1 w=2.5u l=0.18u
M29n s29 s28 0 0 n1 w=1u l=0.18u
M29p s29 s28 vdd vdd p1 w=2.5u l=0.18u
M30n s30 s29 0 0 n1 w=1u l=0.18u
M30p s30 s29 vdd vdd p1 w=2.5u l=0.18u
M31n s31 s30 0 0 n1 w=1u l=0.18u
M31p s31 s30 vdd vdd p1 w=2.5u l=0.18u
M32n s32 s31 0 0 n1 w=1u l=0.18u
M32p s32 s31 vdd vdd p1 w=2.5u l=0.18u
M33n s33 s32 0 0 n1 w=1u l=0.18u
M33p s33 s32 vdd vdd p1 w=2.5u l=0.18u
M34n s34 s33 0 0 n1 w=1u l=0.18u
M34p s34 s33 vdd vdd p1 w=2.5u l=0.18u
M35n s35 s34 0 0 n1 w=1u l=0.18u
M35p s35 s34 vdd vdd p1 w=2.5u l=0.18u
M36n s36 s35 0 0 n1 w=1u l=0.18u
M36p s36 s35 vdd vdd p1 w=2.5u l=0.18u
M37n s37 s36 0 0 n1 w=1u l=0.18u
M37p s37 s36 vdd vdd p1 w=2.5u l=0.18u
M38n s38 s37 0 0 n1 w=1u l=0.18u
M38p s38 s37 vdd vdd p1 w=2.5u l=0.18u
M39n s39 s38 0 0 n1 w=1u l=0.18u
M39p s39 s38 vdd vdd p1 w=2.5u l=0.18u
M40n s40 s39 0 0 n1 w=1u l=0.18u
M40p s40 s39 vdd vdd p1 w=2.5u l=0.18u
M41n s41 s40 0 0 n1 w=1u l=0.18u
M41p s41 s40 vdd vdd p1 w=2.5u l=0.18u
M42n s42 s41 0 0 n1 w=1u l=0.18u
M42p s42 s41 vdd vdd p1 w=2.5u l=0.18u
M43n s43 s42 0 0 n1 w=1u l=0.18u
M43p s43 s42 vdd vdd p1 w=2.5u l=0.18u
M44n s44 s43 0 0 n1 w=1u l=0.18u
M44p s44 s43 vdd vdd p1 w=2.5u l=0.18u
M45n s45 s44 0 0 n1 w=1u l=0.18u
M45p s45 s44 vdd vdd p1 w=2.5u l=0.18u
M46n s46 s45 0 0 n1 w=1u l=0.18u
M46p s46 s45 vdd vdd p1 w=2.5u l=0.18u
M47n s47 s46 0 0 n1 w=1u l=0.18u
M47p s47 s46 vdd vdd p1 w=2.5u l=0.18u
M48n s48 s47 0 0 n1 w=1u l=0.18u
M48p s48 s47 vdd vdd p1 w=2.5u l=0.18u
M49n s49 s48 0 0 n1 w=1u l=0.18u
M49p s49 s48 vdd vdd p1 w=2.5u l=0.18u
M50n s50 s49 0 0 n1 w=1u l=0.18u
M50p s50 s49 vdd vdd p1 w=2.5u l=0.18u
M51n s51 s50 0 0 n1 w=1u l=0.18u
M51p s51 s50 vdd vdd p1 w=2.5u l=0.18u
M52n s52 s51 0 0 n1 w=1u l=0.18u
M52p s52 s51 vdd vdd p1 w=2.5u l=0.18u
M53n s53 s52 0 0 n1 w=1u l=0.18u
M53p s53 s52 vdd vdd p1 w=2.5u l=0.18u
M54n s54 s53 0 0 n1 w=1u l=0.18u
M54p s54 s53 vdd vdd p1 w=2.5u l=0.18u
M55n s55 s54 0 0 n1 w=1u l=0.18u
M55p s55 s54 vdd vdd p1 w=2.5u l=0.18u
M56n s56 s55 0 0 n1 w=1u l=0.18u
M56p s56 s55 vdd vdd p1 w=2.5u l=0.18u
M57n s57 s56 0 0 n1 w=1u l=0.18u
M57p s57 s56 vdd vdd p1 w=2.5u l=0.18u
M58n s58 s57 0 0 n1 w=1u l=0.18u
M58p s58 s57 vdd vdd p1 w=2.5u l=0.18u
M59n s59 s58 0 0 n1 w=1u l=0.18u
M59p s59 s58 vdd vdd p1 w=2.5u l=0.18u
M60n s60 s59 0 0 n1 w=1u l=0.18u
M60p s60 s59 vdd vdd p1 w=2.5u l=0.18u
M61n s61 s60 0 0 n1 w=1u l=0.18u
M61p s61 s60 vdd vdd p1 w=2.5u l=0.18u
M62n s62 s61 0 0 n1 w=1u l=0.18u
M62p s62 s61 vdd vdd p1 w=2.5u l=0.18u
M63n s63 s62 0 0 n1 w=1u l=0.18u
M63p s63 s62 vdd vdd p1 w=2.5u l=0.18u
M64n s64 s63 0 0 n1 w=1u l=0.18u
M64p s64 s63 vdd vdd p1 w=2.5u l=0.18u
M65n s65 s64 0 0 n1 w=1u l=0.18u
M65p s65 s64 vdd vdd p1 w=2.5u l=0.18u
M66n s66 s65 0 0 n1 w=1u l=0.18u
M66p s66 s65 vdd vdd p1 w=2.5u l=0.18u
M67n s67 s66 0 0 n1 w=1u l=0.18u
M67p s67 s66 vdd vdd p1 w=2.5u l=0.18u
M68n s68 s67 0 0 n1 w=1u l=0.18u
M68p s68 s67 vdd vdd p1 w=2.5u l=0.18u
M69n s69 s68 0 0 n1 w=1u l=0.18u
M69p s69 s68 vdd vdd p1 w=2.5u l=0.18u
M70n s70 s69 0 0 n1 w=1u l=0.18u
M70p s70 s69 vdd vdd p1 w=2.5u l=0.18u
M71n s71 s70 0 0 n1 w=1u l=0.18u
M71p s71 s70 vdd vdd p1 w=2.5u l=0.18u
M72n s72 s71 0 0 n1 w=1u l=0.18u
M72p s72 s71 vdd vdd p1 w=2.5u l=0.18u
M73n s73 s72 0 0 n1 w=1u l=0.18u
M73p s73 s72 vdd vdd p1 w=2.5u l=0.18u
M74n s74 s73 0 0 n1 w=1u l=0.18u
M74p s74 s73 vdd vdd p1 w=2.5u l=0.18u
M75n s75 s74 0 0 n1 w=1u l=0.18u
M75p s75 s74 vdd vdd p1 w=2.5u l=0.18u
M76n s76 s75 0 0 n1 w=1u l=0.18u
M76p s76 s75 vdd vdd p1 w=2.5u l=0.18u
M77n s77 s76 0 0 n1 w=1u l=0.18u
M77p s77 s76 vdd vdd p1 w=2.5u l=0.18u
M78n s78 s77 0 0 n1 w=1u l=0.18u
M78p s78 s77 vdd vdd p1 w=2.5u l=0.18u
M79n s79 s78 0 0 n1 w=1u l=0.18u
M79p s79 s78 vdd vdd p1 w=2.5u l=0.18u
M80n s80 s79 0 0 n1 w=1u l=0.18u
M80p s80 s79 vdd vdd p1 w=2.5u l=0.18u
M81n s81 s80 0 0 n1 w=1u l=0.18u
M81p s81 s80 vdd vdd p1 w=2.5u l=0.18u
M82n s82 s81 0 0 n1 w=1u l=0.18u
M82p s82 s81 vdd vdd p1 w=2.5u l=0.18u
M83n s83 s82 0 0 n1 w=1u l=0.18u
M83p s83 s82 vdd vdd p1 w=2.5u l=0.18u
M84n s84 s83 0 0 n1 w=1u l=0.18u
M84p s84 s83 vdd vdd p1 w=2.5u l=0.18u
M85n s85 s84 0 0 n1 w=1u l=0.18u
M85p s85 s84 vdd vdd p1 w=2.5u l=0.18u
M86n s86 s85 0 0 n1 w=1u l=0.18u
M86p s86 s85 vdd vdd p1 w=2.5u l=0.18u
M87n s87 s86 0 0 n1 w=1u l=0.18u
M87p s87 s86 vdd vdd p1 w=2.5u l=0.18u
M88n s88 s87 0 0 n1 w=1u l=0.18u
M88p s88 s87 vdd vdd p1 w=2.5u l=0.18u
M89n s89 s88 0 0 n1 w=1u l=0.18u
M89p s89 s88 vdd vdd p1 w=2.5u l=0.18u
M90n s90 s89 0 0 n1 w=1u l=0.18u
M90p s90 s89 vdd vdd p1 w=2.5u l=0.18u
M91n s91 s90 0 0 n1 w=1u l=0.18u
M91p s91 s90 vdd vdd p1 w=2.5u l=0.18u
M92n s92 s91 0 0 n1 w=1u l=0.18u
M92p s92 s91 vdd vdd p1 w=2.5u l=0.18u
M93n s93 s92 0 0 n1 w=1u l=0.18u
M93p s93 s92 vdd vdd p1 w=2.5u l=0.18u
M94n s94 s93 0 0 n1 w=1u l=0.18u
M94p s94 s93 vdd vdd p1 w=2.5u l=0.18u
M95n s95 s94 0 0 n1 w=1u l=0.18u
M95p s95 s94 vdd vdd p1 w=2.5u l=0.18u
M96n s96 s95 0 0 n1 w=1u l=0.18u
M96p s96 s95 vdd vdd p1 w=2.5u l=0.18u
M97n s97 s96 0 0 n1 w=1u l=0.18u
M97p s97 s96 vdd vdd p1 w=2.5u l=0.18u
M98n s98 s97 0 0 n1 w=1u l=0.18u
M98p s98 s97 vdd vdd p1 w=2.5u l=0.18u
M99n s99 s98 0 0 n1 w=1u l=0.18u
M99p s99 s98 vdd vdd p1 w=2.5u l=0.18u
M100n s100 s99 0 0 n1 w=1u l=0.18u
M100p s100 s99 vdd vdd p1 w=2.5u l=0.18u
Rld s100 0 1Meg
.model n1 nmos level=1 vto=0.5 kp=200u lambda=0.05 gamma=0.4 phi=0.7 cbd=5f cbs=5f
.model p1 pmos level=1 vto=-0.5 kp=70u lambda=0.06 gamma=0.4 phi=0.7 cbd=5f cbs=5f
.op
.end
