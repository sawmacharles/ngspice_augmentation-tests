* op_bsrc_tanh_loop3: three cascaded tanh stages (gain 100 each) with global negative feedback
* Hard for DC OP because: three saturating stages in a loop with a total gain of 1e6; each stage clamps at +-3 V and the root is at the intersection of three linear windows
* (card #637 corpus, generated by tools/gen_opcorpus.py -- edit the generator, not the deck)
Vref ref 0 1
Bs1 a 0 V=3*tanh(100*(V(ref)-0.5*V(c)))
Bs2 b 0 V=3*tanh(100*V(a))
Bs3 c 0 V=3*tanh(100*V(b))
Ra a 0 1Meg
Rb b 0 1Meg
Rc c 0 1Meg
.op
.end
