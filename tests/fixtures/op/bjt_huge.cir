* op_bjt_huge: NPN with area=1e6 forced to Vbe=0.95 V through 20 ohm, collector 5 V through 0.5 ohm
* Hard for DC OP because: device currents of ~1e5 A at the limit of the exponent; saturation with huge amps; junction limiting and gmin have to cooperate
* (card #637 corpus, generated by tools/gen_opcorpus.py -- edit the generator, not the deck)
Vc vcc 0 5
Rc vcc c 0.5
Vb vb 0 0.95
Rb vb b 20
Q1 c b 0 qn area=1e6
.model qn npn is=1e-16 bf=150 br=2 vaf=80 var=15 ikf=5m ikr=1m rb=100 rbm=30 re=2 rc=30
+ cje=0.5p cjc=0.3p tf=20p ne=1.5 ise=1e-15 nc=2 isc=1e-14
.op
.end
