* op_folded_cascode_ol: folded-cascode OTA (BSIM4) open loop, inputs at mid supply
* Hard for DC OP because: four stacked devices per branch, cascode bias voltages from ideal sources; output impedance ~Mohm so a few mV of input offset saturates
* (card #637 corpus, generated by tools/gen_opcorpus.py -- edit the generator, not the deck)
Vdd vdd 0 1.8
Vp inp 0 0.9
Vn inn 0 0.9
Vbc1 vbc1 0 0.95
Vbp vbp 0 1.05
Vbc2 vbc2 0 0.85
Mt0 tail vbt 0 0 nb4 w=20u l=1u
Vbt vbt 0 0.62
M1 f1 inp tail 0 nb4 w=20u l=0.36u
M2 f2 inn tail 0 nb4 w=20u l=0.36u
Mp1 f1 vbp vdd vdd pb4 w=40u l=1u
Mp2 f2 vbp vdd vdd pb4 w=40u l=1u
Mc1 o1 vbc1 f1 vdd pb4 w=40u l=0.36u
Mc2 out vbc1 f2 vdd pb4 w=40u l=0.36u
Mn1 m1 vbc2 o1 0 nb4 w=20u l=0.36u
Mn2 m2 vbc2 out 0 nb4 w=20u l=0.36u
Ms1 m1 o1 0 0 nb4 w=10u l=1u
Ms2 m2 o1 0 0 nb4 w=10u l=1u
.model nb4 nmos level=54 version=4.8.2
+ mobmod=0 capmod=0 igcmod=0 igbmod=0 rdsmod=0 rbodymod=0 rgatemod=0 acnqsmod=0
+ toxe=4e-9 toxp=4e-9 toxm=4e-9 vth0=0.45 k1=0.4 k2=0 k3=0 w0=2.5e-6 u0=300 vsat=1.1e5
+ cgso=2e-10 cgdo=2e-10 cgbo=0 cf=0 cjs=1e-4 cjd=1e-4 cjswd=1e-10 cjswgd=1e-10
.model pb4 pmos level=54 version=4.8.2
+ mobmod=0 capmod=0 igcmod=0 igbmod=0 rdsmod=0 rbodymod=0 rgatemod=0 acnqsmod=0
+ toxe=4e-9 toxp=4e-9 toxm=4e-9 vth0=-0.45 k1=0.4 k2=0 k3=0 w0=2.5e-6 u0=100 vsat=1.0e5
+ cgso=2e-10 cgdo=2e-10 cgbo=0 cf=0 cjs=1e-4 cjd=1e-4 cjswd=1e-10 cjswgd=1e-10
.op
.end
