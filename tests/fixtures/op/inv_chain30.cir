* op_inv_chain30: 30-stage CMOS inverter chain (level 3), input parked near the first stage's switching point
* Hard for DC OP because: end-to-end small-signal gain is astronomically high (30 stages of ~10x); a 1 mV change at the input rewrites the pattern of rails
* (card #637 corpus, generated by tools/gen_opcorpus.py -- edit the generator, not the deck)
Vdd vdd 0 1.8
Vin s0 0 0.82
M1n s1 s0 0 0 n3 w=1u l=0.35u
M1p s1 s0 vdd vdd p3 w=2.5u l=0.35u
M2n s2 s1 0 0 n3 w=1u l=0.35u
M2p s2 s1 vdd vdd p3 w=2.5u l=0.35u
M3n s3 s2 0 0 n3 w=1u l=0.35u
M3p s3 s2 vdd vdd p3 w=2.5u l=0.35u
M4n s4 s3 0 0 n3 w=1u l=0.35u
M4p s4 s3 vdd vdd p3 w=2.5u l=0.35u
M5n s5 s4 0 0 n3 w=1u l=0.35u
M5p s5 s4 vdd vdd p3 w=2.5u l=0.35u
M6n s6 s5 0 0 n3 w=1u l=0.35u
M6p s6 s5 vdd vdd p3 w=2.5u l=0.35u
M7n s7 s6 0 0 n3 w=1u l=0.35u
M7p s7 s6 vdd vdd p3 w=2.5u l=0.35u
M8n s8 s7 0 0 n3 w=1u l=0.35u
M8p s8 s7 vdd vdd p3 w=2.5u l=0.35u
M9n s9 s8 0 0 n3 w=1u l=0.35u
M9p s9 s8 vdd vdd p3 w=2.5u l=0.35u
M10n s10 s9 0 0 n3 w=1u l=0.35u
M10p s10 s9 vdd vdd p3 w=2.5u l=0.35u
M11n s11 s10 0 0 n3 w=1u l=0.35u
M11p s11 s10 vdd vdd p3 w=2.5u l=0.35u
M12n s12 s11 0 0 n3 w=1u l=0.35u
M12p s12 s11 vdd vdd p3 w=2.5u l=0.35u
M13n s13 s12 0 0 n3 w=1u l=0.35u
M13p s13 s12 vdd vdd p3 w=2.5u l=0.35u
M14n s14 s13 0 0 n3 w=1u l=0.35u
M14p s14 s13 vdd vdd p3 w=2.5u l=0.35u
M15n s15 s14 0 0 n3 w=1u l=0.35u
M15p s15 s14 vdd vdd p3 w=2.5u l=0.35u
M16n s16 s15 0 0 n3 w=1u l=0.35u
M16p s16 s15 vdd vdd p3 w=2.5u l=0.35u
M17n s17 s16 0 0 n3 w=1u l=0.35u
M17p s17 s16 vdd vdd p3 w=2.5u l=0.35u
M18n s18 s17 0 0 n3 w=1u l=0.35u
M18p s18 s17 vdd vdd p3 w=2.5u l=0.35u
M19n s19 s18 0 0 n3 w=1u l=0.35u
M19p s19 s18 vdd vdd p3 w=2.5u l=0.35u
M20n s20 s19 0 0 n3 w=1u l=0.35u
M20p s20 s19 vdd vdd p3 w=2.5u l=0.35u
M21n s21 s20 0 0 n3 w=1u l=0.35u
M21p s21 s20 vdd vdd p3 w=2.5u l=0.35u
M22n s22 s21 0 0 n3 w=1u l=0.35u
M22p s22 s21 vdd vdd p3 w=2.5u l=0.35u
M23n s23 s22 0 0 n3 w=1u l=0.35u
M23p s23 s22 vdd vdd p3 w=2.5u l=0.35u
M24n s24 s23 0 0 n3 w=1u l=0.35u
M24p s24 s23 vdd vdd p3 w=2.5u l=0.35u
M25n s25 s24 0 0 n3 w=1u l=0.35u
M25p s25 s24 vdd vdd p3 w=2.5u l=0.35u
M26n s26 s25 0 0 n3 w=1u l=0.35u
M26p s26 s25 vdd vdd p3 w=2.5u l=0.35u
M27n s27 s26 0 0 n3 w=1u l=0.35u
M27p s27 s26 vdd vdd p3 w=2.5u l=0.35u
M28n s28 s27 0 0 n3 w=1u l=0.35u
M28p s28 s27 vdd vdd p3 w=2.5u l=0.35u
M29n s29 s28 0 0 n3 w=1u l=0.35u
M29p s29 s28 vdd vdd p3 w=2.5u l=0.35u
M30n s30 s29 0 0 n3 w=1u l=0.35u
M30p s30 s29 vdd vdd p3 w=2.5u l=0.35u
Rld s30 0 1Meg
.model n3 nmos level=3 vto=0.5 uo=400 tox=4e-9 theta=0.15 vmax=1.5e5 eta=0.02 kappa=0.1
+ gamma=0.5 phi=0.8 nsub=3e17 xj=0.15u ld=0.02u cgso=3e-10 cgdo=3e-10 cj=1e-3 mj=0.5 cjsw=2e-10
.model p3 pmos level=3 vto=-0.5 uo=130 tox=4e-9 theta=0.15 vmax=1.0e5 eta=0.02 kappa=0.1
+ gamma=0.5 phi=0.8 nsub=3e17 xj=0.15u ld=0.02u cgso=3e-10 cgdo=3e-10 cj=1e-3 mj=0.5 cjsw=2e-10
.op
.end
