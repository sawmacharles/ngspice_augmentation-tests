* op_schmitt_bjt: emitter-coupled Schmitt trigger, input parked inside the hysteresis window
* Hard for DC OP because: two stable states plus an unstable one at the same input voltage; high loop gain around the common emitter
* (card #637 corpus, generated by tools/gen_opcorpus.py -- edit the generator, not the deck)
Vcc vcc 0 12
Vin in 0 3.6
Rc1 vcc c1 1.5k
Rc2 vcc c2 1k
R1 c1 b2 4.7k
R2 b2 0 8.2k
Re e 0 470
Q1 c1 in e qn
Q2 c2 b2 e qn
.model qn npn is=1e-16 bf=150 br=2 vaf=80 var=15 ikf=5m ikr=1m rb=100 rbm=30 re=2 rc=30
+ cje=0.5p cjc=0.3p tf=20p ne=1.5 ise=1e-15 nc=2 isc=1e-14
.op
.end
