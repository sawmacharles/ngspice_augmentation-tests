* op_mesh16: 16x16 resistive mesh (100 ohm links), a diode to ground at every node, fed by 5 V through 10 ohm at one corner
* Hard for DC OP because: 256 exponential junctions all start at 0 and are pulled ~10 mA-class by one corner; propagation of voltage through the mesh needs many Newton steps (limiting is per-device)
* (card #637 corpus, generated by tools/gen_opcorpus.py -- edit the generator, not the deck)
Vs top 0 5
Rs top m0_0 10
Rh0_0 m0_0 m0_1 100
Rv0_0 m0_0 m1_0 100
D0_0 m0_0 0 dm
Rh0_1 m0_1 m0_2 100
Rv0_1 m0_1 m1_1 100
D0_1 m0_1 0 dm
Rh0_2 m0_2 m0_3 100
Rv0_2 m0_2 m1_2 100
D0_2 m0_2 0 dm
Rh0_3 m0_3 m0_4 100
Rv0_3 m0_3 m1_3 100
D0_3 m0_3 0 dm
Rh0_4 m0_4 m0_5 100
Rv0_4 m0_4 m1_4 100
D0_4 m0_4 0 dm
Rh0_5 m0_5 m0_6 100
Rv0_5 m0_5 m1_5 100
D0_5 m0_5 0 dm
Rh0_6 m0_6 m0_7 100
Rv0_6 m0_6 m1_6 100
D0_6 m0_6 0 dm
Rh0_7 m0_7 m0_8 100
Rv0_7 m0_7 m1_7 100
D0_7 m0_7 0 dm
Rh0_8 m0_8 m0_9 100
Rv0_8 m0_8 m1_8 100
D0_8 m0_8 0 dm
Rh0_9 m0_9 m0_10 100
Rv0_9 m0_9 m1_9 100
D0_9 m0_9 0 dm
Rh0_10 m0_10 m0_11 100
Rv0_10 m0_10 m1_10 100
D0_10 m0_10 0 dm
Rh0_11 m0_11 m0_12 100
Rv0_11 m0_11 m1_11 100
D0_11 m0_11 0 dm
Rh0_12 m0_12 m0_13 100
Rv0_12 m0_12 m1_12 100
D0_12 m0_12 0 dm
Rh0_13 m0_13 m0_14 100
Rv0_13 m0_13 m1_13 100
D0_13 m0_13 0 dm
Rh0_14 m0_14 m0_15 100
Rv0_14 m0_14 m1_14 100
D0_14 m0_14 0 dm
Rv0_15 m0_15 m1_15 100
D0_15 m0_15 0 dm
Rh1_0 m1_0 m1_1 100
Rv1_0 m1_0 m2_0 100
D1_0 m1_0 0 dm
Rh1_1 m1_1 m1_2 100
Rv1_1 m1_1 m2_1 100
D1_1 m1_1 0 dm
Rh1_2 m1_2 m1_3 100
Rv1_2 m1_2 m2_2 100
D1_2 m1_2 0 dm
Rh1_3 m1_3 m1_4 100
Rv1_3 m1_3 m2_3 100
D1_3 m1_3 0 dm
Rh1_4 m1_4 m1_5 100
Rv1_4 m1_4 m2_4 100
D1_4 m1_4 0 dm
Rh1_5 m1_5 m1_6 100
Rv1_5 m1_5 m2_5 100
D1_5 m1_5 0 dm
Rh1_6 m1_6 m1_7 100
Rv1_6 m1_6 m2_6 100
D1_6 m1_6 0 dm
Rh1_7 m1_7 m1_8 100
Rv1_7 m1_7 m2_7 100
D1_7 m1_7 0 dm
Rh1_8 m1_8 m1_9 100
Rv1_8 m1_8 m2_8 100
D1_8 m1_8 0 dm
Rh1_9 m1_9 m1_10 100
Rv1_9 m1_9 m2_9 100
D1_9 m1_9 0 dm
Rh1_10 m1_10 m1_11 100
Rv1_10 m1_10 m2_10 100
D1_10 m1_10 0 dm
Rh1_11 m1_11 m1_12 100
Rv1_11 m1_11 m2_11 100
D1_11 m1_11 0 dm
Rh1_12 m1_12 m1_13 100
Rv1_12 m1_12 m2_12 100
D1_12 m1_12 0 dm
Rh1_13 m1_13 m1_14 100
Rv1_13 m1_13 m2_13 100
D1_13 m1_13 0 dm
Rh1_14 m1_14 m1_15 100
Rv1_14 m1_14 m2_14 100
D1_14 m1_14 0 dm
Rv1_15 m1_15 m2_15 100
D1_15 m1_15 0 dm
Rh2_0 m2_0 m2_1 100
Rv2_0 m2_0 m3_0 100
D2_0 m2_0 0 dm
Rh2_1 m2_1 m2_2 100
Rv2_1 m2_1 m3_1 100
D2_1 m2_1 0 dm
Rh2_2 m2_2 m2_3 100
Rv2_2 m2_2 m3_2 100
D2_2 m2_2 0 dm
Rh2_3 m2_3 m2_4 100
Rv2_3 m2_3 m3_3 100
D2_3 m2_3 0 dm
Rh2_4 m2_4 m2_5 100
Rv2_4 m2_4 m3_4 100
D2_4 m2_4 0 dm
Rh2_5 m2_5 m2_6 100
Rv2_5 m2_5 m3_5 100
D2_5 m2_5 0 dm
Rh2_6 m2_6 m2_7 100
Rv2_6 m2_6 m3_6 100
D2_6 m2_6 0 dm
Rh2_7 m2_7 m2_8 100
Rv2_7 m2_7 m3_7 100
D2_7 m2_7 0 dm
Rh2_8 m2_8 m2_9 100
Rv2_8 m2_8 m3_8 100
D2_8 m2_8 0 dm
Rh2_9 m2_9 m2_10 100
Rv2_9 m2_9 m3_9 100
D2_9 m2_9 0 dm
Rh2_10 m2_10 m2_11 100
Rv2_10 m2_10 m3_10 100
D2_10 m2_10 0 dm
Rh2_11 m2_11 m2_12 100
Rv2_11 m2_11 m3_11 100
D2_11 m2_11 0 dm
Rh2_12 m2_12 m2_13 100
Rv2_12 m2_12 m3_12 100
D2_12 m2_12 0 dm
Rh2_13 m2_13 m2_14 100
Rv2_13 m2_13 m3_13 100
D2_13 m2_13 0 dm
Rh2_14 m2_14 m2_15 100
Rv2_14 m2_14 m3_14 100
D2_14 m2_14 0 dm
Rv2_15 m2_15 m3_15 100
D2_15 m2_15 0 dm
Rh3_0 m3_0 m3_1 100
Rv3_0 m3_0 m4_0 100
D3_0 m3_0 0 dm
Rh3_1 m3_1 m3_2 100
Rv3_1 m3_1 m4_1 100
D3_1 m3_1 0 dm
Rh3_2 m3_2 m3_3 100
Rv3_2 m3_2 m4_2 100
D3_2 m3_2 0 dm
Rh3_3 m3_3 m3_4 100
Rv3_3 m3_3 m4_3 100
D3_3 m3_3 0 dm
Rh3_4 m3_4 m3_5 100
Rv3_4 m3_4 m4_4 100
D3_4 m3_4 0 dm
Rh3_5 m3_5 m3_6 100
Rv3_5 m3_5 m4_5 100
D3_5 m3_5 0 dm
Rh3_6 m3_6 m3_7 100
Rv3_6 m3_6 m4_6 100
D3_6 m3_6 0 dm
Rh3_7 m3_7 m3_8 100
Rv3_7 m3_7 m4_7 100
D3_7 m3_7 0 dm
Rh3_8 m3_8 m3_9 100
Rv3_8 m3_8 m4_8 100
D3_8 m3_8 0 dm
Rh3_9 m3_9 m3_10 100
Rv3_9 m3_9 m4_9 100
D3_9 m3_9 0 dm
Rh3_10 m3_10 m3_11 100
Rv3_10 m3_10 m4_10 100
D3_10 m3_10 0 dm
Rh3_11 m3_11 m3_12 100
Rv3_11 m3_11 m4_11 100
D3_11 m3_11 0 dm
Rh3_12 m3_12 m3_13 100
Rv3_12 m3_12 m4_12 100
D3_12 m3_12 0 dm
Rh3_13 m3_13 m3_14 100
Rv3_13 m3_13 m4_13 100
D3_13 m3_13 0 dm
Rh3_14 m3_14 m3_15 100
Rv3_14 m3_14 m4_14 100
D3_14 m3_14 0 dm
Rv3_15 m3_15 m4_15 100
D3_15 m3_15 0 dm
Rh4_0 m4_0 m4_1 100
Rv4_0 m4_0 m5_0 100
D4_0 m4_0 0 dm
Rh4_1 m4_1 m4_2 100
Rv4_1 m4_1 m5_1 100
D4_1 m4_1 0 dm
Rh4_2 m4_2 m4_3 100
Rv4_2 m4_2 m5_2 100
D4_2 m4_2 0 dm
Rh4_3 m4_3 m4_4 100
Rv4_3 m4_3 m5_3 100
D4_3 m4_3 0 dm
Rh4_4 m4_4 m4_5 100
Rv4_4 m4_4 m5_4 100
D4_4 m4_4 0 dm
Rh4_5 m4_5 m4_6 100
Rv4_5 m4_5 m5_5 100
D4_5 m4_5 0 dm
Rh4_6 m4_6 m4_7 100
Rv4_6 m4_6 m5_6 100
D4_6 m4_6 0 dm
Rh4_7 m4_7 m4_8 100
Rv4_7 m4_7 m5_7 100
D4_7 m4_7 0 dm
Rh4_8 m4_8 m4_9 100
Rv4_8 m4_8 m5_8 100
D4_8 m4_8 0 dm
Rh4_9 m4_9 m4_10 100
Rv4_9 m4_9 m5_9 100
D4_9 m4_9 0 dm
Rh4_10 m4_10 m4_11 100
Rv4_10 m4_10 m5_10 100
D4_10 m4_10 0 dm
Rh4_11 m4_11 m4_12 100
Rv4_11 m4_11 m5_11 100
D4_11 m4_11 0 dm
Rh4_12 m4_12 m4_13 100
Rv4_12 m4_12 m5_12 100
D4_12 m4_12 0 dm
Rh4_13 m4_13 m4_14 100
Rv4_13 m4_13 m5_13 100
D4_13 m4_13 0 dm
Rh4_14 m4_14 m4_15 100
Rv4_14 m4_14 m5_14 100
D4_14 m4_14 0 dm
Rv4_15 m4_15 m5_15 100
D4_15 m4_15 0 dm
Rh5_0 m5_0 m5_1 100
Rv5_0 m5_0 m6_0 100
D5_0 m5_0 0 dm
Rh5_1 m5_1 m5_2 100
Rv5_1 m5_1 m6_1 100
D5_1 m5_1 0 dm
Rh5_2 m5_2 m5_3 100
Rv5_2 m5_2 m6_2 100
D5_2 m5_2 0 dm
Rh5_3 m5_3 m5_4 100
Rv5_3 m5_3 m6_3 100
D5_3 m5_3 0 dm
Rh5_4 m5_4 m5_5 100
Rv5_4 m5_4 m6_4 100
D5_4 m5_4 0 dm
Rh5_5 m5_5 m5_6 100
Rv5_5 m5_5 m6_5 100
D5_5 m5_5 0 dm
Rh5_6 m5_6 m5_7 100
Rv5_6 m5_6 m6_6 100
D5_6 m5_6 0 dm
Rh5_7 m5_7 m5_8 100
Rv5_7 m5_7 m6_7 100
D5_7 m5_7 0 dm
Rh5_8 m5_8 m5_9 100
Rv5_8 m5_8 m6_8 100
D5_8 m5_8 0 dm
Rh5_9 m5_9 m5_10 100
Rv5_9 m5_9 m6_9 100
D5_9 m5_9 0 dm
Rh5_10 m5_10 m5_11 100
Rv5_10 m5_10 m6_10 100
D5_10 m5_10 0 dm
Rh5_11 m5_11 m5_12 100
Rv5_11 m5_11 m6_11 100
D5_11 m5_11 0 dm
Rh5_12 m5_12 m5_13 100
Rv5_12 m5_12 m6_12 100
D5_12 m5_12 0 dm
Rh5_13 m5_13 m5_14 100
Rv5_13 m5_13 m6_13 100
D5_13 m5_13 0 dm
Rh5_14 m5_14 m5_15 100
Rv5_14 m5_14 m6_14 100
D5_14 m5_14 0 dm
Rv5_15 m5_15 m6_15 100
D5_15 m5_15 0 dm
Rh6_0 m6_0 m6_1 100
Rv6_0 m6_0 m7_0 100
D6_0 m6_0 0 dm
Rh6_1 m6_1 m6_2 100
Rv6_1 m6_1 m7_1 100
D6_1 m6_1 0 dm
Rh6_2 m6_2 m6_3 100
Rv6_2 m6_2 m7_2 100
D6_2 m6_2 0 dm
Rh6_3 m6_3 m6_4 100
Rv6_3 m6_3 m7_3 100
D6_3 m6_3 0 dm
Rh6_4 m6_4 m6_5 100
Rv6_4 m6_4 m7_4 100
D6_4 m6_4 0 dm
Rh6_5 m6_5 m6_6 100
Rv6_5 m6_5 m7_5 100
D6_5 m6_5 0 dm
Rh6_6 m6_6 m6_7 100
Rv6_6 m6_6 m7_6 100
D6_6 m6_6 0 dm
Rh6_7 m6_7 m6_8 100
Rv6_7 m6_7 m7_7 100
D6_7 m6_7 0 dm
Rh6_8 m6_8 m6_9 100
Rv6_8 m6_8 m7_8 100
D6_8 m6_8 0 dm
Rh6_9 m6_9 m6_10 100
Rv6_9 m6_9 m7_9 100
D6_9 m6_9 0 dm
Rh6_10 m6_10 m6_11 100
Rv6_10 m6_10 m7_10 100
D6_10 m6_10 0 dm
Rh6_11 m6_11 m6_12 100
Rv6_11 m6_11 m7_11 100
D6_11 m6_11 0 dm
Rh6_12 m6_12 m6_13 100
Rv6_12 m6_12 m7_12 100
D6_12 m6_12 0 dm
Rh6_13 m6_13 m6_14 100
Rv6_13 m6_13 m7_13 100
D6_13 m6_13 0 dm
Rh6_14 m6_14 m6_15 100
Rv6_14 m6_14 m7_14 100
D6_14 m6_14 0 dm
Rv6_15 m6_15 m7_15 100
D6_15 m6_15 0 dm
Rh7_0 m7_0 m7_1 100
Rv7_0 m7_0 m8_0 100
D7_0 m7_0 0 dm
Rh7_1 m7_1 m7_2 100
Rv7_1 m7_1 m8_1 100
D7_1 m7_1 0 dm
Rh7_2 m7_2 m7_3 100
Rv7_2 m7_2 m8_2 100
D7_2 m7_2 0 dm
Rh7_3 m7_3 m7_4 100
Rv7_3 m7_3 m8_3 100
D7_3 m7_3 0 dm
Rh7_4 m7_4 m7_5 100
Rv7_4 m7_4 m8_4 100
D7_4 m7_4 0 dm
Rh7_5 m7_5 m7_6 100
Rv7_5 m7_5 m8_5 100
D7_5 m7_5 0 dm
Rh7_6 m7_6 m7_7 100
Rv7_6 m7_6 m8_6 100
D7_6 m7_6 0 dm
Rh7_7 m7_7 m7_8 100
Rv7_7 m7_7 m8_7 100
D7_7 m7_7 0 dm
Rh7_8 m7_8 m7_9 100
Rv7_8 m7_8 m8_8 100
D7_8 m7_8 0 dm
Rh7_9 m7_9 m7_10 100
Rv7_9 m7_9 m8_9 100
D7_9 m7_9 0 dm
Rh7_10 m7_10 m7_11 100
Rv7_10 m7_10 m8_10 100
D7_10 m7_10 0 dm
Rh7_11 m7_11 m7_12 100
Rv7_11 m7_11 m8_11 100
D7_11 m7_11 0 dm
Rh7_12 m7_12 m7_13 100
Rv7_12 m7_12 m8_12 100
D7_12 m7_12 0 dm
Rh7_13 m7_13 m7_14 100
Rv7_13 m7_13 m8_13 100
D7_13 m7_13 0 dm
Rh7_14 m7_14 m7_15 100
Rv7_14 m7_14 m8_14 100
D7_14 m7_14 0 dm
Rv7_15 m7_15 m8_15 100
D7_15 m7_15 0 dm
Rh8_0 m8_0 m8_1 100
Rv8_0 m8_0 m9_0 100
D8_0 m8_0 0 dm
Rh8_1 m8_1 m8_2 100
Rv8_1 m8_1 m9_1 100
D8_1 m8_1 0 dm
Rh8_2 m8_2 m8_3 100
Rv8_2 m8_2 m9_2 100
D8_2 m8_2 0 dm
Rh8_3 m8_3 m8_4 100
Rv8_3 m8_3 m9_3 100
D8_3 m8_3 0 dm
Rh8_4 m8_4 m8_5 100
Rv8_4 m8_4 m9_4 100
D8_4 m8_4 0 dm
Rh8_5 m8_5 m8_6 100
Rv8_5 m8_5 m9_5 100
D8_5 m8_5 0 dm
Rh8_6 m8_6 m8_7 100
Rv8_6 m8_6 m9_6 100
D8_6 m8_6 0 dm
Rh8_7 m8_7 m8_8 100
Rv8_7 m8_7 m9_7 100
D8_7 m8_7 0 dm
Rh8_8 m8_8 m8_9 100
Rv8_8 m8_8 m9_8 100
D8_8 m8_8 0 dm
Rh8_9 m8_9 m8_10 100
Rv8_9 m8_9 m9_9 100
D8_9 m8_9 0 dm
Rh8_10 m8_10 m8_11 100
Rv8_10 m8_10 m9_10 100
D8_10 m8_10 0 dm
Rh8_11 m8_11 m8_12 100
Rv8_11 m8_11 m9_11 100
D8_11 m8_11 0 dm
Rh8_12 m8_12 m8_13 100
Rv8_12 m8_12 m9_12 100
D8_12 m8_12 0 dm
Rh8_13 m8_13 m8_14 100
Rv8_13 m8_13 m9_13 100
D8_13 m8_13 0 dm
Rh8_14 m8_14 m8_15 100
Rv8_14 m8_14 m9_14 100
D8_14 m8_14 0 dm
Rv8_15 m8_15 m9_15 100
D8_15 m8_15 0 dm
Rh9_0 m9_0 m9_1 100
Rv9_0 m9_0 m10_0 100
D9_0 m9_0 0 dm
Rh9_1 m9_1 m9_2 100
Rv9_1 m9_1 m10_1 100
D9_1 m9_1 0 dm
Rh9_2 m9_2 m9_3 100
Rv9_2 m9_2 m10_2 100
D9_2 m9_2 0 dm
Rh9_3 m9_3 m9_4 100
Rv9_3 m9_3 m10_3 100
D9_3 m9_3 0 dm
Rh9_4 m9_4 m9_5 100
Rv9_4 m9_4 m10_4 100
D9_4 m9_4 0 dm
Rh9_5 m9_5 m9_6 100
Rv9_5 m9_5 m10_5 100
D9_5 m9_5 0 dm
Rh9_6 m9_6 m9_7 100
Rv9_6 m9_6 m10_6 100
D9_6 m9_6 0 dm
Rh9_7 m9_7 m9_8 100
Rv9_7 m9_7 m10_7 100
D9_7 m9_7 0 dm
Rh9_8 m9_8 m9_9 100
Rv9_8 m9_8 m10_8 100
D9_8 m9_8 0 dm
Rh9_9 m9_9 m9_10 100
Rv9_9 m9_9 m10_9 100
D9_9 m9_9 0 dm
Rh9_10 m9_10 m9_11 100
Rv9_10 m9_10 m10_10 100
D9_10 m9_10 0 dm
Rh9_11 m9_11 m9_12 100
Rv9_11 m9_11 m10_11 100
D9_11 m9_11 0 dm
Rh9_12 m9_12 m9_13 100
Rv9_12 m9_12 m10_12 100
D9_12 m9_12 0 dm
Rh9_13 m9_13 m9_14 100
Rv9_13 m9_13 m10_13 100
D9_13 m9_13 0 dm
Rh9_14 m9_14 m9_15 100
Rv9_14 m9_14 m10_14 100
D9_14 m9_14 0 dm
Rv9_15 m9_15 m10_15 100
D9_15 m9_15 0 dm
Rh10_0 m10_0 m10_1 100
Rv10_0 m10_0 m11_0 100
D10_0 m10_0 0 dm
Rh10_1 m10_1 m10_2 100
Rv10_1 m10_1 m11_1 100
D10_1 m10_1 0 dm
Rh10_2 m10_2 m10_3 100
Rv10_2 m10_2 m11_2 100
D10_2 m10_2 0 dm
Rh10_3 m10_3 m10_4 100
Rv10_3 m10_3 m11_3 100
D10_3 m10_3 0 dm
Rh10_4 m10_4 m10_5 100
Rv10_4 m10_4 m11_4 100
D10_4 m10_4 0 dm
Rh10_5 m10_5 m10_6 100
Rv10_5 m10_5 m11_5 100
D10_5 m10_5 0 dm
Rh10_6 m10_6 m10_7 100
Rv10_6 m10_6 m11_6 100
D10_6 m10_6 0 dm
Rh10_7 m10_7 m10_8 100
Rv10_7 m10_7 m11_7 100
D10_7 m10_7 0 dm
Rh10_8 m10_8 m10_9 100
Rv10_8 m10_8 m11_8 100
D10_8 m10_8 0 dm
Rh10_9 m10_9 m10_10 100
Rv10_9 m10_9 m11_9 100
D10_9 m10_9 0 dm
Rh10_10 m10_10 m10_11 100
Rv10_10 m10_10 m11_10 100
D10_10 m10_10 0 dm
Rh10_11 m10_11 m10_12 100
Rv10_11 m10_11 m11_11 100
D10_11 m10_11 0 dm
Rh10_12 m10_12 m10_13 100
Rv10_12 m10_12 m11_12 100
D10_12 m10_12 0 dm
Rh10_13 m10_13 m10_14 100
Rv10_13 m10_13 m11_13 100
D10_13 m10_13 0 dm
Rh10_14 m10_14 m10_15 100
Rv10_14 m10_14 m11_14 100
D10_14 m10_14 0 dm
Rv10_15 m10_15 m11_15 100
D10_15 m10_15 0 dm
Rh11_0 m11_0 m11_1 100
Rv11_0 m11_0 m12_0 100
D11_0 m11_0 0 dm
Rh11_1 m11_1 m11_2 100
Rv11_1 m11_1 m12_1 100
D11_1 m11_1 0 dm
Rh11_2 m11_2 m11_3 100
Rv11_2 m11_2 m12_2 100
D11_2 m11_2 0 dm
Rh11_3 m11_3 m11_4 100
Rv11_3 m11_3 m12_3 100
D11_3 m11_3 0 dm
Rh11_4 m11_4 m11_5 100
Rv11_4 m11_4 m12_4 100
D11_4 m11_4 0 dm
Rh11_5 m11_5 m11_6 100
Rv11_5 m11_5 m12_5 100
D11_5 m11_5 0 dm
Rh11_6 m11_6 m11_7 100
Rv11_6 m11_6 m12_6 100
D11_6 m11_6 0 dm
Rh11_7 m11_7 m11_8 100
Rv11_7 m11_7 m12_7 100
D11_7 m11_7 0 dm
Rh11_8 m11_8 m11_9 100
Rv11_8 m11_8 m12_8 100
D11_8 m11_8 0 dm
Rh11_9 m11_9 m11_10 100
Rv11_9 m11_9 m12_9 100
D11_9 m11_9 0 dm
Rh11_10 m11_10 m11_11 100
Rv11_10 m11_10 m12_10 100
D11_10 m11_10 0 dm
Rh11_11 m11_11 m11_12 100
Rv11_11 m11_11 m12_11 100
D11_11 m11_11 0 dm
Rh11_12 m11_12 m11_13 100
Rv11_12 m11_12 m12_12 100
D11_12 m11_12 0 dm
Rh11_13 m11_13 m11_14 100
Rv11_13 m11_13 m12_13 100
D11_13 m11_13 0 dm
Rh11_14 m11_14 m11_15 100
Rv11_14 m11_14 m12_14 100
D11_14 m11_14 0 dm
Rv11_15 m11_15 m12_15 100
D11_15 m11_15 0 dm
Rh12_0 m12_0 m12_1 100
Rv12_0 m12_0 m13_0 100
D12_0 m12_0 0 dm
Rh12_1 m12_1 m12_2 100
Rv12_1 m12_1 m13_1 100
D12_1 m12_1 0 dm
Rh12_2 m12_2 m12_3 100
Rv12_2 m12_2 m13_2 100
D12_2 m12_2 0 dm
Rh12_3 m12_3 m12_4 100
Rv12_3 m12_3 m13_3 100
D12_3 m12_3 0 dm
Rh12_4 m12_4 m12_5 100
Rv12_4 m12_4 m13_4 100
D12_4 m12_4 0 dm
Rh12_5 m12_5 m12_6 100
Rv12_5 m12_5 m13_5 100
D12_5 m12_5 0 dm
Rh12_6 m12_6 m12_7 100
Rv12_6 m12_6 m13_6 100
D12_6 m12_6 0 dm
Rh12_7 m12_7 m12_8 100
Rv12_7 m12_7 m13_7 100
D12_7 m12_7 0 dm
Rh12_8 m12_8 m12_9 100
Rv12_8 m12_8 m13_8 100
D12_8 m12_8 0 dm
Rh12_9 m12_9 m12_10 100
Rv12_9 m12_9 m13_9 100
D12_9 m12_9 0 dm
Rh12_10 m12_10 m12_11 100
Rv12_10 m12_10 m13_10 100
D12_10 m12_10 0 dm
Rh12_11 m12_11 m12_12 100
Rv12_11 m12_11 m13_11 100
D12_11 m12_11 0 dm
Rh12_12 m12_12 m12_13 100
Rv12_12 m12_12 m13_12 100
D12_12 m12_12 0 dm
Rh12_13 m12_13 m12_14 100
Rv12_13 m12_13 m13_13 100
D12_13 m12_13 0 dm
Rh12_14 m12_14 m12_15 100
Rv12_14 m12_14 m13_14 100
D12_14 m12_14 0 dm
Rv12_15 m12_15 m13_15 100
D12_15 m12_15 0 dm
Rh13_0 m13_0 m13_1 100
Rv13_0 m13_0 m14_0 100
D13_0 m13_0 0 dm
Rh13_1 m13_1 m13_2 100
Rv13_1 m13_1 m14_1 100
D13_1 m13_1 0 dm
Rh13_2 m13_2 m13_3 100
Rv13_2 m13_2 m14_2 100
D13_2 m13_2 0 dm
Rh13_3 m13_3 m13_4 100
Rv13_3 m13_3 m14_3 100
D13_3 m13_3 0 dm
Rh13_4 m13_4 m13_5 100
Rv13_4 m13_4 m14_4 100
D13_4 m13_4 0 dm
Rh13_5 m13_5 m13_6 100
Rv13_5 m13_5 m14_5 100
D13_5 m13_5 0 dm
Rh13_6 m13_6 m13_7 100
Rv13_6 m13_6 m14_6 100
D13_6 m13_6 0 dm
Rh13_7 m13_7 m13_8 100
Rv13_7 m13_7 m14_7 100
D13_7 m13_7 0 dm
Rh13_8 m13_8 m13_9 100
Rv13_8 m13_8 m14_8 100
D13_8 m13_8 0 dm
Rh13_9 m13_9 m13_10 100
Rv13_9 m13_9 m14_9 100
D13_9 m13_9 0 dm
Rh13_10 m13_10 m13_11 100
Rv13_10 m13_10 m14_10 100
D13_10 m13_10 0 dm
Rh13_11 m13_11 m13_12 100
Rv13_11 m13_11 m14_11 100
D13_11 m13_11 0 dm
Rh13_12 m13_12 m13_13 100
Rv13_12 m13_12 m14_12 100
D13_12 m13_12 0 dm
Rh13_13 m13_13 m13_14 100
Rv13_13 m13_13 m14_13 100
D13_13 m13_13 0 dm
Rh13_14 m13_14 m13_15 100
Rv13_14 m13_14 m14_14 100
D13_14 m13_14 0 dm
Rv13_15 m13_15 m14_15 100
D13_15 m13_15 0 dm
Rh14_0 m14_0 m14_1 100
Rv14_0 m14_0 m15_0 100
D14_0 m14_0 0 dm
Rh14_1 m14_1 m14_2 100
Rv14_1 m14_1 m15_1 100
D14_1 m14_1 0 dm
Rh14_2 m14_2 m14_3 100
Rv14_2 m14_2 m15_2 100
D14_2 m14_2 0 dm
Rh14_3 m14_3 m14_4 100
Rv14_3 m14_3 m15_3 100
D14_3 m14_3 0 dm
Rh14_4 m14_4 m14_5 100
Rv14_4 m14_4 m15_4 100
D14_4 m14_4 0 dm
Rh14_5 m14_5 m14_6 100
Rv14_5 m14_5 m15_5 100
D14_5 m14_5 0 dm
Rh14_6 m14_6 m14_7 100
Rv14_6 m14_6 m15_6 100
D14_6 m14_6 0 dm
Rh14_7 m14_7 m14_8 100
Rv14_7 m14_7 m15_7 100
D14_7 m14_7 0 dm
Rh14_8 m14_8 m14_9 100
Rv14_8 m14_8 m15_8 100
D14_8 m14_8 0 dm
Rh14_9 m14_9 m14_10 100
Rv14_9 m14_9 m15_9 100
D14_9 m14_9 0 dm
Rh14_10 m14_10 m14_11 100
Rv14_10 m14_10 m15_10 100
D14_10 m14_10 0 dm
Rh14_11 m14_11 m14_12 100
Rv14_11 m14_11 m15_11 100
D14_11 m14_11 0 dm
Rh14_12 m14_12 m14_13 100
Rv14_12 m14_12 m15_12 100
D14_12 m14_12 0 dm
Rh14_13 m14_13 m14_14 100
Rv14_13 m14_13 m15_13 100
D14_13 m14_13 0 dm
Rh14_14 m14_14 m14_15 100
Rv14_14 m14_14 m15_14 100
D14_14 m14_14 0 dm
Rv14_15 m14_15 m15_15 100
D14_15 m14_15 0 dm
Rh15_0 m15_0 m15_1 100
D15_0 m15_0 0 dm
Rh15_1 m15_1 m15_2 100
D15_1 m15_1 0 dm
Rh15_2 m15_2 m15_3 100
D15_2 m15_2 0 dm
Rh15_3 m15_3 m15_4 100
D15_3 m15_3 0 dm
Rh15_4 m15_4 m15_5 100
D15_4 m15_4 0 dm
Rh15_5 m15_5 m15_6 100
D15_5 m15_5 0 dm
Rh15_6 m15_6 m15_7 100
D15_6 m15_6 0 dm
Rh15_7 m15_7 m15_8 100
D15_7 m15_7 0 dm
Rh15_8 m15_8 m15_9 100
D15_8 m15_8 0 dm
Rh15_9 m15_9 m15_10 100
D15_9 m15_9 0 dm
Rh15_10 m15_10 m15_11 100
D15_10 m15_10 0 dm
Rh15_11 m15_11 m15_12 100
D15_11 m15_11 0 dm
Rh15_12 m15_12 m15_13 100
D15_12 m15_12 0 dm
Rh15_13 m15_13 m15_14 100
D15_13 m15_13 0 dm
Rh15_14 m15_14 m15_15 100
D15_14 m15_14 0 dm
D15_15 m15_15 0 dm
.model dm d is=1e-14 n=1 rs=0.5 cjo=1p
.op
.end
