* op_bsrc_cubic_loop: two coupled cubic (bistable-well) nodes: I(a)=V(a)^3-V(a)+0.5*(V(a)-V(b)), same for b, weak 10 kohm tie to a 0.1 V source
* Hard for DC OP because: double-well nonlinearities on both nodes: up to 9 DC roots (3 per node, coupled); Newton path depends on starting point
* (card #637 corpus, generated by tools/gen_opcorpus.py -- edit the generator, not the deck)
V1 s 0 0.1
R1 s a 10k
R2 s b 10k
Ba a 0 I=V(a)^3-V(a)+0.5*(V(a)-V(b))
Bb b 0 I=V(b)^3-V(b)+0.5*(V(b)-V(a))
.op
.end
