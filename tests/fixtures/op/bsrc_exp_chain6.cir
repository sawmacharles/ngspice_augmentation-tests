* op_bsrc_exp_chain6: six exponential B-source diodes in series from 30 V through 0.5 ohm, plus a shunt exp device at each tap through 1 kohm
* Hard for DC OP because: chain of unlimited exponentials where each tap is only pinned by the next device; the Newton path overshoots at every node simultaneously
* (card #637 corpus, generated by tools/gen_opcorpus.py -- edit the generator, not the deck)
V1 in 0 30
R1 in n0 0.5
Bd0 n0 n1 I=1e-15*(exp((V(n0)-V(n1))/0.026)-1)
Rt0 n0 t0 1k
Bt0 t0 0 I=1e-15*(exp(V(t0)/0.026)-1)
Bd1 n1 n2 I=1e-15*(exp((V(n1)-V(n2))/0.026)-1)
Rt1 n1 t1 1k
Bt1 t1 0 I=1e-15*(exp(V(t1)/0.026)-1)
Bd2 n2 n3 I=1e-15*(exp((V(n2)-V(n3))/0.026)-1)
Rt2 n2 t2 1k
Bt2 t2 0 I=1e-15*(exp(V(t2)/0.026)-1)
Bd3 n3 n4 I=1e-15*(exp((V(n3)-V(n4))/0.026)-1)
Rt3 n3 t3 1k
Bt3 t3 0 I=1e-15*(exp(V(t3)/0.026)-1)
Bd4 n4 n5 I=1e-15*(exp((V(n4)-V(n5))/0.026)-1)
Rt4 n4 t4 1k
Bt4 t4 0 I=1e-15*(exp(V(t4)/0.026)-1)
Bd5 n5 0 I=1e-15*(exp((V(n5)-0)/0.026)-1)
Rt5 n5 t5 1k
Bt5 t5 0 I=1e-15*(exp(V(t5)/0.026)-1)
.op
.end
