* op_bsrc_cubic_roots: node with KCL (1.5 - v) = 2*(v-1)(v-2)(v-3) through a 1 ohm resistor and a cubic B-source sink
* Hard for DC OP because: three DC roots (v about 1.1, 1.8, 2.9); only the central root is unstable-looking in Newton; start 0 lands in the basin of one of them
* (card #637 corpus, generated by tools/gen_opcorpus.py -- edit the generator, not the deck)
V1 s 0 1.5
R1 s a 1
Bc a 0 I=2*(V(a)-1)*(V(a)-2)*(V(a)-3)
.op
.end
