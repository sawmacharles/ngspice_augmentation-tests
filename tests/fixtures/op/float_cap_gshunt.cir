* op_float_cap_gshunt: same floating node plus an explicit .options gshunt=1e-12
* Hard for DC OP because: with the user shunt the node is defined (x = 0 V through gshunt); checks the gshunt code path and that fallbacks respect it
* (card #637 corpus, generated by tools/gen_opcorpus.py -- edit the generator, not the deck)
.options gshunt=1e-12
V1 a 0 3
C1 a x 1p
C2 x 0 2p
R1 a 0 1k
.op
.end
