* op_mos_leak_node: storage node connected only through two OFF BSIM3 transistors (DRAM-style), one to 1.8 V, one to ground
* Hard for DC OP because: node voltage is the ratio of two subthreshold/junction leakages (~1e-12 A): near-singular conductance ~1e-12 S, gmin dominates
* (card #637 corpus, generated by tools/gen_opcorpus.py -- edit the generator, not the deck)
Vdd vdd 0 1.8
Mup vdd gz x 0 nb3 w=0.5u l=0.18u
Mdn x gz 0 0 nb3 w=0.5u l=0.18u
Vgz gz 0 0
.model nb3 nmos level=8 version=3.3.0 tox=4.1e-9 vth0=0.45 k1=0.55 k2=0 u0=300 vsat=1.0e5
+ nch=1.7e17 xj=1.5e-7 pclm=1.2 rdsw=150 cgso=3e-10 cgdo=3e-10 cj=1e-3 mj=0.5 cjsw=2e-10 nfactor=1.2 voff=-0.1
.op
.end
