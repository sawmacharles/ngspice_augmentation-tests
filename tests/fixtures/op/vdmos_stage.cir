* op_vdmos_stage: VDMOS power stage: 24 V through 4 ohm, gate 4.5 V, device in saturation (~3 A)
* Hard for DC OP because: vdmos square-law with quasi-saturation terms and body diode; large Id range and a drain resistance of milliohms
* (card #637 corpus, generated by tools/gen_opcorpus.py -- edit the generator, not the deck)
Vdd vdd 0 24
Vg g 0 4.5
Rl vdd d 4
M1 d g 0 0 dmos
.model dmos vdmos nchan vto=3 kp=3 lambda=0.01 rd=15m rs=8m rg=1 cgdmax=100p cgdmin=10p cgs=800p
.op
.end
