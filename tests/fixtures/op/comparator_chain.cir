* op_comparator_chain: diff pair + mirror + three CMOS inverter stages (level 3), 1 mV differential input
* Hard for DC OP because: total gain >1e6 without DC feedback; the mV-level input places the first stage in its linear window while later stages are slammed to the rails
* (card #637 corpus, generated by tools/gen_opcorpus.py -- edit the generator, not the deck)
Vdd vdd 0 3.3
Vp inp 0 1.651
Vn inn 0 1.65
Vb vb 0 0.85
Mt tail vb 0 0 n3 w=10u l=0.7u
M1 d1 inp tail 0 n3 w=10u l=0.7u
M2 d2 inn tail 0 n3 w=10u l=0.7u
M3 d1 d1 vdd vdd p3 w=20u l=0.7u
M4 d2 d1 vdd vdd p3 w=20u l=0.7u
Man o1 d2 0 0 n3 w=4u l=0.35u
Map o1 d2 vdd vdd p3 w=10u l=0.35u
Mbn o2 o1 0 0 n3 w=8u l=0.35u
Mbp o2 o1 vdd vdd p3 w=20u l=0.35u
Mcn out o2 0 0 n3 w=16u l=0.35u
Mcp out o2 vdd vdd p3 w=40u l=0.35u
.model n3 nmos level=3 vto=0.5 uo=400 tox=4e-9 theta=0.15 vmax=1.5e5 eta=0.02 kappa=0.1
+ gamma=0.5 phi=0.8 nsub=3e17 xj=0.15u ld=0.02u cgso=3e-10 cgdo=3e-10 cj=1e-3 mj=0.5 cjsw=2e-10
.model p3 pmos level=3 vto=-0.5 uo=130 tox=4e-9 theta=0.15 vmax=1.0e5 eta=0.02 kappa=0.1
+ gamma=0.5 phi=0.8 nsub=3e17 xj=0.15u ld=0.02u cgso=3e-10 cgdo=3e-10 cj=1e-3 mj=0.5 cjsw=2e-10
.op
.end
