* op_float_cap: node coupled to a 3 V source and ground only through capacitors (no DC path)
* Hard for DC OP because: matrix is singular at DC unless a gshunt/gmin is added; any value of the node voltage is 'correct'
* (card #637 corpus, generated by tools/gen_opcorpus.py -- edit the generator, not the deck)
V1 a 0 3
C1 a x 1p
C2 x 0 2p
R1 a 0 1k
.op
.end
