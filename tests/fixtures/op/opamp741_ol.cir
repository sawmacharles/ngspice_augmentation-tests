* op_opamp741_ol: simplified 741-like bipolar opamp (~20 BJTs, Gummel-Poon), +-15 V, open loop, inputs at 0
* Hard for DC OP because: no DC feedback and loop gain ~1e5: output rails after microvolt offsets; mixed lateral PNP / NPN stack with Vbe multiplier; internal bias loop has an all-off root
* (card #637 corpus, generated by tools/gen_opcorpus.py -- edit the generator, not the deck)
Vcc vcc 0 15
Vee vee 0 -15
Vin inp 0 0
Vin2 inn 0 0
* bias: Q12/R5/Q11, Widlar Q10/R4
R5 qc12 qc11 39k
Q12 qc12 qc12 vcc qp
Q11 qc11 qc11 vee qn
Q10 q10c qc11 e10 qn
R4 e10 vee 5k
* Q8/Q9 pnp mirror feeding the input stage
Q8 q8c q8c vcc qp
Q9 q9c q8c vcc qp
* Q9 collector = bias node for Q3/Q4 bases, sunk by Q10
Q3 c3 q9c e1 qp
Q4 c4 q9c e2 qp
Q1 q8c inp e1 qn
Q2 q8c inn e2 qn
* Q9c ties the pnp bases; Q10 pulls it down
Rq q9c q10c 1m
* Q5/Q6 mirror with Q7 buffer
Q5 c3 b56 r1n qn
Q6 c4 b56 r2n qn
Q7 vcc c3 b56 qn
R1 r1n vee 1k
R2 r2n vee 1k
R3 b56 vee 50k
* second stage: Q16 follower, Q17 CE with Q13B load
Q16 vcc c4 b17 qn
R9 b17 vee 50k
Q17 n17 b17 e17 qn
R8 e17 vee 100
Q13b n17 qc12 vcc qp
* output stage: Vbe multiplier between nx and n17, class AB pair
Q13a nx qc12 vcc qp
Q18 nx nb n17 qn
Ra nx nb 4.5k
Rb nb n17 7.5k
Q14 vcc nx o14 qn
Q20 vee n17 o20 qp
R6 o14 out 27
R7 o20 out 22
Cc n17 c4 30p
Rload out 0 2k
.model qn npn is=1e-16 bf=150 br=2 vaf=80 var=15 ikf=5m ikr=1m rb=100 rbm=30 re=2 rc=30
+ cje=0.5p cjc=0.3p tf=20p ne=1.5 ise=1e-15 nc=2 isc=1e-14
.model qp pnp is=2e-16 bf=50 br=1 vaf=50 var=10 ikf=1m ikr=0.5m rb=200 rbm=60 re=5 rc=50
+ cje=0.8p cjc=0.5p tf=60p ne=1.5 ise=2e-15
.op
.end
