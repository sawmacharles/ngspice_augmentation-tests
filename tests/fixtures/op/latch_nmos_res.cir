* op_latch_nmos_res: cross-coupled NMOS (level 3) latch with resistor loads
* Hard for DC OP because: bistable pair; symmetric start gives the metastable root with loop gain > 1
* (card #637 corpus, generated by tools/gen_opcorpus.py -- edit the generator, not the deck)
Vdd vdd 0 3.3
R1 vdd a 20k
R2 vdd b 20k
M1 a b 0 0 n3 w=4u l=0.35u
M2 b a 0 0 n3 w=4u l=0.35u
.model n3 nmos level=3 vto=0.5 uo=400 tox=4e-9 theta=0.15 vmax=1.5e5 eta=0.02 kappa=0.1
+ gamma=0.5 phi=0.8 nsub=3e17 xj=0.15u ld=0.02u cgso=3e-10 cgdo=3e-10 cj=1e-3 mj=0.5 cjsw=2e-10
.op
.end
