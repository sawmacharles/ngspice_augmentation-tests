* op_gilbert_cell: Gilbert multiplier cell: 6 NPN, tail current source, 0.1 V differential on both ports
* Hard for DC OP because: stacked differential pairs with exponential Vbe; the tail and the two mid-level emitter nodes are weakly defined until currents split
* (card #637 corpus, generated by tools/gen_opcorpus.py -- edit the generator, not the deck)
Vcc vcc 0 5
Vx xp 0 2.6
Vxn xn 0 2.5
Vy yp 0 1.6
Vyn yn 0 1.5
Q1 a1 xp t1 qn
Q2 a2 xn t1 qn
Q3 a2 xp t2 qn
Q4 a1 xn t2 qn
Q5 t1 yp e5 qn
Q6 t2 yn e5 qn
It e5 0 DC 1m
Rl1 vcc a1 2k
Rl2 vcc a2 2k
.model qn npn is=1e-16 bf=150 br=2 vaf=80 var=15 ikf=5m ikr=1m rb=100 rbm=30 re=2 rc=30
+ cje=0.5p cjc=0.3p tf=20p ne=1.5 ise=1e-15 nc=2 isc=1e-14
.op
.end
