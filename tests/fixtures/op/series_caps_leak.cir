* op_series_caps_leak: three series capacitors with a 1e15 ohm leak on the first internal node only
* Hard for DC OP because: conductance range of 15 decades in one matrix: the leak defines n1, n2 is only held by gmin-level shunts
* (card #637 corpus, generated by tools/gen_opcorpus.py -- edit the generator, not the deck)
V1 a 0 5
C1 a n1 1p
C2 n1 n2 1p
C3 n2 0 1p
Rleak n1 0 1e15
.op
.end
