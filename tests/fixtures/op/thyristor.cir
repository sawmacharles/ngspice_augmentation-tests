* op_thyristor: PNPN thyristor as a coupled npn/pnp pair, gate open (10 kohm to cathode), 20 V anode supply through 100 ohm
* Hard for DC OP because: regenerative loop (loop gain bf_n*bf_p > 1): off state and latched on state both solve KCL; the on state needs both devices saturated
* (card #637 corpus, generated by tools/gen_opcorpus.py -- edit the generator, not the deck)
Vak a0 0 20
Ra a0 a 100
Rb a an 220k
Q1 an g k qn
Q2 g an a qp
Rg g 0 10k
Rk k 0 0.1
.model qn npn is=1e-16 bf=150 br=2 vaf=80 var=15 ikf=5m ikr=1m rb=100 rbm=30 re=2 rc=30
+ cje=0.5p cjc=0.3p tf=20p ne=1.5 ise=1e-15 nc=2 isc=1e-14
.model qp pnp is=2e-16 bf=50 br=1 vaf=50 var=10 ikf=1m ikr=0.5m rb=200 rbm=60 re=5 rc=50
+ cje=0.8p cjc=0.5p tf=60p ne=1.5 ise=2e-15
.op
.end
