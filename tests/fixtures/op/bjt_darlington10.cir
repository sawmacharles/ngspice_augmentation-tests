* op_bjt_darlington10: ten emitter-follower BJTs in a chain (10-deep Darlington), 40 V supply, base driven to 7.5 V through 50 ohm
* Hard for DC OP because: ten series Vbe drops each needing ~0.75 V from an initially zero chain; collector currents span 1e-15..1 A and the base resistances run in high injection
* (card #637 corpus, generated by tools/gen_opcorpus.py -- edit the generator, not the deck)
V1 vcc 0 40
Vin in 0 7.5
Rin in b0 50
Q0 vcc b0 b1 qn
Q1 vcc b1 b2 qn
Q2 vcc b2 b3 qn
Q3 vcc b3 b4 qn
Q4 vcc b4 b5 qn
Q5 vcc b5 b6 qn
Q6 vcc b6 b7 qn
Q7 vcc b7 b8 qn
Q8 vcc b8 b9 qn
Q9 vcc b9 b10 qn
Re b10 0 100
.model qn npn is=1e-16 bf=150 br=2 vaf=80 var=15 ikf=5m ikr=1m rb=100 rbm=30 re=2 rc=30
+ cje=0.5p cjc=0.3p tf=20p ne=1.5 ise=1e-15 nc=2 isc=1e-14
.op
.end
