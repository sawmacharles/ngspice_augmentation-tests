* op_brokaw_bgr: Brokaw-type bandgap core (Q1 8x, Q2 1x, ideal clamped gain-1e4 amplifier), 5 V
* Hard for DC OP because: PTAT loop: the all-zero state is a valid root (amp output 0 at zero input) in addition to the ~1.25 V reference; exponential Vbe with 8x area ratio
* (card #637 corpus, generated by tools/gen_opcorpus.py -- edit the generator, not the deck)
Vcc vcc 0 5
* amplifier: output ref, forcing equal collector voltages, one-sided so ref=0 is a legal root
Bamp ref 0 V=5*tanh(1e4*(V(c2)-V(c1)))
R2a ref c1 2k
R2b ref c2 2k
Q1 c1 ref e1 qn area=8
Q2 c2 ref e qn
R1 e1 e 2k
R3 e 0 11k
Rvcc vcc ref 1e9
.model qn npn is=1e-16 bf=150 br=2 vaf=80 var=15 ikf=5m ikr=1m rb=100 rbm=30 re=2 rc=30
+ cje=0.5p cjc=0.3p tf=20p ne=1.5 ise=1e-15 nc=2 isc=1e-14
.op
.end
