* op_sram6t: 6T SRAM cell (BSIM4), word line off, bit lines precharged high
* Hard for DC OP because: two inverters in positive feedback -> three DC roots (two stable, one metastable); Newton from 0 has to pick one
* (card #637 corpus, generated by tools/gen_opcorpus.py -- edit the generator, not the deck)
Vdd vdd 0 1.8
Vwl wl 0 0
Vbl bl 0 1.8
Vblb blb 0 1.8
M1n qb q 0 0 nb4 w=0.5u l=0.18u
M1p qb q vdd vdd pb4 w=0.3u l=0.18u
M2n q qb 0 0 nb4 w=0.5u l=0.18u
M2p q qb vdd vdd pb4 w=0.3u l=0.18u
Ma1 bl wl q 0 nb4 w=0.3u l=0.18u
Ma2 blb wl qb 0 nb4 w=0.3u l=0.18u
.model nb4 nmos level=54 version=4.8.2
+ mobmod=0 capmod=0 igcmod=0 igbmod=0 rdsmod=0 rbodymod=0 rgatemod=0 acnqsmod=0
+ toxe=4e-9 toxp=4e-9 toxm=4e-9 vth0=0.45 k1=0.4 k2=0 k3=0 w0=2.5e-6 u0=300 vsat=1.1e5
+ cgso=2e-10 cgdo=2e-10 cgbo=0 cf=0 cjs=1e-4 cjd=1e-4 cjswd=1e-10 cjswgd=1e-10
.model pb4 pmos level=54 version=4.8.2
+ mobmod=0 capmod=0 igcmod=0 igbmod=0 rdsmod=0 rbodymod=0 rgatemod=0 acnqsmod=0
+ toxe=4e-9 toxp=4e-9 toxm=4e-9 vth0=-0.45 k1=0.4 k2=0 k3=0 w0=2.5e-6 u0=100 vsat=1.0e5
+ cgso=2e-10 cgdo=2e-10 cgbo=0 cf=0 cjs=1e-4 cjd=1e-4 cjswd=1e-10 cjswgd=1e-10
.op
.end
