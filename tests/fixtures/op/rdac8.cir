* op_rdac8: 8-bit R-2R DAC, level-3 NMOS switches to vref or ground, code 0xB5
* Hard for DC OP because: mix of 1e-9-ish off-state conductances and 20 kohm networks; floating-ish source nodes of the off switches
* (card #637 corpus, generated by tools/gen_opcorpus.py -- edit the generator, not the deck)
Vdd vdd 0 1.8
Vref vref 0 1.0
Vb0 g0 0 1.8
Vb1 g1 0 0
Vb2 g2 0 1.8
Vb3 g3 0 0
Vb4 g4 0 1.8
Vb5 g5 0 1.8
Vb6 g6 0 0
Vb7 g7 0 1.8
* R-2R ladder, node r0 is LSB side
R2t r0 0 20k
R2_0 r0 sw0 20k
Msw0a sw0 g0 vref 0 n3 w=4u l=0.35u
Msw0b sw0 gb0 0 0 n3 w=4u l=0.35u
Vgb0 gb0 0 0
Rs0 r0 r1 10k
R2_1 r1 sw1 20k
Msw1a sw1 g1 vref 0 n3 w=4u l=0.35u
Msw1b sw1 gb1 0 0 n3 w=4u l=0.35u
Vgb1 gb1 0 1.8
Rs1 r1 r2 10k
R2_2 r2 sw2 20k
Msw2a sw2 g2 vref 0 n3 w=4u l=0.35u
Msw2b sw2 gb2 0 0 n3 w=4u l=0.35u
Vgb2 gb2 0 0
Rs2 r2 r3 10k
R2_3 r3 sw3 20k
Msw3a sw3 g3 vref 0 n3 w=4u l=0.35u
Msw3b sw3 gb3 0 0 n3 w=4u l=0.35u
Vgb3 gb3 0 1.8
Rs3 r3 r4 10k
R2_4 r4 sw4 20k
Msw4a sw4 g4 vref 0 n3 w=4u l=0.35u
Msw4b sw4 gb4 0 0 n3 w=4u l=0.35u
Vgb4 gb4 0 0
Rs4 r4 r5 10k
R2_5 r5 sw5 20k
Msw5a sw5 g5 vref 0 n3 w=4u l=0.35u
Msw5b sw5 gb5 0 0 n3 w=4u l=0.35u
Vgb5 gb5 0 0
Rs5 r5 r6 10k
R2_6 r6 sw6 20k
Msw6a sw6 g6 vref 0 n3 w=4u l=0.35u
Msw6b sw6 gb6 0 0 n3 w=4u l=0.35u
Vgb6 gb6 0 1.8
Rs6 r6 r7 10k
R2_7 r7 sw7 20k
Msw7a sw7 g7 vref 0 n3 w=4u l=0.35u
Msw7b sw7 gb7 0 0 n3 w=4u l=0.35u
Vgb7 gb7 0 0
Rbuf r7 out 1
Rl out 0 1Meg
.model n3 nmos level=3 vto=0.5 uo=400 tox=4e-9 theta=0.15 vmax=1.5e5 eta=0.02 kappa=0.1
+ gamma=0.5 phi=0.8 nsub=3e17 xj=0.15u ld=0.02u cgso=3e-10 cgdo=3e-10 cj=1e-3 mj=0.5 cjsw=2e-10
.op
.end
