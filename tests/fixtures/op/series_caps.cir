* op_series_caps: voltage source - 3 series capacitors - ground
* Hard for DC OP because: two floating nodes with no DC path at all
* (card #637 corpus, generated by tools/gen_opcorpus.py -- edit the generator, not the deck)
V1 a 0 5
C1 a n1 1p
C2 n1 n2 1p
C3 n2 0 1p
.op
.end
