* op_bsrc_tanhsw_buck: DC-only slice of a smooth-switch converter: two tanh-conductance switches (ksw=30), PWM level held at 0.5 V, L shorted at DC
* Hard for DC OP because: both switches are half-on at the same instant (tanh midpoint) so the node 'sw' is a divider of two nonlinear conductances, goff/gon = 1e-8 ratio
* (card #637 corpus, generated by tools/gen_opcorpus.py -- edit the generator, not the deck)
.param gon=100 goff=1e-6 ksw=30
Vin vin 0 12
Vpwm pwm 0 0.5005
Bhs vin sw I=(V(vin)-V(sw))*({goff}+({gon}-{goff})*0.5*(1+tanh({ksw}*(V(pwm)-0.5))))
Bls sw 0 I=V(sw)*({goff}+({gon}-{goff})*0.5*(1+tanh({ksw}*(0.5-V(pwm)))))
Csw sw 0 100p
Rdcr sw vout 10m
Cout vout 0 100u
Rload vout 0 3.3
.op
.end
