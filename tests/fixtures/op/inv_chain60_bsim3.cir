* op_inv_chain60_bsim3: 60-stage CMOS inverter chain (BSIM3), input parked at the first stage's switching region
* Hard for DC OP because: 60 stages of gain ~10-20 in series (1e60 overall); every stage is in a different region on the path from the all-zero start
* (card #637 corpus, generated by tools/gen_opcorpus.py -- edit the generator, not the deck)
Vdd vdd 0 1.8
Vin s0 0 0.78
M1n s1 s0 0 0 nb3 w=1u l=0.18u
M1p s1 s0 vdd vdd pb3 w=2.5u l=0.18u
M2n s2 s1 0 0 nb3 w=1u l=0.18u
M2p s2 s1 vdd vdd pb3 w=2.5u l=0.18u
M3n s3 s2 0 0 nb3 w=1u l=0.18u
M3p s3 s2 vdd vdd pb3 w=2.5u l=0.18u
M4n s4 s3 0 0 nb3 w=1u l=0.18u
M4p s4 s3 vdd vdd pb3 w=2.5u l=0.18u
M5n s5 s4 0 0 nb3 w=1u l=0.18u
M5p s5 s4 vdd vdd pb3 w=2.5u l=0.18u
M6n s6 s5 0 0 nb3 w=1u l=0.18u
M6p s6 s5 vdd vdd pb3 w=2.5u l=0.18u
M7n s7 s6 0 0 nb3 w=1u l=0.18u
M7p s7 s6 vdd vdd pb3 w=2.5u l=0.18u
M8n s8 s7 0 0 nb3 w=1u l=0.18u
M8p s8 s7 vdd vdd pb3 w=2.5u l=0.18u
M9n s9 s8 0 0 nb3 w=1u l=0.18u
M9p s9 s8 vdd vdd pb3 w=2.5u l=0.18u
M10n s10 s9 0 0 nb3 w=1u l=0.18u
M10p s10 s9 vdd vdd pb3 w=2.5u l=0.18u
M11n s11 s10 0 0 nb3 w=1u l=0.18u
M11p s11 s10 vdd vdd pb3 w=2.5u l=0.18u
M12n s12 s11 0 0 nb3 w=1u l=0.18u
M12p s12 s11 vdd vdd pb3 w=2.5u l=0.18u
M13n s13 s12 0 0 nb3 w=1u l=0.18u
M13p s13 s12 vdd vdd pb3 w=2.5u l=0.18u
M14n s14 s13 0 0 nb3 w=1u l=0.18u
M14p s14 s13 vdd vdd pb3 w=2.5u l=0.18u
M15n s15 s14 0 0 nb3 w=1u l=0.18u
M15p s15 s14 vdd vdd pb3 w=2.5u l=0.18u
M16n s16 s15 0 0 nb3 w=1u l=0.18u
M16p s16 s15 vdd vdd pb3 w=2.5u l=0.18u
M17n s17 s16 0 0 nb3 w=1u l=0.18u
M17p s17 s16 vdd vdd pb3 w=2.5u l=0.18u
M18n s18 s17 0 0 nb3 w=1u l=0.18u
M18p s18 s17 vdd vdd pb3 w=2.5u l=0.18u
M19n s19 s18 0 0 nb3 w=1u l=0.18u
M19p s19 s18 vdd vdd pb3 w=2.5u l=0.18u
M20n s20 s19 0 0 nb3 w=1u l=0.18u
M20p s20 s19 vdd vdd pb3 w=2.5u l=0.18u
M21n s21 s20 0 0 nb3 w=1u l=0.18u
M21p s21 s20 vdd vdd pb3 w=2.5u l=0.18u
M22n s22 s21 0 0 nb3 w=1u l=0.18u
M22p s22 s21 vdd vdd pb3 w=2.5u l=0.18u
M23n s23 s22 0 0 nb3 w=1u l=0.18u
M23p s23 s22 vdd vdd pb3 w=2.5u l=0.18u
M24n s24 s23 0 0 nb3 w=1u l=0.18u
M24p s24 s23 vdd vdd pb3 w=2.5u l=0.18u
M25n s25 s24 0 0 nb3 w=1u l=0.18u
M25p s25 s24 vdd vdd pb3 w=2.5u l=0.18u
M26n s26 s25 0 0 nb3 w=1u l=0.18u
M26p s26 s25 vdd vdd pb3 w=2.5u l=0.18u
M27n s27 s26 0 0 nb3 w=1u l=0.18u
M27p s27 s26 vdd vdd pb3 w=2.5u l=0.18u
M28n s28 s27 0 0 nb3 w=1u l=0.18u
M28p s28 s27 vdd vdd pb3 w=2.5u l=0.18u
M29n s29 s28 0 0 nb3 w=1u l=0.18u
M29p s29 s28 vdd vdd pb3 w=2.5u l=0.18u
M30n s30 s29 0 0 nb3 w=1u l=0.18u
M30p s30 s29 vdd vdd pb3 w=2.5u l=0.18u
M31n s31 s30 0 0 nb3 w=1u l=0.18u
M31p s31 s30 vdd vdd pb3 w=2.5u l=0.18u
M32n s32 s31 0 0 nb3 w=1u l=0.18u
M32p s32 s31 vdd vdd pb3 w=2.5u l=0.18u
M33n s33 s32 0 0 nb3 w=1u l=0.18u
M33p s33 s32 vdd vdd pb3 w=2.5u l=0.18u
M34n s34 s33 0 0 nb3 w=1u l=0.18u
M34p s34 s33 vdd vdd pb3 w=2.5u l=0.18u
M35n s35 s34 0 0 nb3 w=1u l=0.18u
M35p s35 s34 vdd vdd pb3 w=2.5u l=0.18u
M36n s36 s35 0 0 nb3 w=1u l=0.18u
M36p s36 s35 vdd vdd pb3 w=2.5u l=0.18u
M37n s37 s36 0 0 nb3 w=1u l=0.18u
M37p s37 s36 vdd vdd pb3 w=2.5u l=0.18u
M38n s38 s37 0 0 nb3 w=1u l=0.18u
M38p s38 s37 vdd vdd pb3 w=2.5u l=0.18u
M39n s39 s38 0 0 nb3 w=1u l=0.18u
M39p s39 s38 vdd vdd pb3 w=2.5u l=0.18u
M40n s40 s39 0 0 nb3 w=1u l=0.18u
M40p s40 s39 vdd vdd pb3 w=2.5u l=0.18u
M41n s41 s40 0 0 nb3 w=1u l=0.18u
M41p s41 s40 vdd vdd pb3 w=2.5u l=0.18u
M42n s42 s41 0 0 nb3 w=1u l=0.18u
M42p s42 s41 vdd vdd pb3 w=2.5u l=0.18u
M43n s43 s42 0 0 nb3 w=1u l=0.18u
M43p s43 s42 vdd vdd pb3 w=2.5u l=0.18u
M44n s44 s43 0 0 nb3 w=1u l=0.18u
M44p s44 s43 vdd vdd pb3 w=2.5u l=0.18u
M45n s45 s44 0 0 nb3 w=1u l=0.18u
M45p s45 s44 vdd vdd pb3 w=2.5u l=0.18u
M46n s46 s45 0 0 nb3 w=1u l=0.18u
M46p s46 s45 vdd vdd pb3 w=2.5u l=0.18u
M47n s47 s46 0 0 nb3 w=1u l=0.18u
M47p s47 s46 vdd vdd pb3 w=2.5u l=0.18u
M48n s48 s47 0 0 nb3 w=1u l=0.18u
M48p s48 s47 vdd vdd pb3 w=2.5u l=0.18u
M49n s49 s48 0 0 nb3 w=1u l=0.18u
M49p s49 s48 vdd vdd pb3 w=2.5u l=0.18u
M50n s50 s49 0 0 nb3 w=1u l=0.18u
M50p s50 s49 vdd vdd pb3 w=2.5u l=0.18u
M51n s51 s50 0 0 nb3 w=1u l=0.18u
M51p s51 s50 vdd vdd pb3 w=2.5u l=0.18u
M52n s52 s51 0 0 nb3 w=1u l=0.18u
M52p s52 s51 vdd vdd pb3 w=2.5u l=0.18u
M53n s53 s52 0 0 nb3 w=1u l=0.18u
M53p s53 s52 vdd vdd pb3 w=2.5u l=0.18u
M54n s54 s53 0 0 nb3 w=1u l=0.18u
M54p s54 s53 vdd vdd pb3 w=2.5u l=0.18u
M55n s55 s54 0 0 nb3 w=1u l=0.18u
M55p s55 s54 vdd vdd pb3 w=2.5u l=0.18u
M56n s56 s55 0 0 nb3 w=1u l=0.18u
M56p s56 s55 vdd vdd pb3 w=2.5u l=0.18u
M57n s57 s56 0 0 nb3 w=1u l=0.18u
M57p s57 s56 vdd vdd pb3 w=2.5u l=0.18u
M58n s58 s57 0 0 nb3 w=1u l=0.18u
M58p s58 s57 vdd vdd pb3 w=2.5u l=0.18u
M59n s59 s58 0 0 nb3 w=1u l=0.18u
M59p s59 s58 vdd vdd pb3 w=2.5u l=0.18u
M60n s60 s59 0 0 nb3 w=1u l=0.18u
M60p s60 s59 vdd vdd pb3 w=2.5u l=0.18u
Rld s60 0 1Meg
.model nb3 nmos level=8 version=3.3.0 tox=4.1e-9 vth0=0.45 k1=0.55 k2=0 u0=300 vsat=1.0e5
+ nch=1.7e17 xj=1.5e-7 pclm=1.2 rdsw=150 cgso=3e-10 cgdo=3e-10 cj=1e-3 mj=0.5 cjsw=2e-10 nfactor=1.2 voff=-0.1
.model pb3 pmos level=8 version=3.3.0 tox=4.1e-9 vth0=-0.45 k1=0.55 k2=0 u0=90 vsat=0.9e5
+ nch=1.7e17 xj=1.5e-7 pclm=1.2 rdsw=300 cgso=3e-10 cgdo=3e-10 cj=1e-3 mj=0.5 cjsw=2e-10 nfactor=1.2 voff=-0.1
.op
.end
