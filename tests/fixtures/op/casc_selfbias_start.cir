* op_casc_selfbias_start: self-biased cascoded beta-multiplier with a 50 Mohm startup bleed (stacked NMOS cascodes, PMOS cascode mirror), 3.3 V
* Hard for DC OP because: stacked diode-connected devices give 2*Vgs headroom conditions and a zero-current root; wide Newton basin issues
* (card #637 corpus, generated by tools/gen_opcorpus.py -- edit the generator, not the deck)
Vdd vdd 0 3.3
M1 m1d ng 0 0 n3 w=4u l=2u
Mc1 ng ng m1d 0 n3 w=4u l=2u
M2 m2d ng rs 0 n3 w=16u l=2u
Mc2 pg ng m2d 0 n3 w=16u l=2u
Rs rs 0 3k
M3 pd1 pg vdd vdd p3 w=20u l=2u
Mc3 pg pg pd1 vdd p3 w=20u l=2u
M4 pd2 pg vdd vdd p3 w=20u l=2u
Mc4 ng pg pd2 vdd p3 w=20u l=2u
Rst vdd ng 50Meg
.model n3 nmos level=3 vto=0.5 uo=400 tox=4e-9 theta=0.15 vmax=1.5e5 eta=0.02 kappa=0.1
+ gamma=0.5 phi=0.8 nsub=3e17 xj=0.15u ld=0.02u cgso=3e-10 cgdo=3e-10 cj=1e-3 mj=0.5 cjsw=2e-10
.model p3 pmos level=3 vto=-0.5 uo=130 tox=4e-9 theta=0.15 vmax=1.0e5 eta=0.02 kappa=0.1
+ gamma=0.5 phi=0.8 nsub=3e17 xj=0.15u ld=0.02u cgso=3e-10 cgdo=3e-10 cj=1e-3 mj=0.5 cjsw=2e-10
.op
.end
