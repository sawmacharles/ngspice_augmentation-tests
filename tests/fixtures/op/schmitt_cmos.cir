* op_schmitt_cmos: 6T CMOS Schmitt trigger (level 3), input at mid supply
* Hard for DC OP because: internal feedback transistors give a hysteresis loop; input mid-supply has several roots near the switching point
* (card #637 corpus, generated by tools/gen_opcorpus.py -- edit the generator, not the deck)
Vdd vdd 0 3.3
Vin in 0 1.65
Mp1 p1 in vdd vdd p3 w=8u l=0.35u
Mp2 out in p1 vdd p3 w=8u l=0.35u
Mp3 0 out p1 vdd p3 w=4u l=0.35u
Mn1 n1 in 0 0 n3 w=3u l=0.35u
Mn2 out in n1 0 n3 w=3u l=0.35u
Mn3 vdd out n1 0 n3 w=2u l=0.35u
.model n3 nmos level=3 vto=0.5 uo=400 tox=4e-9 theta=0.15 vmax=1.5e5 eta=0.02 kappa=0.1
+ gamma=0.5 phi=0.8 nsub=3e17 xj=0.15u ld=0.02u cgso=3e-10 cgdo=3e-10 cj=1e-3 mj=0.5 cjsw=2e-10
.model p3 pmos level=3 vto=-0.5 uo=130 tox=4e-9 theta=0.15 vmax=1.0e5 eta=0.02 kappa=0.1
+ gamma=0.5 phi=0.8 nsub=3e17 xj=0.15u ld=0.02u cgso=3e-10 cgdo=3e-10 cj=1e-3 mj=0.5 cjsw=2e-10
.op
.end
