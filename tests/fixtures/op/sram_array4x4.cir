* op_sram_array4x4: 4x4 SRAM array (96 BSIM4 transistors), random per-cell device widths (seed 6370), word lines off
* Hard for DC OP because: 16 independent bistable cells, each with its own (asymmetric) metastable point; the global Newton path has to resolve 16 symmetry-breaking decisions at once
* (card #637 corpus, generated by tools/gen_opcorpus.py -- edit the generator, not the deck)
Vdd vdd 0 1.8
Vbl bl 0 1.8
Vblb blb 0 1.8
Vwl wl 0 0
Mn1_0_0 qb0_0 q0_0 0 0 nb4 w=0.47u l=0.18u
Mp1_0_0 qb0_0 q0_0 vdd vdd pb4 w=0.35u l=0.18u
Mn2_0_0 q0_0 qb0_0 0 0 nb4 w=0.58u l=0.18u
Mp2_0_0 q0_0 qb0_0 vdd vdd pb4 w=0.29u l=0.18u
Ma1_0_0 bl wl q0_0 0 nb4 w=0.3u l=0.18u
Ma2_0_0 blb wl qb0_0 0 nb4 w=0.3u l=0.18u
Mn1_0_1 qb0_1 q0_1 0 0 nb4 w=0.64u l=0.18u
Mp1_0_1 qb0_1 q0_1 vdd vdd pb4 w=0.39u l=0.18u
Mn2_0_1 q0_1 qb0_1 0 0 nb4 w=0.51u l=0.18u
Mp2_0_1 q0_1 qb0_1 vdd vdd pb4 w=0.37u l=0.18u
Ma1_0_1 bl wl q0_1 0 nb4 w=0.3u l=0.18u
Ma2_0_1 blb wl qb0_1 0 nb4 w=0.3u l=0.18u
Mn1_0_2 qb0_2 q0_2 0 0 nb4 w=0.55u l=0.18u
Mp1_0_2 qb0_2 q0_2 vdd vdd pb4 w=0.39u l=0.18u
Mn2_0_2 q0_2 qb0_2 0 0 nb4 w=0.47u l=0.18u
Mp2_0_2 q0_2 qb0_2 vdd vdd pb4 w=0.44u l=0.18u
Ma1_0_2 bl wl q0_2 0 nb4 w=0.3u l=0.18u
Ma2_0_2 blb wl qb0_2 0 nb4 w=0.3u l=0.18u
Mn1_0_3 qb0_3 q0_3 0 0 nb4 w=0.57u l=0.18u
Mp1_0_3 qb0_3 q0_3 vdd vdd pb4 w=0.3u l=0.18u
Mn2_0_3 q0_3 qb0_3 0 0 nb4 w=0.61u l=0.18u
Mp2_0_3 q0_3 qb0_3 vdd vdd pb4 w=0.36u l=0.18u
Ma1_0_3 bl wl q0_3 0 nb4 w=0.3u l=0.18u
Ma2_0_3 blb wl qb0_3 0 nb4 w=0.3u l=0.18u
Mn1_1_0 qb1_0 q1_0 0 0 nb4 w=0.69u l=0.18u
Mp1_1_0 qb1_0 q1_0 vdd vdd pb4 w=0.28u l=0.18u
Mn2_1_0 q1_0 qb1_0 0 0 nb4 w=0.62u l=0.18u
Mp2_1_0 q1_0 qb1_0 vdd vdd pb4 w=0.31u l=0.18u
Ma1_1_0 bl wl q1_0 0 nb4 w=0.3u l=0.18u
Ma2_1_0 blb wl qb1_0 0 nb4 w=0.3u l=0.18u
Mn1_1_1 qb1_1 q1_1 0 0 nb4 w=0.56u l=0.18u
Mp1_1_1 qb1_1 q1_1 vdd vdd pb4 w=0.38u l=0.18u
Mn2_1_1 q1_1 qb1_1 0 0 nb4 w=0.53u l=0.18u
Mp2_1_1 q1_1 qb1_1 vdd vdd pb4 w=0.28u l=0.18u
Ma1_1_1 bl wl q1_1 0 nb4 w=0.3u l=0.18u
Ma2_1_1 blb wl qb1_1 0 nb4 w=0.3u l=0.18u
Mn1_1_2 qb1_2 q1_2 0 0 nb4 w=0.64u l=0.18u
Mp1_1_2 qb1_2 q1_2 vdd vdd pb4 w=0.44u l=0.18u
Mn2_1_2 q1_2 qb1_2 0 0 nb4 w=0.7u l=0.18u
Mp2_1_2 q1_2 qb1_2 vdd vdd pb4 w=0.39u l=0.18u
Ma1_1_2 bl wl q1_2 0 nb4 w=0.3u l=0.18u
Ma2_1_2 blb wl qb1_2 0 nb4 w=0.3u l=0.18u
Mn1_1_3 qb1_3 q1_3 0 0 nb4 w=0.44u l=0.18u
Mp1_1_3 qb1_3 q1_3 vdd vdd pb4 w=0.3u l=0.18u
Mn2_1_3 q1_3 qb1_3 0 0 nb4 w=0.69u l=0.18u
Mp2_1_3 q1_3 qb1_3 vdd vdd pb4 w=0.43u l=0.18u
Ma1_1_3 bl wl q1_3 0 nb4 w=0.3u l=0.18u
Ma2_1_3 blb wl qb1_3 0 nb4 w=0.3u l=0.18u
Mn1_2_0 qb2_0 q2_0 0 0 nb4 w=0.65u l=0.18u
Mp1_2_0 qb2_0 q2_0 vdd vdd pb4 w=0.31u l=0.18u
Mn2_2_0 q2_0 qb2_0 0 0 nb4 w=0.61u l=0.18u
Mp2_2_0 q2_0 qb2_0 vdd vdd pb4 w=0.29u l=0.18u
Ma1_2_0 bl wl q2_0 0 nb4 w=0.3u l=0.18u
Ma2_2_0 blb wl qb2_0 0 nb4 w=0.3u l=0.18u
Mn1_2_1 qb2_1 q2_1 0 0 nb4 w=0.46u l=0.18u
Mp1_2_1 qb2_1 q2_1 vdd vdd pb4 w=0.4u l=0.18u
Mn2_2_1 q2_1 qb2_1 0 0 nb4 w=0.44u l=0.18u
Mp2_2_1 q2_1 qb2_1 vdd vdd pb4 w=0.43u l=0.18u
Ma1_2_1 bl wl q2_1 0 nb4 w=0.3u l=0.18u
Ma2_2_1 blb wl qb2_1 0 nb4 w=0.3u l=0.18u
Mn1_2_2 qb2_2 q2_2 0 0 nb4 w=0.53u l=0.18u
Mp1_2_2 qb2_2 q2_2 vdd vdd pb4 w=0.32u l=0.18u
Mn2_2_2 q2_2 qb2_2 0 0 nb4 w=0.64u l=0.18u
Mp2_2_2 q2_2 qb2_2 vdd vdd pb4 w=0.31u l=0.18u
Ma1_2_2 bl wl q2_2 0 nb4 w=0.3u l=0.18u
Ma2_2_2 blb wl qb2_2 0 nb4 w=0.3u l=0.18u
Mn1_2_3 qb2_3 q2_3 0 0 nb4 w=0.43u l=0.18u
Mp1_2_3 qb2_3 q2_3 vdd vdd pb4 w=0.33u l=0.18u
Mn2_2_3 q2_3 qb2_3 0 0 nb4 w=0.5u l=0.18u
Mp2_2_3 q2_3 qb2_3 vdd vdd pb4 w=0.36u l=0.18u
Ma1_2_3 bl wl q2_3 0 nb4 w=0.3u l=0.18u
Ma2_2_3 blb wl qb2_3 0 nb4 w=0.3u l=0.18u
Mn1_3_0 qb3_0 q3_0 0 0 nb4 w=0.59u l=0.18u
Mp1_3_0 qb3_0 q3_0 vdd vdd pb4 w=0.36u l=0.18u
Mn2_3_0 q3_0 qb3_0 0 0 nb4 w=0.55u l=0.18u
Mp2_3_0 q3_0 qb3_0 vdd vdd pb4 w=0.45u l=0.18u
Ma1_3_0 bl wl q3_0 0 nb4 w=0.3u l=0.18u
Ma2_3_0 blb wl qb3_0 0 nb4 w=0.3u l=0.18u
Mn1_3_1 qb3_1 q3_1 0 0 nb4 w=0.54u l=0.18u
Mp1_3_1 qb3_1 q3_1 vdd vdd pb4 w=0.35u l=0.18u
Mn2_3_1 q3_1 qb3_1 0 0 nb4 w=0.43u l=0.18u
Mp2_3_1 q3_1 qb3_1 vdd vdd pb4 w=0.37u l=0.18u
Ma1_3_1 bl wl q3_1 0 nb4 w=0.3u l=0.18u
Ma2_3_1 blb wl qb3_1 0 nb4 w=0.3u l=0.18u
Mn1_3_2 qb3_2 q3_2 0 0 nb4 w=0.55u l=0.18u
Mp1_3_2 qb3_2 q3_2 vdd vdd pb4 w=0.34u l=0.18u
Mn2_3_2 q3_2 qb3_2 0 0 nb4 w=0.57u l=0.18u
Mp2_3_2 q3_2 qb3_2 vdd vdd pb4 w=0.41u l=0.18u
Ma1_3_2 bl wl q3_2 0 nb4 w=0.3u l=0.18u
Ma2_3_2 blb wl qb3_2 0 nb4 w=0.3u l=0.18u
Mn1_3_3 qb3_3 q3_3 0 0 nb4 w=0.58u l=0.18u
Mp1_3_3 qb3_3 q3_3 vdd vdd pb4 w=0.37u l=0.18u
Mn2_3_3 q3_3 qb3_3 0 0 nb4 w=0.63u l=0.18u
Mp2_3_3 q3_3 qb3_3 vdd vdd pb4 w=0.38u l=0.18u
Ma1_3_3 bl wl q3_3 0 nb4 w=0.3u l=0.18u
Ma2_3_3 blb wl qb3_3 0 nb4 w=0.3u l=0.18u
.model nb4 nmos level=54 version=4.8.2
+ mobmod=0 capmod=0 igcmod=0 igbmod=0 rdsmod=0 rbodymod=0 rgatemod=0 acnqsmod=0
+ toxe=4e-9 toxp=4e-9 toxm=4e-9 vth0=0.45 k1=0.4 k2=0 k3=0 w0=2.5e-6 u0=300 vsat=1.1e5
+ cgso=2e-10 cgdo=2e-10 cgbo=0 cf=0 cjs=1e-4 cjd=1e-4 cjswd=1e-10 cjswgd=1e-10
.model pb4 pmos level=54 version=4.8.2
+ mobmod=0 capmod=0 igcmod=0 igbmod=0 rdsmod=0 rbodymod=0 rgatemod=0 acnqsmod=0
+ toxe=4e-9 toxp=4e-9 toxm=4e-9 vth0=-0.45 k1=0.4 k2=0 k3=0 w0=2.5e-6 u0=100 vsat=1.0e5
+ cgso=2e-10 cgdo=2e-10 cgbo=0 cf=0 cjs=1e-4 cjd=1e-4 cjswd=1e-10 cjswgd=1e-10
.op
.end
