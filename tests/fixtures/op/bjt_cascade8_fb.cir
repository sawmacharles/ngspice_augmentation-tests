* op_bjt_cascade8_fb: eight direct-coupled common-emitter BJT stages with a global DC feedback resistor from the last collector to the first base
* Hard for DC OP because: total gain 1e8+ in a global loop; every stage swings from cutoff to saturation along the Newton path, wild Vbe values at the start
* (card #637 corpus, generated by tools/gen_opcorpus.py -- edit the generator, not the deck)
Vcc vcc 0 15
Vin in 0 0.6
Rin in b0 10k
Rc0 vcc c0 2000
Q0 c0 b0 e0 qn
Re0 e0 0 200
Rco0 c0 b1 1k
Rc1 vcc c1 2300
Q1 c1 b1 e1 qn
Re1 e1 0 250
Rco1 c1 b2 1k
Rc2 vcc c2 2600
Q2 c2 b2 e2 qn
Re2 e2 0 300
Rco2 c2 b3 1k
Rc3 vcc c3 2900
Q3 c3 b3 e3 qn
Re3 e3 0 350
Rco3 c3 b4 1k
Rc4 vcc c4 3200
Q4 c4 b4 e4 qn
Re4 e4 0 400
Rco4 c4 b5 1k
Rc5 vcc c5 3500
Q5 c5 b5 e5 qn
Re5 e5 0 450
Rco5 c5 b6 1k
Rc6 vcc c6 3800
Q6 c6 b6 e6 qn
Re6 e6 0 500
Rco6 c6 b7 1k
Rc7 vcc c7 4100
Q7 c7 b7 e7 qn
Re7 e7 0 550
Rfb c7 b0 200k
.model qn npn is=1e-16 bf=150 br=2 vaf=80 var=15 ikf=5m ikr=1m rb=100 rbm=30 re=2 rc=30
+ cje=0.5p cjc=0.3p tf=20p ne=1.5 ise=1e-15 nc=2 isc=1e-14
.op
.end
