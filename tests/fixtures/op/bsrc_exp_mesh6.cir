* op_bsrc_exp_mesh6: 6x6 resistive mesh (10 ohm links) with a B-source exponential diode at every node, fed by 20 V through 1 ohm
* Hard for DC OP because: 36 unlimited exponentials all coupled through a resistive mesh: the first step puts ~20 V on exp(V/26 mV) at the feed corner and propagates it
* (card #637 corpus, generated by tools/gen_opcorpus.py -- edit the generator, not the deck)
Vs top 0 20
Rs top m0_0 1
Rh0_0 m0_0 m0_1 10
Rv0_0 m0_0 m1_0 10
Bd0_0 m0_0 0 I=1e-15*(exp(V(m0_0)/0.026)-1)
Rh0_1 m0_1 m0_2 10
Rv0_1 m0_1 m1_1 10
Bd0_1 m0_1 0 I=1e-15*(exp(V(m0_1)/0.026)-1)
Rh0_2 m0_2 m0_3 10
Rv0_2 m0_2 m1_2 10
Bd0_2 m0_2 0 I=1e-15*(exp(V(m0_2)/0.026)-1)
Rh0_3 m0_3 m0_4 10
Rv0_3 m0_3 m1_3 10
Bd0_3 m0_3 0 I=1e-15*(exp(V(m0_3)/0.026)-1)
Rh0_4 m0_4 m0_5 10
Rv0_4 m0_4 m1_4 10
Bd0_4 m0_4 0 I=1e-15*(exp(V(m0_4)/0.026)-1)
Rv0_5 m0_5 m1_5 10
Bd0_5 m0_5 0 I=1e-15*(exp(V(m0_5)/0.026)-1)
Rh1_0 m1_0 m1_1 10
Rv1_0 m1_0 m2_0 10
Bd1_0 m1_0 0 I=1e-15*(exp(V(m1_0)/0.026)-1)
Rh1_1 m1_1 m1_2 10
Rv1_1 m1_1 m2_1 10
Bd1_1 m1_1 0 I=1e-15*(exp(V(m1_1)/0.026)-1)
Rh1_2 m1_2 m1_3 10
Rv1_2 m1_2 m2_2 10
Bd1_2 m1_2 0 I=1e-15*(exp(V(m1_2)/0.026)-1)
Rh1_3 m1_3 m1_4 10
Rv1_3 m1_3 m2_3 10
Bd1_3 m1_3 0 I=1e-15*(exp(V(m1_3)/0.026)-1)
Rh1_4 m1_4 m1_5 10
Rv1_4 m1_4 m2_4 10
Bd1_4 m1_4 0 I=1e-15*(exp(V(m1_4)/0.026)-1)
Rv1_5 m1_5 m2_5 10
Bd1_5 m1_5 0 I=1e-15*(exp(V(m1_5)/0.026)-1)
Rh2_0 m2_0 m2_1 10
Rv2_0 m2_0 m3_0 10
Bd2_0 m2_0 0 I=1e-15*(exp(V(m2_0)/0.026)-1)
Rh2_1 m2_1 m2_2 10
Rv2_1 m2_1 m3_1 10
Bd2_1 m2_1 0 I=1e-15*(exp(V(m2_1)/0.026)-1)
Rh2_2 m2_2 m2_3 10
Rv2_2 m2_2 m3_2 10
Bd2_2 m2_2 0 I=1e-15*(exp(V(m2_2)/0.026)-1)
Rh2_3 m2_3 m2_4 10
Rv2_3 m2_3 m3_3 10
Bd2_3 m2_3 0 I=1e-15*(exp(V(m2_3)/0.026)-1)
Rh2_4 m2_4 m2_5 10
Rv2_4 m2_4 m3_4 10
Bd2_4 m2_4 0 I=1e-15*(exp(V(m2_4)/0.026)-1)
Rv2_5 m2_5 m3_5 10
Bd2_5 m2_5 0 I=1e-15*(exp(V(m2_5)/0.026)-1)
Rh3_0 m3_0 m3_1 10
Rv3_0 m3_0 m4_0 10
Bd3_0 m3_0 0 I=1e-15*(exp(V(m3_0)/0.026)-1)
Rh3_1 m3_1 m3_2 10
Rv3_1 m3_1 m4_1 10
Bd3_1 m3_1 0 I=1e-15*(exp(V(m3_1)/0.026)-1)
Rh3_2 m3_2 m3_3 10
Rv3_2 m3_2 m4_2 10
Bd3_2 m3_2 0 I=1e-15*(exp(V(m3_2)/0.026)-1)
Rh3_3 m3_3 m3_4 10
Rv3_3 m3_3 m4_3 10
Bd3_3 m3_3 0 I=1e-15*(exp(V(m3_3)/0.026)-1)
Rh3_4 m3_4 m3_5 10
Rv3_4 m3_4 m4_4 10
Bd3_4 m3_4 0 I=1e-15*(exp(V(m3_4)/0.026)-1)
Rv3_5 m3_5 m4_5 10
Bd3_5 m3_5 0 I=1e-15*(exp(V(m3_5)/0.026)-1)
Rh4_0 m4_0 m4_1 10
Rv4_0 m4_0 m5_0 10
Bd4_0 m4_0 0 I=1e-15*(exp(V(m4_0)/0.026)-1)
Rh4_1 m4_1 m4_2 10
Rv4_1 m4_1 m5_1 10
Bd4_1 m4_1 0 I=1e-15*(exp(V(m4_1)/0.026)-1)
Rh4_2 m4_2 m4_3 10
Rv4_2 m4_2 m5_2 10
Bd4_2 m4_2 0 I=1e-15*(exp(V(m4_2)/0.026)-1)
Rh4_3 m4_3 m4_4 10
Rv4_3 m4_3 m5_3 10
Bd4_3 m4_3 0 I=1e-15*(exp(V(m4_3)/0.026)-1)
Rh4_4 m4_4 m4_5 10
Rv4_4 m4_4 m5_4 10
Bd4_4 m4_4 0 I=1e-15*(exp(V(m4_4)/0.026)-1)
Rv4_5 m4_5 m5_5 10
Bd4_5 m4_5 0 I=1e-15*(exp(V(m4_5)/0.026)-1)
Rh5_0 m5_0 m5_1 10
Bd5_0 m5_0 0 I=1e-15*(exp(V(m5_0)/0.026)-1)
Rh5_1 m5_1 m5_2 10
Bd5_1 m5_1 0 I=1e-15*(exp(V(m5_1)/0.026)-1)
Rh5_2 m5_2 m5_3 10
Bd5_2 m5_2 0 I=1e-15*(exp(V(m5_2)/0.026)-1)
Rh5_3 m5_3 m5_4 10
Bd5_3 m5_3 0 I=1e-15*(exp(V(m5_3)/0.026)-1)
Rh5_4 m5_4 m5_5 10
Bd5_4 m5_4 0 I=1e-15*(exp(V(m5_4)/0.026)-1)
Bd5_5 m5_5 0 I=1e-15*(exp(V(m5_5)/0.026)-1)
.op
.end
