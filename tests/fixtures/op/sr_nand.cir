* op_sr_nand: SR latch from two MOS (level 1) NAND2 gates with S=R=1 (hold)
* Hard for DC OP because: bistable hold state: two legitimate roots plus metastable; series stacks make each gate high-gain
* (card #637 corpus, generated by tools/gen_opcorpus.py -- edit the generator, not the deck)
Vdd vdd 0 1.8
Vs sb 0 1.8
Vr rb 0 1.8
* NAND(sb, qb) -> q
Mn1a q sb x1 0 n1 w=2u l=0.18u
Mn1b x1 qb 0 0 n1 w=2u l=0.18u
Mp1a q sb vdd vdd p1 w=2u l=0.18u
Mp1b q qb vdd vdd p1 w=2u l=0.18u
* NAND(rb, q) -> qb
Mn2a qb rb x2 0 n1 w=2u l=0.18u
Mn2b x2 q 0 0 n1 w=2u l=0.18u
Mp2a qb rb vdd vdd p1 w=2u l=0.18u
Mp2b qb q vdd vdd p1 w=2u l=0.18u
.model n1 nmos level=1 vto=0.5 kp=200u lambda=0.05 gamma=0.4 phi=0.7 cbd=5f cbs=5f
.model p1 pmos level=1 vto=-0.5 kp=70u lambda=0.06 gamma=0.4 phi=0.7 cbd=5f cbs=5f
.op
.end
