* op_bgr_cmos_opamp: Kuijk/Banba-style bandgap: PMOS mirror (3 branches), ideal tanh amplifier equalising the two branch voltages, 1x and 8x PNP (substrate-style) with R, output branch R3+PNP
* Hard for DC OP because: zero-current root (mirror off) plus the intended root; the amplifier drives the PMOS gate through a saturating tanh so Newton from 0 sits on a flat stretch
* (card #637 corpus, generated by tools/gen_opcorpus.py -- edit the generator, not the deck)
Vdd vdd 0 3.3
Bop pg 0 V=1.65*(1+tanh(500*(V(b)-V(a))))
Mp1 a pg vdd vdd p3 w=40u l=1u
Mp2 b pg vdd vdd p3 w=40u l=1u
Mp3 ref pg vdd vdd p3 w=40u l=1u
Q1 0 0 a qs
Rb b e2 6k
Q2 0 0 e2 qs area=8
R3 ref r3 2k
Q3 0 0 r3 qs
Rs ref 0 1e9
.model p3 pmos level=3 vto=-0.5 uo=130 tox=4e-9 theta=0.15 vmax=1.0e5 eta=0.02 kappa=0.1
+ gamma=0.5 phi=0.8 nsub=3e17 xj=0.15u ld=0.02u cgso=3e-10 cgdo=3e-10 cj=1e-3 mj=0.5 cjsw=2e-10
.model qs pnp is=1e-16 bf=50 vaf=50 rb=100 re=2
.op
.end
