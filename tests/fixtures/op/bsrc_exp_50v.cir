* op_bsrc_exp_50v: two B-source exponential diodes (Is=1e-15, VT=26 mV) in series, 50 V through 0.1 ohm
* Hard for DC OP because: no junction limiting exists for B-source exp(): the first step lands at tens of volts and exp(V/VT) overflows; the root has ~0.8 V across each device
* (card #637 corpus, generated by tools/gen_opcorpus.py -- edit the generator, not the deck)
V1 in 0 50
R1 in a 0.1
Bd1 a b I=1e-15*(exp((V(a)-V(b))/0.026)-1)
Bd2 b 0 I=1e-15*(exp(V(b)/0.026)-1)
.op
.end
