* op_zener_bv: 14 V source through 100 ohm into two series reverse-biased zeners (bv=6.8 V and 5.1 V)
* Hard for DC OP because: the OP lies in reverse breakdown, where the diode needs a large step from the reverse-leakage region (exponential knee at bv)
* (card #637 corpus, generated by tools/gen_opcorpus.py -- edit the generator, not the deck)
V1 in 0 14
R1 in a 100
D1 b a dz1
D2 0 b dz2
.model dz1 d is=1e-14 bv=6.8 ibv=5m rs=2
.model dz2 d is=1e-14 bv=5.1 ibv=5m rs=2
.op
.end
