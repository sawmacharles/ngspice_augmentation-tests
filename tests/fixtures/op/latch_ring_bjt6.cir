* op_latch_ring_bjt6: six cross-coupled BJT latches (200 uA tails) coupled in a ring by 30k/47k resistors
* Hard for DC OP because: 2^6 latch states plus metastable mixtures; the coupling is asymmetric so the all-metastable point is not a root and Newton must break symmetry
* (card #637 corpus, generated by tools/gen_opcorpus.py -- edit the generator, not the deck)
Vcc vcc 0 5
Rl0a vcc a0 5k
Rl0b vcc b0 5k
Qa0 a0 b0 e0 qn
Qb0 b0 a0 e0 qn
It0 e0 0 DC 200u
Rx0 a0 b1 30k
Ry0 b0 a1 47k
Rl1a vcc a1 5k
Rl1b vcc b1 5k
Qa1 a1 b1 e1 qn
Qb1 b1 a1 e1 qn
It1 e1 0 DC 200u
Rx1 a1 b2 30k
Ry1 b1 a2 47k
Rl2a vcc a2 5k
Rl2b vcc b2 5k
Qa2 a2 b2 e2 qn
Qb2 b2 a2 e2 qn
It2 e2 0 DC 200u
Rx2 a2 b3 30k
Ry2 b2 a3 47k
Rl3a vcc a3 5k
Rl3b vcc b3 5k
Qa3 a3 b3 e3 qn
Qb3 b3 a3 e3 qn
It3 e3 0 DC 200u
Rx3 a3 b4 30k
Ry3 b3 a4 47k
Rl4a vcc a4 5k
Rl4b vcc b4 5k
Qa4 a4 b4 e4 qn
Qb4 b4 a4 e4 qn
It4 e4 0 DC 200u
Rx4 a4 b5 30k
Ry4 b4 a5 47k
Rl5a vcc a5 5k
Rl5b vcc b5 5k
Qa5 a5 b5 e5 qn
Qb5 b5 a5 e5 qn
It5 e5 0 DC 200u
Rx5 a5 b0 30k
Ry5 b5 a0 47k
.model qn npn is=1e-16 bf=150 br=2 vaf=80 var=15 ikf=5m ikr=1m rb=100 rbm=30 re=2 rc=30
+ cje=0.5p cjc=0.3p tf=20p ne=1.5 ise=1e-15 nc=2 isc=1e-14
.op
.end
