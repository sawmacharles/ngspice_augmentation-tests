* op_betamult_nostart: CMOS beta-multiplier (Vt-independent) current reference WITHOUT startup
* Hard for DC OP because: has a degenerate zero-current solution; Newton from 0 is already at it, the intended root needs gmin/source stepping or a nodeset
* (card #637 corpus, generated by tools/gen_opcorpus.py -- edit the generator, not the deck)
Vdd vdd 0 3.3
* NMOS pair: M1 diode (1x), M2 (4x) with source resistor; PMOS mirror M3 (diode) / M4
M1 ng ng 0 0 n3 w=4u l=2u
M2 pg ng rs 0 n3 w=16u l=2u
Rs rs 0 5k
M3 pg pg vdd vdd p3 w=20u l=2u
M4 ng pg vdd vdd p3 w=20u l=2u
Mo out pg vdd vdd p3 w=20u l=2u
Rout out 0 20k
.model n3 nmos level=3 vto=0.5 uo=400 tox=4e-9 theta=0.15 vmax=1.5e5 eta=0.02 kappa=0.1
+ gamma=0.5 phi=0.8 nsub=3e17 xj=0.15u ld=0.02u cgso=3e-10 cgdo=3e-10 cj=1e-3 mj=0.5 cjsw=2e-10
.model p3 pmos level=3 vto=-0.5 uo=130 tox=4e-9 theta=0.15 vmax=1.0e5 eta=0.02 kappa=0.1
+ gamma=0.5 phi=0.8 nsub=3e17 xj=0.15u ld=0.02u cgso=3e-10 cgdo=3e-10 cj=1e-3 mj=0.5 cjsw=2e-10
.op
.end
