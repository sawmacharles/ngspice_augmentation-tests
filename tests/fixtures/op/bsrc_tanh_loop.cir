* op_bsrc_tanh_loop: tanh comparator (gain 1e4, +-5 V) closed through a divider: V(out) = 5*tanh(1e4*(1 - 0.5*V(out)))
* Hard for DC OP because: overall loop gain 5e3 around a single saturating nonlinearity: Newton overshoots between the rails; the solution is a 0.2 mV-wide window around out = 2 V
* (card #637 corpus, generated by tools/gen_opcorpus.py -- edit the generator, not the deck)
Vref ref 0 1
Bcmp out 0 V=5*tanh(1e4*(V(ref)-0.5*V(out)))
Rl out 0 1k
.op
.end
