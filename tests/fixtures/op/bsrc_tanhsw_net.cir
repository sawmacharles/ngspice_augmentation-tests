* op_bsrc_tanhsw_net: four-switch tanh network (H-bridge-like) with controls from a resistor ladder placed at the tanh midpoints, load across the bridge
* Hard for DC OP because: several tanh conductances simultaneously in their transition (mid-point gain); a high-gain nonlinear resistor network with 3 coupled nodes
* (card #637 corpus, generated by tools/gen_opcorpus.py -- edit the generator, not the deck)
.param gon=50 goff=1e-7 ksw=40
Vin vin 0 10
Vc c1 0 0.5
R1 c1 ca 100
R2 ca 0 100
Bs1 vin a I=(V(vin)-V(a))*({goff}+({gon}-{goff})*0.5*(1+tanh({ksw}*(V(ca)-0.25))))
Bs2 a 0 I=V(a)*({goff}+({gon}-{goff})*0.5*(1+tanh({ksw}*(0.25-V(ca)))))
Bs3 vin b I=(V(vin)-V(b))*({goff}+({gon}-{goff})*0.5*(1+tanh({ksw}*(0.25-V(ca)))))
Bs4 b 0 I=V(b)*({goff}+({gon}-{goff})*0.5*(1+tanh({ksw}*(V(ca)-0.25))))
Rload a b 2
Cx a 0 1p
Cy b 0 1p
.op
.end
