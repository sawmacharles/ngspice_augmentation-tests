* op_ring_even20_bsim3: 20-stage (even) BSIM3 inverter ring with slightly graded PMOS widths (breaks the symmetry of the metastable point)
* Hard for DC OP because: two stable alternating states plus a metastable one; with the asymmetry the all-equal start is not a root and 20 stages of gain must resolve consistently
* (card #637 corpus, generated by tools/gen_opcorpus.py -- edit the generator, not the deck)
Vdd vdd 0 1.8
M1n s1 s0 0 0 nb3 w=1u l=0.18u
M1p s1 s0 vdd vdd pb3 w=2.30u l=0.18u
M2n s2 s1 0 0 nb3 w=1u l=0.18u
M2p s2 s1 vdd vdd pb3 w=2.32u l=0.18u
M3n s3 s2 0 0 nb3 w=1u l=0.18u
M3p s3 s2 vdd vdd pb3 w=2.34u l=0.18u
M4n s4 s3 0 0 nb3 w=1u l=0.18u
M4p s4 s3 vdd vdd pb3 w=2.36u l=0.18u
M5n s5 s4 0 0 nb3 w=1u l=0.18u
M5p s5 s4 vdd vdd pb3 w=2.38u l=0.18u
M6n s6 s5 0 0 nb3 w=1u l=0.18u
M6p s6 s5 vdd vdd pb3 w=2.40u l=0.18u
M7n s7 s6 0 0 nb3 w=1u l=0.18u
M7p s7 s6 vdd vdd pb3 w=2.42u l=0.18u
M8n s8 s7 0 0 nb3 w=1u l=0.18u
M8p s8 s7 vdd vdd pb3 w=2.44u l=0.18u
M9n s9 s8 0 0 nb3 w=1u l=0.18u
M9p s9 s8 vdd vdd pb3 w=2.46u l=0.18u
M10n s10 s9 0 0 nb3 w=1u l=0.18u
M10p s10 s9 vdd vdd pb3 w=2.48u l=0.18u
M11n s11 s10 0 0 nb3 w=1u l=0.18u
M11p s11 s10 vdd vdd pb3 w=2.50u l=0.18u
M12n s12 s11 0 0 nb3 w=1u l=0.18u
M12p s12 s11 vdd vdd pb3 w=2.52u l=0.18u
M13n s13 s12 0 0 nb3 w=1u l=0.18u
M13p s13 s12 vdd vdd pb3 w=2.54u l=0.18u
M14n s14 s13 0 0 nb3 w=1u l=0.18u
M14p s14 s13 vdd vdd pb3 w=2.56u l=0.18u
M15n s15 s14 0 0 nb3 w=1u l=0.18u
M15p s15 s14 vdd vdd pb3 w=2.58u l=0.18u
M16n s16 s15 0 0 nb3 w=1u l=0.18u
M16p s16 s15 vdd vdd pb3 w=2.60u l=0.18u
M17n s17 s16 0 0 nb3 w=1u l=0.18u
M17p s17 s16 vdd vdd pb3 w=2.62u l=0.18u
M18n s18 s17 0 0 nb3 w=1u l=0.18u
M18p s18 s17 vdd vdd pb3 w=2.64u l=0.18u
M19n s19 s18 0 0 nb3 w=1u l=0.18u
M19p s19 s18 vdd vdd pb3 w=2.66u l=0.18u
M20n s0 s19 0 0 nb3 w=1u l=0.18u
M20p s0 s19 vdd vdd pb3 w=2.68u l=0.18u
.model nb3 nmos level=8 version=3.3.0 tox=4.1e-9 vth0=0.45 k1=0.55 k2=0 u0=300 vsat=1.0e5
+ nch=1.7e17 xj=1.5e-7 pclm=1.2 rdsw=150 cgso=3e-10 cgdo=3e-10 cj=1e-3 mj=0.5 cjsw=2e-10 nfactor=1.2 voff=-0.1
.model pb3 pmos level=8 version=3.3.0 tox=4.1e-9 vth0=-0.45 k1=0.55 k2=0 u0=90 vsat=0.9e5
+ nch=1.7e17 xj=1.5e-7 pclm=1.2 rdsw=300 cgso=3e-10 cgdo=3e-10 cj=1e-3 mj=0.5 cjsw=2e-10 nfactor=1.2 voff=-0.1
.op
.end
