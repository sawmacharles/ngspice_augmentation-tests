* card #682 fixture: the R4d dead-time PCM buck, every element wrapped in a .subckt (schematics v4 netlist). Same circuit, same .pss card; both must report the same
* stable spectral radius (s140: flat 0.994, subckt 1.267 "period-doubling" from a noisy Floquet column).
* s4 netlist -- pcm/r4d/testbench (testbench)

.include "@DEVLIB@"

Vin vin 0 DC 11
XHS vin sw dly_hs sw_smooth gon=70 goff=1e-6 k=150
XLS sw 0 dly_ls sw_smooth gon=70 goff=1e-6 k=150
XBODY 0 sw body_diode g=50 vf=0.6 kd=50
XCSW sw 0 capacitor c=100p ic=0
XRSENSE sw swcs resistor r=0.05
XL1 swcs swl inductor l=10u ic=0
XRDCR swl vout resistor r=10m
XRESR vout cx resistor r=10m
XCOUT cx 0 capacitor c=100u ic=0
XRLOAD vout 0 resistor r=3.3
Vprobe fbtop vout DC 0
XRA fbtop fbnode resistor r=2300
XRB fbnode 0 resistor r=1000
XR1IN fbnode compin resistor r=10k
Vrefsrc vrefnode 0 DC 1
XOTA vc vrefnode compin ota_gm gm=1000
XC1F compin vc capacitor c=25.21p ic=0
XR2F compin n2 resistor r=50.51k
XC2F n2 vc capacitor c=6.534n ic=0
XROA vc 0 resistor r=100
XCOA vc 0 capacitor c=100p ic=0
XCS vcs sw swcs csamp gain=8
XVSLOPE slope 0 vpulse v1=0 v2=0 td=0 tr=1.94u tf=60n pw=1n per=2u
XCMP reset_sig vcs slope vc cmp_sum k=100
XVSETP setp 0 vpulse v1=0 v2=1 td=0 tr=1n tf=1n pw=20n per=2u
XLATCH q setp reset_sig rs_latch cq=1p gset=1e-4 greset=1
XQBUF qbuf q vbuf
XQINV qbuf_inv q vinv
XRCHG_HS qbuf dly_hs resistor r=430
XDDIS_HS dly_hs dis_hs diode
XRDIS_HS dis_hs qbuf resistor r=60
XCDLY_HS dly_hs 0 capacitor c=100p ic=0
XRCHG_LS qbuf_inv dly_ls resistor r=430
XDDIS_LS dly_ls dis_ls diode
XRDIS_LS dis_ls qbuf_inv resistor r=60
XCDLY_LS dly_ls 0 capacitor c=100p ic=0

.ic v(vc)=0.6 v(compin)=1 v(fbnode)=1 v(fbtop)=0 v(vout)=0 v(q)=0
.ic v(dly_hs)=0 v(dly_ls)=0
.pss 500e3 1500e-6 vout 200 10 150 1e-6 method=shoot
.control
set num_threads=2
run
quit
.endc
.end
