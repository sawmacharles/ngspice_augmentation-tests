* xspice_dig_logic: digital/hybrid XSPICE models under .pss (card #551); STATEFILE is replaced by the test
Vclk clk 0 PULSE(0 1 0 5n 5n 495n 1u)
Vone one 0 DC 1
Vzero zero 0 DC 0
Abr [clk one zero] [dclk dhi dlo] adc1
.model adc1 adc_bridge(in_low=0.3 in_high=0.7)
At1 dhi dclk dlo dlo dq1 dq1n tf
At2 dhi dq1n dlo dlo dq2 dq2n tf
.model tf d_tff(clk_delay=1n set_delay=1n reset_delay=1n ic=0)
Ag1 [dq1 dq2] g1 m_and
Ag2 [dq1 dq2] g2 m_or
Ag3 [dq1 dq2] g3 m_nand
Ag4 [dq1 dq2] g4 m_nor
Ag5 [dq1 dq2] g5 m_xor
Ag6 [dq1 dq2] g6 m_xnor
Ag7 dq1 g7 m_inv
Ag8 dq2 g8 m_buf
.model m_and d_and(rise_delay=2n fall_delay=2n)
.model m_or d_or(rise_delay=2n fall_delay=2n)
.model m_nand d_nand(rise_delay=2n fall_delay=2n)
.model m_nor d_nor(rise_delay=2n fall_delay=2n)
.model m_xor d_xor(rise_delay=2n fall_delay=2n)
.model m_xnor d_xnor(rise_delay=2n fall_delay=2n)
.model m_inv d_inverter(rise_delay=2n fall_delay=2n)
.model m_buf d_buffer(rise_delay=2n fall_delay=2n)
Abo [g1 g2 g3 g4 g5 g6 g7 g8] [a0 a1 a2 a3 a4 a5 a6 a7] dac1
Rd0 a0 out 1k
Rd1 a1 out 1.3k
Rd2 a2 out 1.7k
Rd3 a3 out 2.2k
Rd4 a4 out 2.9k
Rd5 a5 out 3.7k
Rd6 a6 out 4.7k
Rd7 a7 out 6k
.model dac1 dac_bridge(out_low=0 out_high=1 t_rise=50n t_fall=50n)
Co out 0 100p
Rl out 0 10k
