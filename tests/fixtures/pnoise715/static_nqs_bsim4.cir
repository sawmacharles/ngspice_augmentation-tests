* pnoise715/static_nqs_bsim4.cir -- card #715 static check: BSIM4 common-source stage with a NON-QUASI-STATIC channel (trnqsmod={nq},
* W/L 40u/20u, relaxation time ~0.1 us) at a DC gate bias (Vin 0.9 V through Rs 1k, Rd 20k, Cl 50f): an LTI circuit; the PSS period comes
* from a 100 kHz clock on an unrelated net (clkgnd: a noiseless RC).  BSIM4's .noise/.ac do NOT carry the transient NQS model (b4acld.c
* isolates the charge node; only acnqsmod changes .ac), so the reference per generator is the .noise density times the ratio of the td .pac
* transfer (validated against a transient FRA, card #559) to the quasi-static .ac transfer.  Flicker off.
.param nq=1 ntn=1
.model nch4 nmos level=54 version=4.8.2 mobmod=0 capmod=2 igcmod=0 igbmod=0 rdsmod=0 rbodymod=0 rgatemod=0 acnqsmod=0 trnqsmod={nq}
+ toxe=3e-9 toxp=3e-9 toxm=3e-9 vth0=0.5 k1=0.4 k2=0 k3=0 w0=2.5e-6 u0=300 vsat=1.1e5 cgso=2e-10 cgdo=2e-10 cgbo=1e-11
+ cgsl=1e-10 cgdl=1e-10 cf=1e-10 cjs=1e-3 cjd=1e-3 cjswd=1e-10 cjswgd=1e-10 xpart=0 noia=0 noib=0 noic=0 ntnoi={ntn}
Vclk clk 0 PULSE(0 1 0 1n 1n 5u 10u)
Rclk clk clkgnd 1k noisy=0
Cclk clkgnd 0 1p
Vdd vdd 0 3
Vin in 0 DC 0.9 AC 1
Rs in g 1k
M1 out g 0 0 nch4 w=40u l=20u as=4p ad=4p ps=10u pd=10u
Rd vdd out 20k
Cl out 0 50f
.end
