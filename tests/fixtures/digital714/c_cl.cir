* 714 c_cl: closed-loop buck (type-III), digital clock only: d_osc -> dac_bridge discharges the analog ramp; ANALOG tanh comparator (no digital block in the control-to-duty path); loop broken by lgprobe XP
.param vin_v=12 fs=500k
.param lval=10u rdcr=10m cval=100u esrval=10m rload=3.3 ra=2300 rb=1000 vref=1
.param r1=10k r2=27.51k r3=101.7 c1=36.35p c2=2.299n c3=6.261n
.param vramp=2 gm_oa=1000 ro_oa=100 co_oa=100p
.param gon=100 goff=1e-6 ksw=30
.include ../../../stb/lgprobe.lib
Vin vin 0 DC {vin_v}
Bhs vin sw I = (V(vin)-V(sw)) * ({goff}+({gon}-{goff})*0.5*(1+tanh({ksw}*(V(pwm)-0.5))))
Bls sw 0 I = V(sw) * ({goff}+({gon}-{goff})*0.5*(1+tanh({ksw}*(0.5-V(pwm)))))
Csw sw 0 100p
L1 sw swl {lval} IC=0
Rdcr swl vout {rdcr}
Resr vout cx {esrval}
Cout cx 0 {cval} IC=0
Rload vout 0 {rload}
XP fbtop vout lgprobe
Ra fbtop fbnode {ra}
Rb fbnode 0 {rb}
Vrefsrc vrefnode 0 DC {vref}
Goa 0 opout vrefnode compin {gm_oa}
Roa opout 0 {ro_oa}
Coa opout 0 {co_oa}
R1in fbnode compin {r1}
R3in fbnode n3 {r3}
C3in n3 compin {c3}
C1f compin opout {c1}
R2f compin n2 {r2}
C2f n2 opout {c2}
Aosc nc clkd mosc
.model mosc d_osc(cntl_array=[0 1] freq_array=[{fs} {fs}] duty_cycle=0.02 init_phase=0 rise_delay=1n fall_delay=1n)
Vnc nc 0 DC 0.5
Adclk [clkd] [clka] dacclk
.model dacclk dac_bridge(out_low=0 out_high=1 t_rise=2n t_fall=2n)
Rclk clka 0 1Meg
* ramp: constant current into Cr (Vramp per period), discharged by a conductance while the clock pulse is high
Iramp 0 ramp DC {vramp*fs*10p}
Cr ramp 0 10p
Brst ramp 0 I = V(ramp) * 1m * V(clka)
Rr ramp 0 1G
Bcmp pwm 0 V = 0.5*(1+tanh(200*(V(opout)-V(ramp))))
.ic v(vout)=0 v(cx)=0 v(opout)=0.55 v(compin)=1 v(fbnode)=1 v(ramp)=0
