* 714 a_cl: closed-loop buck (type-III compensator), PWM from an XSPICE comparator: analog ramp (PULSE) vs compensator output -> adc_bridge -> d_buffer -> dac_bridge -> tanh switches; loop broken by lgprobe XP
.param vin_v=12 fs=500k tclk={1/fs}
.param lval=10u rdcr=10m cval=100u esrval=10m rload=3.3 ra=2300 rb=1000 vref=1
.param r1=10k r2=27.51k r3=101.7 c1=36.35p c2=2.299n c3=6.261n
.param vramp=2 gm_oa=1000 ro_oa=100 co_oa=100p
.param gon=100 goff=1e-6 ksw=30
.include ../../../stb/lgprobe.lib
Vin vin 0 DC {vin_v}
Bhs vin sw I = (V(vin)-V(sw)) * ({goff}+({gon}-{goff})*0.5*(1+tanh({ksw}*(V(pwm)-0.5))))
Bls sw 0 I = V(sw) * ({goff}+({gon}-{goff})*0.5*(1+tanh({ksw}*(0.5-V(pwm)))))
Csw sw 0 100p
L1 sw swl {lval} IC=0
Rdcr swl vout {rdcr}
Resr vout cx {esrval}
Cout cx 0 {cval} IC=0
Rload vout 0 {rload}
XP fbtop vout lgprobe
Ra fbtop fbnode {ra}
Rb fbnode 0 {rb}
Vrefsrc vrefnode 0 DC {vref}
Goa 0 opout vrefnode compin {gm_oa}
Roa opout 0 {ro_oa}
Coa opout 0 {co_oa}
R1in fbnode compin {r1}
R3in fbnode n3 {r3}
C3in n3 compin {c3}
C1f compin opout {c1}
R2f compin n2 {r2}
C2f n2 opout {c2}
Vramp ramp 0 PULSE(0 {vramp} 0 {0.98*tclk} {0.02*tclk} 1n {tclk})
Ecmp cmpv 0 opout ramp 1
Acmp [cmpv] [d1] adccmp
.model adccmp adc_bridge(in_low=0 in_high=0 rise_delay=1n fall_delay=1n)
Abuf d1 d2 dbuf
.model dbuf d_buffer(rise_delay=2n fall_delay=3n)
Adac [d2] [pwm] dacmod
.model dacmod dac_bridge(out_low=0 out_high=1 t_rise=5n t_fall=5n)
Rpw pwm 0 1Meg
.ic v(vout)=0 v(cx)=0 v(opout)=0.55 v(compin)=1 v(fbnode)=1
