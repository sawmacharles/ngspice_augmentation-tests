* xspice_an_square: XSPICE time source 'square' as the clock (driven=1) (card #551)
Vc c 0 DC 0
A1 c o1 m
.model m square(cntl_array=[-1 1] freq_array=[100k 100k] out_low=0 out_high=1 duty_cycle=0.3 rise_time=20n fall_time=20n)
Rl o1 out 1k
Co out 0 100p
