* pac_r6odm_ctrl2out.cir -- open-loop ASYNCHRONOUS buck: an ideal `sw` high-side switch (500 kHz, ramp vs control) and a CHARGED power
* diode (CJO + TT) as the freewheel path, so the switch node carries device-model charge next to the ideal switch's event
* (card #559 item 1; the case that was refused since #544).  THIS variant: the freewheel path is the drain-bulk junction of an NMOS held
* off (gate behind 1 kOhm to ground): its junction diode (is) and capacitance (cbd) and the gate-drain overlap capacitance cgdo load the
* switch node, and the gate node moves with it through cgdo (a capacitive divider the event's charge jump has to respect).  {csw} is a native capacitor at the switch node (0 = none: the
* node's only charge is then the diode's junction + diffusion charge, and the Rsnub/Csnub branch is the only native cap near it).
* Control-to-output sweep deck, test_pac.py style (no .control block, body only).
.param vin_v=12 fs=500k tclk={1/fs}
.param lval=10u rdcr=10m cval=100u esrval=10m rload=3.3
.param vramp=2 vctrl_dc=0.55
.param ronsw=10m roffsw=1Meg
.param csw=1n cjo=300p

Vin vin 0 DC {vin_v}

Shs vin sw ctrlnode ramp SWMOD
.model SWMOD SW(vt=0 vh=0.005 ron={ronsw} roff={roffsw})
M2 sw gm2 0 0 NM w=10m l=2u
Rg gm2 0 1k
.model NM nmos level=1 vto=3 kp=1e-5 lambda=0.0 is=1e-9 n=1.05 rs=0 rd=0 cbd={cjo} pb=0.7 mj=0.5 cgdo=1e-8 cgso=0 cgbo=0 tox=1e-7
Csw sw 0 {csw}
Rsnub sw nsnub 10
Csnub nsnub 0 1n
L1 sw swl {lval} IC=0
Rdcr swl vout {rdcr}
Resr vout cx {esrval}
Cout cx 0 {cval} IC=0
Rload vout 0 {rload}

Vramp ramp 0 PULSE(0 {vramp} 0 {0.97*tclk} {0.03*tclk} 1n {tclk})
Vctrl ctrlnode 0 DC {vctrl_dc} AC 1

.end
