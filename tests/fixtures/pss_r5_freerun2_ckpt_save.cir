* R5 free-running hysteretic buck -- checkpoint SAVE phase (card #489
* second pass, plan T6.2, tasks 1/2: independent cold-start .tran period
* and 20-phase orbit checks). Cold start (NOT seeded from the shooting
* engine), coarse tstep, settle to 460us -- see check_r5_freerun2_period()
* in tests/test_pss.py for why: settling at a coarse (fast) resolution and
* only paying for a fine resolution AFTER the checkpoint (in the restart
* deck) makes an otherwise very expensive fine-resolution measurement
* cheap, while still being a genuine, independent, cold-start .tran (the
* IC still comes from t=0, never from PSS-FREERUN's own converged x0).
* Needs a fork build with savestate/loadstate (docs/checkpoint.md, card
* #472) -- same NGSPICE build this project's other free-running checks
* need anyway (method=shoot trigger=).
.param vin_v=12 vref=3.3 hys=0.02
.param lval=10u rdcr=10m cval=100u esrval=10m rload=3.3
.param gon=100 goff=1e-6 ksw=30 khys=200
.param cq=1p kdrive=1e-3

Vin vin 0 DC {vin_v}
.ic v(q)=0.5

Bhs vin sw I = (V(vin)-V(sw)) * ({goff}+({gon}-{goff})*0.5*(1+tanh({ksw}*(V(q)-0.5))))
Bls sw 0   I = V(sw)              * ({goff}+({gon}-{goff})*0.5*(1+tanh({ksw}*(0.5-V(q)))))
Csw sw 0 100p

L1 sw swl {lval} IC=0
Rdcr swl vout {rdcr}
Resr vout cx {esrval}
Cout cx 0 {cval} IC=0
Rload vout 0 {rload}

Cq q 0 {cq}
Bq q 0 I = {kdrive}*(V(q) - 0.5*(1-tanh({khys}*(V(vout)-({vref}-{hys}/2+{hys}*V(q))))))

.control
set filetype=ascii
tran 10n 460u 0 uic
savestate ckpt.bin
.endc
.end
