* tr_ind_interrupt -- inductor current interrupted by a switch without a clamp: 1 mH carrying 10 A, SW opens (RON 1 mOhm, ROFF 1e12) into 1 fF: dI/dt energy has nowhere to go (kV-scale spike)
* stock: completes at default settings
* probe: v(b) l1#branch
.model swi SW(RON=1m ROFF=1e12 VT=2.5 VH=0.1)
V1 in 0 DC 10
Vg g 0 PULSE(5 0 10u 10n 10n 1 2)
R1 in a 1m
L1 a b 1m IC=10
S1 b 0 g 0 swi
Csw b 0 1f
.tran 10n 30u uic
.end
