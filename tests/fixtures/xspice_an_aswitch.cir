* xspice_an_aswitch: XSPICE code model 'aswitch' in a periodic circuit (card #551); tests/test_xspice.py appends .options/.pss/.tran
Vin in 0 SIN(0.3 0.8 100k)
Vc c 0 DC 1.0
A1 c %gd(in o1) m
.model m aswitch(cntl_off=0.0 cntl_on=1.0 r_off=1e6 r_on=100 log=FALSE)
Rl o1 out 1k
Co out 0 100p
