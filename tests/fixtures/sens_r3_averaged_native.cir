* R3 voltage-mode buck, AVERAGED linear small-signal stand-in, DETUNED compensator --
* NATIVE .stb probe variant of tests/fixtures/compopt_r3_averaged_detuned.cir for
* adjoint sensitivity (card #475, plan T10.7, 2026-09-29). Same topology/values;
* the lgprobe.lib subcircuit is replaced by a plain 0V V-source in series with the
* same wire (native .stb's own probe convention), so this deck needs no .include
* and runs on the private-fork native .stb build only. See
* compopt_r3_averaged_detuned.cir's own header for the averaging derivation and
* the SWEEP NOTE (fstart as low as 500 Hz avoids a near-integrator low-frequency
* false-positive on this exact compensator family).
.param vin_v=12 fs=500k
.param lval=10u rdcr=10m cval=100u esrval=10m rload=3.3
.param ra=2300 rb=1000 vref=1
.param r1=10k r2=100k r3=101.7 c1=36.35p c2=0.3n c3=6.261n
.param vramp=2
.param gm_oa=1000 ro_oa=100 co_oa=100p

Vin vin 0 DC {vin_v}
Eavg sw 0 opout 0 {vin_v/vramp}

L1 sw swl {lval} IC=0
Rdcr swl vout {rdcr}
Resr vout cx {esrval}
Cout cx 0 {cval}
Rload vout 0 {rload}

Vprobe fbtop vout DC 0
Ra fbtop fbnode {ra}
Rb fbnode 0 {rb}

Vrefsrc vrefnode 0 DC {vref}
Goa 0 opout vrefnode compin {gm_oa}
Roa opout 0 {ro_oa}
Coa opout 0 {co_oa}

R1in fbnode compin {r1}
R3in fbnode n3 {r3}
C3in n3 compin {c3}
C1f compin opout {c1}
R2f compin n2 {r2}
C2f n2 opout {c2}
.end
