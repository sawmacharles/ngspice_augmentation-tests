* pnoise_track_hold_bsim4.cir -- card #544: same with a BSIM4 switch (capmod 2, flicker off), model card from tests/test_pac_charge.py
.param rtrack=50k c=50p fclk=10k duty=0.2
Vin vin 0 DC 1 SIN(1 0.05 {fclk} 0 0)
Rtrack vin trnode {rtrack}
Vclk clk 0 PULSE(0 3 0 5n 5n {duty*(1/fclk)} {1/fclk})
.model nsw nmos level=54 version=4.8.2 mobmod=0 capmod=2 igcmod=0 igbmod=0 rdsmod=0 rbodymod=0 rgatemod=0 acnqsmod=0 toxe=3e-9 toxp=3e-9 toxm=3e-9 vth0=0.5 k1=0.4 k2=0 k3=0 w0=2.5e-6 u0=300 vsat=1.1e5 cgso=2e-10 cgdo=2e-10 cgbo=1e-11 cgsl=1e-10 cgdl=1e-10 cf=1e-10 xpart=0 noia=0 noib=0 noic=0
Msw trnode clk vout 0 nsw w=8u l=0.5u
C1 vout 0 {c}
.end
