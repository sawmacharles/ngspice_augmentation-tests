* R9 digitally controlled synchronous buck from XSPICE primitives (ngspice_augmentation, card #551, 2026-10-02) -- GENERATED by tools/gen_r9.py
* nbits=7 div=600 bin=0.003 (fb volts) initial duty 0.2745 (code 35)
.param vin_v=12 fs=500k tclk={1/fs}
.param lval=10u rdcr=10m cval=100u esrval=10m rload=3.3 ra=2300 rb=1000 vref=1 bin=0.003
.param gon=100 goff=1e-6 ksw=30
Vin vin 0 DC {vin_v}
* power stage (R3): smooth switches driven by the DPWM node pwm (0/1 V)
Bhs vin sw I = (V(vin)-V(sw)) * ({goff}+({gon}-{goff})*0.5*(1+tanh({ksw}*(V(pwm)-0.5))))
Bls sw 0 I = V(sw) * ({goff}+({gon}-{goff})*0.5*(1+tanh({ksw}*(0.5-V(pwm)))))
Csw sw 0 100p
L1 sw swl {lval} IC=0
Rdcr swl vout {rdcr}
Resr vout cx {esrval}
Cout cx 0 {cval} IC=0
Rload vout 0 {rload}
.include ../../stb/lgprobe.lib
XP fbtop vout lgprobe
Ra fbtop fbnode {ra}
Rb fbnode 0 {rb}
* clock: native source -> digital clock; falling-edge sampling clock
Vclk clk 0 PULSE(0 1 0 5n 5n {0.5*tclk-5n} {tclk})
Vone one 0 DC 1
Vzero zero 0 DC 0
Abr [clk one zero] [dclk dhi dlo] adcclk
.model adcclk adc_bridge(in_low=0.3 in_high=0.7 rise_delay=1n fall_delay=1n)
Ainv dclk dclkn minv
.model minv d_inverter(rise_delay=1n fall_delay=1n)
* ADC: zero-error-bin comparators on the feedback node
Ehi ehi 0 value = {V(fbnode)-vref-bin}
Elo elo 0 value = {vref-bin-V(fbnode)}
Aadc [ehi elo] [chi clo] adccmp
.model adccmp adc_bridge(in_low=-0.2u in_high=0.2u rise_delay=1n fall_delay=1n)
Adh chi dclkn dlo dlo shi shin mdf
Adl clo dclkn dlo dlo slo slon mdf
.model mdf d_dff(clk_delay=2n set_delay=1n reset_delay=1n ic=0)
* slow enable clock
Afd dclk dslow mfd
.model mfd d_fdiv(div_factor=600 high_cycles=300 i_count=0 rise_delay=2n fall_delay=2n)
* up/down counter: lo -> count up, hi -> count down
Aen [shi slo] en mor
.model mor d_or(rise_delay=1n fall_delay=1n)
.model mand d_and(rise_delay=1n fall_delay=1n)
.model mbuf d_buffer(rise_delay=1n fall_delay=1n)
Atf0 t0 dslow dlo dlo b0 bn0 mtf0
.model mtf0 d_tff(clk_delay=2n set_delay=1n reset_delay=1n ic=1)
Atf1 t1 dslow dlo dlo b1 bn1 mtf1
.model mtf1 d_tff(clk_delay=2n set_delay=1n reset_delay=1n ic=1)
Atf2 t2 dslow dlo dlo b2 bn2 mtf2
.model mtf2 d_tff(clk_delay=2n set_delay=1n reset_delay=1n ic=0)
Atf3 t3 dslow dlo dlo b3 bn3 mtf3
.model mtf3 d_tff(clk_delay=2n set_delay=1n reset_delay=1n ic=0)
Atf4 t4 dslow dlo dlo b4 bn4 mtf4
.model mtf4 d_tff(clk_delay=2n set_delay=1n reset_delay=1n ic=0)
Atf5 t5 dslow dlo dlo b5 bn5 mtf5
.model mtf5 d_tff(clk_delay=2n set_delay=1n reset_delay=1n ic=1)
Atf6 t6 dslow dlo dlo b6 bn6 mtf6
.model mtf6 d_tff(clk_delay=2n set_delay=1n reset_delay=1n ic=0)
* T0 = en;  T_i = lo & AND(b_0..b_i-1)  |  hi & AND(~b_0..~b_i-1)
Ab0 en t0 mbuf
Acu1 b0 cu1 mbuf
Acd1 bn0 cd1 mbuf
Atu1 [slo cu1] tu1 mand
Atd1 [shi cd1] td1 mand
Ato1 [tu1 td1] t1 mor
Acu2 [b0 b1] cu2 mand
Acd2 [bn0 bn1] cd2 mand
Atu2 [slo cu2] tu2 mand
Atd2 [shi cd2] td2 mand
Ato2 [tu2 td2] t2 mor
Acu3 [b0 b1 b2] cu3 mand
Acd3 [bn0 bn1 bn2] cd3 mand
Atu3 [slo cu3] tu3 mand
Atd3 [shi cd3] td3 mand
Ato3 [tu3 td3] t3 mor
Acu4 [b0 b1 b2 b3] cu4 mand
Acd4 [bn0 bn1 bn2 bn3] cd4 mand
Atu4 [slo cu4] tu4 mand
Atd4 [shi cd4] td4 mand
Ato4 [tu4 td4] t4 mor
Acu5 [b0 b1 b2 b3 b4] cu5 mand
Acd5 [bn0 bn1 bn2 bn3 bn4] cd5 mand
Atu5 [slo cu5] tu5 mand
Atd5 [shi cd5] td5 mand
Ato5 [tu5 td5] t5 mor
Acu6 [b0 b1 b2 b3 b4 b5] cu6 mand
Acd6 [bn0 bn1 bn2 bn3 bn4 bn5] cd6 mand
Atu6 [slo cu6] tu6 mand
Atd6 [shi cd6] td6 mand
Ato6 [tu6 td6] t6 mor
* DPWM: code -> analog (0..1) -> d_pwm -> drive node
Adac [b6 b5 b4 b3 b2 b1 b0] [code] dacm
.model dacm dac_bridge(out_low=0 out_high=1 t_rise=1n t_fall=1n)
Apwm code dpw mpwm
.model mpwm d_pwm(cntl_array=[0 1] dc_array=[0.01 0.99] frequency={fs} init_phase=0 rise_delay=1n fall_delay=1n)
Adrv [dpw] [pwm] dacd
.model dacd dac_bridge(out_low=0 out_high=1 t_rise=5n t_fall=5n)
Rpw pwm 0 1Meg
.ic v(vout)=0 v(cx)=0

.end
