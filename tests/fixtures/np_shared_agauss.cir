* card #482 regression: the EXISTING per-use agauss() behaviour of a plain
* (non-once) .param must be unchanged by the draw-once patch -- two
* resistors referencing the SAME plain ".param proc_off = agauss(...)"
* must still get INDEPENDENT draws in one run (card #473's own finding,
* docs/mc.md). This is the exact reproducer from docs/mc.md.
.param proc_off = agauss(0, 10m, 3)
.param a = proc_off
.param b = proc_off
R1 1 0 R='1k*(1+proc_off)'
R2 2 0 R='1k*(1+proc_off)'
R5 5 0 R='1k*(1+a)'
R6 6 0 R='1k*(1+b)'
.control
op
print @r1[resistance] @r2[resistance] @r5[resistance] @r6[resistance]
.endc
.end
