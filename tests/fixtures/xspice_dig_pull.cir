* xspice_dig_pull: d_pullup / d_pulldown constants in the logic (card #551)
Vclk clk 0 PULSE(0 1 0 5n 5n 495n 1u)
Vone one 0 DC 1
Vzero zero 0 DC 0
Abr [clk one zero] [dclk dhi dlo] adc1
.model adc1 adc_bridge(in_low=0.3 in_high=0.7)
At1 dhi dclk dlo dlo dq1 dq1n tf
At2 dhi dq1n dlo dlo dq2 dq2n tf
.model tf d_tff(clk_delay=1n set_delay=1n reset_delay=1n ic=0)
Apu pu1 mpu
.model mpu d_pullup(load=1p)
Apd pd1 mpd
.model mpd d_pulldown(load=1p)
Ag1 [dq1 pu1] g1 m_and
Ag2 [dq2 pd1] g2 m_or
.model m_and d_and(rise_delay=2n fall_delay=2n)
.model m_or d_or(rise_delay=2n fall_delay=2n)
Abo [g1 g2] [a0 a1] dac1
Rd0 a0 out 1k
Rd1 a1 out 2.2k
.model dac1 dac_bridge(out_low=0 out_high=1 t_rise=50n t_fall=50n)
Co out 0 100p
Rl out 0 10k
