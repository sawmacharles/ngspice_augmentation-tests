* xspice_an_oneshot: XSPICE code model 'oneshot' in a periodic circuit (card #551); tests/test_xspice.py appends .options/.pss/.tran
Vin in 0 PULSE(0 1 0 100n 100n 4.9u 10u)
Vc c 0 DC 1.0
Vclr z 0 DC 0
A1 in c z o1 m
.model m oneshot(clk_trig=0.5 pos_edge_trig=TRUE cntl_array=[0 1] pw_array=[1u 2u] out_low=0 out_high=1)
Rl o1 out 1k
Co out 0 100p
