* r7_tran -- card #539 fixture. tight reference .tran (reltol 1e-5), last periods = settled orbit
* Body copied verbatim from refs/ (lgprobe include path fixed for tests/fixtures/); outputs under ~/Work/data/ngspice_augmentation/539/test.
* R7 transistor-level synchronous buck (ngspice_augmentation, card #539, 2026-10-01)
* run: ngspice -b r7_bsim_buck.cir  (cwd = refs/; writes under ~/Work/data/ngspice_augmentation/539/)
*
* Everything that conducts or decides is a BSIM4 (level=54, v4.8.2) MOSFET; only the references (Vin, vref, ramp,
* the OTA bias current), the passives and the Tian probe are ideal. Model cards are copied verbatim from cards
* already in this repository (power: tests/fixtures/loss_bsim4_buck.cir; logic and analog: bench/decks/
* d_analog_block.cir) under new names nchp/pchp and nch4/pch4. Junction areas/perimeters (as ad ps pd) are instance
* parameters here so the drain/source-bulk junction caps and body diodes exist (the cards give cjs=cjd, jss default;
* with as=ad=0 the body diode would be a 1e-14 A floor).
*
* TOPOLOGY (single 5 V rail `vin` feeds power stage, drivers and control; 5 V -> 1.46 V, 2 A, fs 500 kHz)
*   power:  Mhs PMOS 60 mm/0.35 um (vin->sw), Mls NMOS 40 mm/0.35 um (sw->0), L 2.2 uH (DCR 10 mOhm in series with Rdcr),
*           Cout 100 uF, ESR 80 mOhm (ESR zero ~20 kHz gives the type-II loop its phase), Rload 0.75 Ohm.
*   PWM:    NMOS 5T diff pair + PMOS mirror comparator (opout vs a 1.2..2.2 V ramp, independent PULSE source),
*           two BSIM4 inverters for a rail-to-rail pwm (high = HS on).
*   dead time: cross-coupled NOR pair, each NOR input fed back through a 6-inverter delay (3 pF per stage, gate dead time 18.8 ns) of the other side's
*           output (hs_on = NOR(!pwm, ls_on delayed), ls_on = NOR(pwm, hs_on delayed)): break-before-make
*           generated by gate delays, not by an RC.
*   drivers: tapered inverter chains (5 stages to the PMOS gate, 4 stages to the NMOS gate; fanout ~4.5-5).
*   error amp: PMOS-input 5T OTA (gm ~1 mS, ro ~49 kOhm), inverting from fb to opout (fb = inn, vref = inp: opout falls
*           when Vout rises, card #519), type-II compensation Rc 2k + Cc 6n in series to ground, Cp 20p.
*   loop probe: XP (lgprobe) in the divider path, same placement/orientation as R3.
*
* MEASURED (s88, reltol 1e-5): Vout 1.45940 V, ripple 70.15 mV, il 1.9464 A (pp 0.970), fsw 500.000 kHz, efficiency 92.9 %,
* FRA loop crossover 26.19 kHz, PM 53.5 deg. Full tables, traps and the engine bugs found with it: refs/README.md "R7 / R7p".
* Hooks used by the fixtures (all DC 0 here, harmless): none in this file; fixtures splice Vctrl/Iinj/Vprobe (tests/fixtures/r7_*.cir).
* Traps: (1) NMOS bias mirror needs the current INTO the diode node (Ibc vin bcb), not out of it; (2) BSIM4 W of 5 mm
* gives Ron ~2 Ohm (u0 is cm2/Vs): the power FETs need 40-60 mm; (3) .pss at default reltol 1e-3 stalls at residual 4e-4, use
* .options reltol=1e-4; (4) some tight option combinations abort .tran at the ramp source (bugs/bug2_tight_reltol).
.param vin_v=5 fs=500k tclk={1/fs}
.param lval=2.2u rdcr=10m cval=100u esrval=80m rload=0.75
.param ra=1.5k rb=1k vref=0.6
.param rc=2k cc=6n cp=20p ibias=20u
.param vrlo=1.2 vrhi=2.2
.param iload=2 vout_ic=1.5 op_ic=1.4

.model nch4 nmos level=54 version=4.8.2
+ mobmod=0 capmod=0 igcmod=0 igbmod=0 rdsmod=0 rbodymod=0 rgatemod=0 acnqsmod=0
+ toxe=3e-9 toxp=3e-9 toxm=3e-9
+ vth0=0.5 k1=0.4 k2=0 k3=0 w0=2.5e-6
+ u0=300 vsat=1.1e5
+ cgso=2e-10 cgdo=2e-10 cgbo=0 cgsl=0 cgdl=0
+ cf=0 cjs=1e-4 cjd=1e-4 cjswd=1e-10 cjswgd=1e-10
.model pch4 pmos level=54 version=4.8.2
+ mobmod=0 capmod=0 igcmod=0 igbmod=0 rdsmod=0 rbodymod=0 rgatemod=0 acnqsmod=0
+ toxe=3e-9 toxp=3e-9 toxm=3e-9
+ vth0=-0.5 k1=0.4 k2=0 k3=0 w0=2.5e-6
+ u0=100 vsat=1.0e5
+ cgso=2e-10 cgdo=2e-10 cgbo=0 cgsl=0 cgdl=0
+ cf=0 cjs=1e-4 cjd=1e-4 cjswd=1e-10 cjswgd=1e-10
.model nchp nmos level=54 version=4.8.2
+ mobmod=0 capmod=0 igcmod=0 igbmod=0 rdsmod=0 rbodymod=0 rgatemod=0 acnqsmod=0
+ toxe=3e-9 toxp=3e-9 toxm=3e-9
+ vth0=1.0 k1=0.4 k2=0 k3=0 w0=2.5e-6
+ u0=300 vsat=1.1e5
.model pchp pmos level=54 version=4.8.2
+ mobmod=0 capmod=0 igcmod=0 igbmod=0 rdsmod=0 rbodymod=0 rgatemod=0 acnqsmod=0
+ toxe=3e-9 toxp=3e-9 toxm=3e-9
+ vth0=-1.0 k1=0.4 k2=0 k3=0 w0=2.5e-6
+ u0=100 vsat=0.8e5

* ---- gates (w in metres via u suffix; junction geometry follows w) ----
.subckt inv in out vdd wn=2u wp=5u
Mn out in 0 0 nch4 w={wn} l=0.5u as={wn*1u} ad={wn*1u} ps={2*wn+2u} pd={2*wn+2u}
Mp out in vdd vdd pch4 w={wp} l=0.5u as={wp*1u} ad={wp*1u} ps={2*wp+2u} pd={2*wp+2u}
.ends inv
.subckt nor2 a b y vdd
Mp1 n1 a vdd vdd pch4 w=10u l=0.5u as=10p ad=10p ps=22u pd=22u
Mp2 y b n1 vdd pch4 w=10u l=0.5u as=10p ad=10p ps=22u pd=22u
Mn1 y a 0 0 nch4 w=2u l=0.5u as=2p ad=2p ps=6u pd=6u
Mn2 y b 0 0 nch4 w=2u l=0.5u as=2p ad=2p ps=6u pd=6u
.ends nor2
* delay: six minimum inverters, 100 fF per stage (sets the dead time)
.subckt dly6 in out vdd
X1 in d1 vdd inv
C1 d1 0 {cdl}
X2 d1 d2 vdd inv
C2 d2 0 {cdl}
X3 d2 d3 vdd inv
C3 d3 0 {cdl}
X4 d3 d4 vdd inv
C4 d4 0 {cdl}
X5 d4 d5 vdd inv
C5 d5 0 {cdl}
X6 d5 out vdd inv
.ends dly6
.param cdl=3p

Vin vin 0 DC {vin_v}
.ic v(opout)={op_ic} v(vout)={vout_ic}

* ---- power stage ----
Mhs sw ghs vin vin pchp w=60000u l=0.35u as=1.2e-7 ad=1.2e-7 ps=0.12 pd=0.12
Mls sw gls 0 0 nchp w=40000u l=0.35u as=8e-8 ad=8e-8 ps=0.08 pd=0.08
L1 sw swl {lval} IC={iload}
Rdcr swl vout {rdcr}
Resr vout cx {esrval}
Cout cx 0 {cval} IC={vout_ic}
Rload vout 0 {rload}

* ---- feedback, error amplifier (PMOS-input 5T OTA), compensation ----
.include ../../stb/lgprobe.lib
XP fbtop vout lgprobe
Ra fbtop fbnode {ra}
Rb fbnode 0 {rb}
Vrefsrc vrefnode 0 DC {vref}
Ib vb 0 DC {ibias}
Mref vb vb vin vin pch4 w=10u l=1u as=10p ad=10p ps=22u pd=22u
Mt tail vb vin vin pch4 w=50u l=1u as=50p ad=50p ps=102u pd=102u
M1 d1 vrefnode tail vin pch4 w=50u l=0.5u as=50p ad=50p ps=102u pd=102u
M2 opout fbnode tail vin pch4 w=50u l=0.5u as=50p ad=50p ps=102u pd=102u
M3 d1 d1 0 0 nch4 w=20u l=1u as=20p ad=20p ps=42u pd=42u
M4 opout d1 0 0 nch4 w=20u l=1u as=20p ad=20p ps=42u pd=42u
Rcomp opout ccn {rc}
Ccomp ccn 0 {cc} IC={op_ic}
Cpar opout 0 {cp}

* ---- PWM comparator (NMOS pair, PMOS mirror) + ramp ----
Vramp ramp 0 PULSE({vrlo} {vrhi} 0 {0.97*tclk} {0.03*tclk} 1n {tclk})
Ibc vin bcb DC 40u
Mbr bcb bcb 0 0 nch4 w=10u l=1u as=10p ad=10p ps=22u pd=22u
Mct ctail bcb 0 0 nch4 w=20u l=1u as=20p ad=20p ps=42u pd=42u
Mc1 cd1 opout ctail 0 nch4 w=20u l=0.5u as=20p ad=20p ps=42u pd=42u
Mc2 cout ramp ctail 0 nch4 w=20u l=0.5u as=20p ad=20p ps=42u pd=42u
Mc3 cd1 cd1 vin vin pch4 w=20u l=1u as=20p ad=20p ps=42u pd=42u
Mc4 cout cd1 vin vin pch4 w=20u l=1u as=20p ad=20p ps=42u pd=42u
Xcp1 cout cpb vin inv
Xcp2 cpb pwm vin inv
Xpb pwm pwm_b vin inv

* ---- dead-time generator (cross-coupled NORs with delayed feedback) ----
Xnh pwm_b ls_d hs_on vin nor2
Xnl pwm hs_d ls_on vin nor2
Xdh hs_on hs_d vin dly6
Xdl ls_on ls_d vin dly6

* ---- gate drivers: tapered chains ----
Xh1 hs_on h1 vin inv wn=2u wp=5u
Xh2 h1 h2 vin inv wn=11u wp=27u
Xh3 h2 h3 vin inv wn=60u wp=150u
Xh4 h3 h4 vin inv wn=330u wp=830u
Xh5 h4 ghs vin inv wn=1815u wp=4540u
Xl1 ls_on l1 vin inv wn=2u wp=5u
Xl2 l1 l2 vin inv wn=16u wp=40u
Xl3 l2 l3 vin inv wn=130u wp=320u
Xl4 l3 gls vin inv wn=1000u wp=2500u

.options reltol=1e-5
.control
set filetype=ascii
set wr_singlescale
set wr_vecnames
set numdgt=15
tran 1n 500u 0 uic
linearize v(vout) v(opout) v(sw) i(L1) v(ghs) v(gls) v(pwm)
wrdata ~/Work/data/ngspice_augmentation/539/test/tran.txt v(vout) v(opout) v(sw) i(L1) v(ghs) v(gls) v(pwm)
.endc
.end
