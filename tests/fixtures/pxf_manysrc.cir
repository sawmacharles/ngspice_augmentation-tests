* pxf_manysrc.cir -- card #504: many-source timing fixture for the true
* adjoint `.pxf ... adjoint=1` engine. Same PSS-on-an-unrelated-clock
* pattern as pxf_lti.cir (card #499) -- the small-signal network under
* test is genuinely LTI (no switches), so timing here isolates the
* adjoint engine's own per-source cost from any switching/saltation
* concern. Vin (voltage) plus 50 independent small current injectors
* I1..I50, ALL DC 0, ALL injecting directly at node 'out' -- deliberately
* simple (every Ik has the identical transfer function to 'out', just a
* different injection point in the SOURCE LIST) since this fixture's own
* job is measuring wall time vs source count (test_pxf.py's
* check_pxf_adjoint_timing()), not exercising varied topology -- the
* three test_pxf.py CORRECTNESS fixtures (pxf_lti/pxf_r2_switched_rc/
* pac_r3_ctrl2out) already cover that. sources="Vin" sources="I1" ...
* sources="Ik" selects the first N-1 injectors + Vin for N in {2,10,50}.
Vclk clk 0 PULSE(0 1 0 1n 1n 5u 10u)
Rclk clk clkgnd 1k
Cclk clkgnd 0 1n

* the true (time-invariant) small-signal network under test
Vin in 0 DC 1
Rin in out 1k
Cout out 0 10n
Rload out 0 10k
I1 0 out DC 0
I2 0 out DC 0
I3 0 out DC 0
I4 0 out DC 0
I5 0 out DC 0
I6 0 out DC 0
I7 0 out DC 0
I8 0 out DC 0
I9 0 out DC 0
I10 0 out DC 0
I11 0 out DC 0
I12 0 out DC 0
I13 0 out DC 0
I14 0 out DC 0
I15 0 out DC 0
I16 0 out DC 0
I17 0 out DC 0
I18 0 out DC 0
I19 0 out DC 0
I20 0 out DC 0
I21 0 out DC 0
I22 0 out DC 0
I23 0 out DC 0
I24 0 out DC 0
I25 0 out DC 0
I26 0 out DC 0
I27 0 out DC 0
I28 0 out DC 0
I29 0 out DC 0
I30 0 out DC 0
I31 0 out DC 0
I32 0 out DC 0
I33 0 out DC 0
I34 0 out DC 0
I35 0 out DC 0
I36 0 out DC 0
I37 0 out DC 0
I38 0 out DC 0
I39 0 out DC 0
I40 0 out DC 0
I41 0 out DC 0
I42 0 out DC 0
I43 0 out DC 0
I44 0 out DC 0
I45 0 out DC 0
I46 0 out DC 0
I47 0 out DC 0
I48 0 out DC 0
I49 0 out DC 0
I50 0 out DC 0

.end
