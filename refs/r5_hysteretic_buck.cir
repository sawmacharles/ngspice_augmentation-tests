* R5 free-running hysteretic buck (ngspice_augmentation, card #450, 2026-09-27)
* run: ngspice -b r5_hysteretic_buck.cir  (writes to ~/Work/data/ngspice_augmentation/refs/r5_hysteretic_buck/)
*
* Same power stage as R3/R4 (12V->3.3V target, L=10uH C=100uF Esr=10mOhm
* Rload=3.3), but no clock and no compensator: this is a self-oscillating
* (free-running) hysteretic converter, direct voltage hysteresis on Vout
* (no divider/reference op-amp -- there is nothing here for T2.2/T5.2 loop-
* gain probing to break, so unlike R3/R4 there is no XP instance in this
* deck; not asked for in the task for R5 either). Switching frequency is an
* OUTPUT of the simulation, not a .param -- see MEASURED below.
*
* Control: a self-referencing (regenerative) smooth Schmitt trigger, not
* the R4-style clocked latch. First attempt used two independent level
* comparators (Set when vout<vref_lo, Reset when vout>vref_hi) driving the
* same Cq/Bq construction as R4's latch -- found 2026-09-27 (card #450) to
* be WRONG for this circuit: once the startup ring-down's amplitude decayed
* enough, q drifted into the comparators' shared dead zone (both ~0) and
* FROZE at a non-binary value (q=0.484), settling the whole converter into
* a static linear-regulator equilibrium (Vout=3.3001V constant, zero
* ripple, zero switching) instead of continuing to oscillate -- a real
* trap, not a transient artifact (checked out to 800us). The two-comparator
* design has no mechanism to prevent a stable fixed point inside the
* transition band. Fixed by making the threshold ITSELF depend on q (true
* hysteresis, Schmitt-trigger style), so there is no fixed point except
* q~=0 and q~=1:
*   threshold(q) = vref_lo + hys*q     (vref_lo at q=0, vref_hi at q=1)
*   q_target = 0.5*(1 - tanh(khys*(vout - threshold(q))))
* This is self-referential (q_target depends on q), solved implicitly each
* Newton iteration like a real positive-feedback Schmitt trigger. A first
* try wrote q directly as this voltage (Bq q 0 V=...) with no capacitor:
* that hit "timestep too small" exactly at the switching instant (checked
* with an isolated 6-line reproducer) because a zero-capacitance algebraic
* self-reference has a literal jump discontinuity with nothing to
* regularize it in time. Fixed by driving q through a capacitor instead
* (relaxation dynamics dq/dt=(kdrive/cq)*(q_target-q)): fast, but not
* infinitely fast, which the transient solver can resolve. See Bq below.
* MEASURED (ngspice-45.2, this deck, 2026-09-27; see refs/README.md for the
* full table). Cold start from Vout=0V with no soft-start or current limit
* overshoots hard on the very first pulse (Vout peaks ~7.6V, ~2.3x the
* 3.3V target, before the reset comparator's turn-off plus the stored
* inductor energy's freewheel-down brings it back into the hysteresis
* band) -- a bigger overshoot than R3/R4/R6's compensated startups, an
* expected consequence of hysteretic control having no loop dynamics to
* limit the first on-time. Settles into steady free-running switching by
* ~400us. Steady state: t_period 2.341067us and 2.342250us at two points
* ~100us apart (RISE=10/11 and RISE=50/51) -- consistent, i.e. genuinely
* periodic, not drifting. fsw ~= 427.2-427.6 kHz (an output, not a
* parameter). Vout: 3.0406V(200us, still settling) -> 3.3004V(1000us) ->
* 3.3005V(3000us, final). Ripple(2900-3000us)=5.637mV (~0.17%, close to
* the hys=20mV .param but not equal -- the L/C filtering and Resr/Rdcr
* drops shape the actual ripple). duty(final)=0.2789 vs ideal Vout/Vin=
* 0.275 -- close. Runtime 2.3s for the full 3ms run.
.param vin_v=12 vref=3.3 hys=0.02
.param lval=10u rdcr=10m cval=100u esrval=10m rload=3.3
.param gon=100 goff=1e-6 ksw=30 khys=200
.param cq=1p kdrive=1e-3

Vin vin 0 DC {vin_v}
.ic v(q)=0.5
* (q has no DC path either, same as R3/R4's compensator nodes -- 'uic' and
* this .ic avoid the same op-point trap noted in r3_vm_buck.cir. An earlier
* attempt also tried .ic v(vout)=3.3, but vout is tied to cx -- which
* Cout's own IC=0 fixes at 0V -- through only a 10 mOhm Resr, so the two
* ICs fought and vout collapsed to ~0 anyway; dropped it and just let this
* deck cold-start from 0V like R3/R4/R6, which is a fine test too: q stays
* pinned at 1 (always-on) until Vout first reaches vref_hi, then hysteretic
* switching begins.)

Bhs vin sw I = (V(vin)-V(sw)) * ({goff}+({gon}-{goff})*0.5*(1+tanh({ksw}*(V(q)-0.5))))
Bls sw 0   I = V(sw)              * ({goff}+({gon}-{goff})*0.5*(1+tanh({ksw}*(0.5-V(q)))))
Csw sw 0 100p

L1 sw swl {lval} IC=0
Rdcr swl vout {rdcr}
Resr vout cx {esrval}
Cout cx 0 {cval} IC=0
Rload vout 0 {rload}

Cq q 0 {cq}
* self-referencing Schmitt trigger (see header): q_target depends on q
* itself through threshold(q)=vref-hys/2+hys*q. Same B-source sign
* convention as r4_pcm_buck.cir's latch (current Bxxx n1 n2 I=expr flows
* n1->n2, so the capacitor at q sees -expr; want Cq*dq/dt=+kdrive*(target-q)
* so expr=kdrive*(q-target)):
Bq q 0 I = {kdrive}*(V(q) - 0.5*(1-tanh({khys}*(V(vout)-({vref}-{hys}/2+{hys}*V(q))))))

.control
set filetype=ascii
* 3ms, not 2ms: settling after the large cold-start inrush (see MEASURED
* below) takes ~400us. The free-running period turned out to be ~2.34us
* (~427kHz, an OUTPUT of the simulation, no .param sets it) -- a first look
* at a coarse (every ~6.6us) debug sample of v(q) appeared to show a much
* slower ~47us envelope; that was aliasing from under-sampling a ~2.34us
* signal at a non-integer-multiple stride, not the real period. The
* TRIG/TARG-measured period below (an exact crossing-time measurement, not
* a sampled plot) is the trustworthy number. 3ms gives ample margin for the
* RISE-indexed measures below to land inside the run either way.
tran 10n 3m 0 uic
meas tran t_period1 TRIG v(q) VAL=0.5 RISE=10 TARG v(q) VAL=0.5 RISE=11
meas tran t_period2 TRIG v(q) VAL=0.5 RISE=50 TARG v(q) VAL=0.5 RISE=51
let fsw_meas1 = 1/t_period1
let fsw_meas2 = 1/t_period2
meas tran vout_avg_early AVG v(vout) FROM=190u TO=200u
meas tran vout_avg_mid AVG v(vout) FROM=990u TO=1000u
meas tran vout_avg_final AVG v(vout) FROM=2900u TO=3000u
meas tran vout_max_final MAX v(vout) FROM=2900u TO=3000u
meas tran vout_min_final MIN v(vout) FROM=2900u TO=3000u
let vout_ripple = vout_max_final - vout_min_final
meas tran vin_avg AVG v(vin) FROM=2900u TO=3000u
meas tran duty_meas AVG v(sw) FROM=2900u TO=3000u
let duty_meas = duty_meas/vin_avg
print t_period1 fsw_meas1 t_period2 fsw_meas2 vout_avg_early vout_avg_mid vout_avg_final vout_max_final vout_min_final vout_ripple duty_meas
write ~/Work/data/ngspice_augmentation/refs/r5_hysteretic_buck/r5_hysteretic_buck.raw
wrdata ~/Work/data/ngspice_augmentation/refs/r5_hysteretic_buck/r5_hysteretic_buck.txt v(vout) v(q) i(L1)
.endc
.end
