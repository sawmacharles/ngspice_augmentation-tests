* R7p (R7 + parasitic RC trees) transistor-level synchronous buck (ngspice_augmentation, card #539, 2026-10-01)
* run: ngspice -b r7_bsim_buck.cir  (cwd = refs/; writes under ~/Work/data/ngspice_augmentation/539/)
*
* Everything that conducts or decides is a BSIM4 (level=54, v4.8.2) MOSFET; only the references (Vin, vref, ramp,
* the OTA bias current), the passives and the Tian probe are ideal. Model cards are copied verbatim from cards
* already in this repository (power: tests/fixtures/loss_bsim4_buck.cir; logic and analog: bench/decks/
* d_analog_block.cir) under new names nchp/pchp and nch4/pch4. Junction areas/perimeters (as ad ps pd) are instance
* parameters here so the drain/source-bulk junction caps and body diodes exist (the cards give cjs=cjd, jss default;
* with as=ad=0 the body diode would be a 1e-14 A floor).
*
* TOPOLOGY (single 5 V rail `vin` feeds power stage, drivers and control; 5 V -> 1.46 V, 2 A, fs 500 kHz)
*   power:  Mhs PMOS 60 mm/0.35 um (vin->sw), Mls NMOS 40 mm/0.35 um (sw->0), L 2.2 uH (DCR 10 mOhm in series with Rdcr),
*           Cout 100 uF, ESR 80 mOhm (ESR zero ~20 kHz gives the type-II loop its phase), Rload 0.75 Ohm.
*   PWM:    NMOS 5T diff pair + PMOS mirror comparator (opout vs a 1.2..2.2 V ramp, independent PULSE source),
*           two BSIM4 inverters for a rail-to-rail pwm (high = HS on).
*   dead time: cross-coupled NOR pair, each NOR input fed back through a 6-inverter delay (3 pF per stage, gate dead time 18.8 ns) of the other side's
*           output (hs_on = NOR(!pwm, ls_on delayed), ls_on = NOR(pwm, hs_on delayed)): break-before-make
*           generated by gate delays, not by an RC.
*   drivers: tapered inverter chains (5 stages to the PMOS gate, 4 stages to the NMOS gate; fanout ~4.5-5).
*   error amp: PMOS-input 5T OTA (gm ~1 mS, ro ~49 kOhm), inverting from fb to opout (fb = inn, vref = inp: opout falls
*           when Vout rises, card #519), type-II compensation Rc 2k + Cc 6n in series to ground, Cp 20p.
*   loop probe: XP (lgprobe) in the divider path, same placement/orientation as R3.
*
* MEASURED (s88, reltol 1e-5): Vout 1.45940 V, ripple 70.15 mV, il 1.9464 A (pp 0.970), fsw 500.000 kHz, efficiency 92.9 %,
* FRA loop crossover 26.19 kHz, PM 53.5 deg. Full tables, traps and the engine bugs found with it: refs/README.md "R7 / R7p".
* Hooks used by the fixtures (all DC 0 here, harmless): none in this file; fixtures splice Vctrl/Iinj/Vprobe (tests/fixtures/r7_*.cir).
* Traps: (1) NMOS bias mirror needs the current INTO the diode node (Ibc vin bcb), not out of it; (2) BSIM4 W of 5 mm
* gives Ron ~2 Ohm (u0 is cm2/Vs): the power FETs need 40-60 mm; (3) .pss at default reltol 1e-3 stalls at residual 4e-4, use
* .options reltol=1e-4; (4) some tight option combinations abort .tran at the ramp source (bugs/bug2_tight_reltol).
.param vin_v=5 fs=500k tclk={1/fs}
.param lval=2.2u rdcr=10m cval=100u esrval=80m rload=0.75
.param ra=1.5k rb=1k vref=0.6
.param rc=2k cc=6n cp=20p ibias=20u
.param vrlo=1.2 vrhi=2.2
.param iload=2 vout_ic=1.5 op_ic=1.4

.model nch4 nmos level=54 version=4.8.2
+ mobmod=0 capmod=0 igcmod=0 igbmod=0 rdsmod=0 rbodymod=0 rgatemod=0 acnqsmod=0
+ toxe=3e-9 toxp=3e-9 toxm=3e-9
+ vth0=0.5 k1=0.4 k2=0 k3=0 w0=2.5e-6
+ u0=300 vsat=1.1e5
+ cgso=2e-10 cgdo=2e-10 cgbo=0 cgsl=0 cgdl=0
+ cf=0 cjs=1e-4 cjd=1e-4 cjswd=1e-10 cjswgd=1e-10
.model pch4 pmos level=54 version=4.8.2
+ mobmod=0 capmod=0 igcmod=0 igbmod=0 rdsmod=0 rbodymod=0 rgatemod=0 acnqsmod=0
+ toxe=3e-9 toxp=3e-9 toxm=3e-9
+ vth0=-0.5 k1=0.4 k2=0 k3=0 w0=2.5e-6
+ u0=100 vsat=1.0e5
+ cgso=2e-10 cgdo=2e-10 cgbo=0 cgsl=0 cgdl=0
+ cf=0 cjs=1e-4 cjd=1e-4 cjswd=1e-10 cjswgd=1e-10
.model nchp nmos level=54 version=4.8.2
+ mobmod=0 capmod=0 igcmod=0 igbmod=0 rdsmod=0 rbodymod=0 rgatemod=0 acnqsmod=0
+ toxe=3e-9 toxp=3e-9 toxm=3e-9
+ vth0=1.0 k1=0.4 k2=0 k3=0 w0=2.5e-6
+ u0=300 vsat=1.1e5
.model pchp pmos level=54 version=4.8.2
+ mobmod=0 capmod=0 igcmod=0 igbmod=0 rdsmod=0 rbodymod=0 rgatemod=0 acnqsmod=0
+ toxe=3e-9 toxp=3e-9 toxm=3e-9
+ vth0=-1.0 k1=0.4 k2=0 k3=0 w0=2.5e-6
+ u0=100 vsat=0.8e5

* ---- gates (w in metres via u suffix; junction geometry follows w) ----
.subckt inv in out vdd wn=2u wp=5u
Mn out in 0 0 nch4 w={wn} l=0.5u as={wn*1u} ad={wn*1u} ps={2*wn+2u} pd={2*wn+2u}
Mp out in vdd vdd pch4 w={wp} l=0.5u as={wp*1u} ad={wp*1u} ps={2*wp+2u} pd={2*wp+2u}
.ends inv
.subckt nor2 a b y vdd
Mp1 n1 a vdd vdd pch4 w=10u l=0.5u as=10p ad=10p ps=22u pd=22u
Mp2 y b n1 vdd pch4 w=10u l=0.5u as=10p ad=10p ps=22u pd=22u
Mn1 y a 0 0 nch4 w=2u l=0.5u as=2p ad=2p ps=6u pd=6u
Mn2 y b 0 0 nch4 w=2u l=0.5u as=2p ad=2p ps=6u pd=6u
.ends nor2
* delay: six minimum inverters, 100 fF per stage (sets the dead time)
.subckt dly6 in out vdd
X1 in d1 vdd inv
C1 d1 0 {cdl}
X2 d1 d2 vdd inv
C2 d2 0 {cdl}
X3 d2 d3 vdd inv
C3 d3 0 {cdl}
X4 d3 d4 vdd inv
C4 d4 0 {cdl}
X5 d4 d5 vdd inv
C5 d5 0 {cdl}
X6 d5 out vdd inv
.ends dly6
.param cdl=3p

Vin vin 0 DC {vin_v}
.ic v(opout)={op_ic} v(vout)={vout_ic}

* ---- power stage ----
Mhs sw ghs vin vin pchp w=60000u l=0.35u as=1.2e-7 ad=1.2e-7 ps=0.12 pd=0.12
Mls sw gls 0 0 nchp w=40000u l=0.35u as=8e-8 ad=8e-8 ps=0.08 pd=0.08
L1 sw swl {lval} IC={iload}
Rdcr swl vout {rdcr}
Resr vout cx {esrval}
Cout cx 0 {cval} IC={vout_ic}
Rload vout 0 {rload}

* ---- feedback, error amplifier (PMOS-input 5T OTA), compensation ----
.include ../stb/lgprobe.lib
XP fbtop vout lgprobe
Ra fbtop fbnode {ra}
Rb fbnode 0 {rb}
Vrefsrc vrefnode 0 DC {vref}
Ib vb 0 DC {ibias}
Mref vb vb vin vin pch4 w=10u l=1u as=10p ad=10p ps=22u pd=22u
Mt tail vb vin vin pch4 w=50u l=1u as=50p ad=50p ps=102u pd=102u
M1 d1 vrefnode tail vin pch4 w=50u l=0.5u as=50p ad=50p ps=102u pd=102u
M2 opout fbnode tail vin pch4 w=50u l=0.5u as=50p ad=50p ps=102u pd=102u
M3 d1 d1 0 0 nch4 w=20u l=1u as=20p ad=20p ps=42u pd=42u
M4 opout d1 0 0 nch4 w=20u l=1u as=20p ad=20p ps=42u pd=42u
Rcomp opout ccn {rc}
Ccomp ccn 0 {cc} IC={op_ic}
Cpar opout 0 {cp}

* ---- PWM comparator (NMOS pair, PMOS mirror) + ramp ----
Vramp ramp 0 PULSE({vrlo} {vrhi} 0 {0.97*tclk} {0.03*tclk} 1n {tclk})
Ibc vin bcb DC 40u
Mbr bcb bcb 0 0 nch4 w=10u l=1u as=10p ad=10p ps=22u pd=22u
Mct ctail bcb 0 0 nch4 w=20u l=1u as=20p ad=20p ps=42u pd=42u
Mc1 cd1 opout ctail 0 nch4 w=20u l=0.5u as=20p ad=20p ps=42u pd=42u
Mc2 cout ramp ctail 0 nch4 w=20u l=0.5u as=20p ad=20p ps=42u pd=42u
Mc3 cd1 cd1 vin vin pch4 w=20u l=1u as=20p ad=20p ps=42u pd=42u
Mc4 cout cd1 vin vin pch4 w=20u l=1u as=20p ad=20p ps=42u pd=42u
Xcp1 cout cpb vin inv
Xcp2 cpb pwm vin inv
Xpb pwm pwm_b vin inv

* ---- dead-time generator (cross-coupled NORs with delayed feedback) ----
Xnh pwm_b ls_d hs_on vin nor2
Xnl pwm hs_d ls_on vin nor2
Xdh hs_on hs_d vin dly6
Xdl ls_on ls_d vin dly6

* ---- gate drivers: tapered chains ----
Xh1 hs_on h1 vin inv wn=2u wp=5u
Xh2 h1 h2 vin inv wn=11u wp=27u
Xh3 h2 h3 vin inv wn=60u wp=150u
Xh4 h3 h4 vin inv wn=330u wp=830u
Xh5 h4 ghs vin inv wn=1815u wp=4540u
Xl1 ls_on l1 vin inv wn=2u wp=5u
Xl2 l1 l2 vin inv wn=16u wp=40u
Xl3 l2 l3 vin inv wn=130u wp=320u
Xl4 l3 gls vin inv wn=1000u wp=2500u

* ---- R7p: synthetic extracted parasitic RC trees (refs/gen_r7p.py, bench/gen_pex_buck.py tree_lines) ----
Rcpl_tv vout tv_0 20m
* tree-shaped synthetic PEX net: branch=3 depth=4, rtrace0=0.05 (x1.5/level), cplane0=2e-10 (x0.6/level), local-mesh-stride=3, coupling-caps=12
Cp_0_tv tv_0 0 2e-10
Rtr_0_1_tv tv_0 tv_1 0.05
Cp_1_tv tv_1 0 1.2e-10
Rtr_0_2_tv tv_0 tv_2 0.05
Cp_2_tv tv_2 0 1.2e-10
Rtr_0_3_tv tv_0 tv_3 0.05
Cp_3_tv tv_3 0 1.2e-10
Rtr_1_4_tv tv_1 tv_4 0.075
Cp_4_tv tv_4 0 7.2e-11
Rtr_1_5_tv tv_1 tv_5 0.075
Cp_5_tv tv_5 0 7.2e-11
Rtr_1_6_tv tv_1 tv_6 0.075
Cp_6_tv tv_6 0 7.2e-11
Rtr_2_7_tv tv_2 tv_7 0.075
Cp_7_tv tv_7 0 7.2e-11
Rtr_2_8_tv tv_2 tv_8 0.075
Cp_8_tv tv_8 0 7.2e-11
Rtr_2_9_tv tv_2 tv_9 0.075
Cp_9_tv tv_9 0 7.2e-11
Rtr_3_10_tv tv_3 tv_10 0.075
Cp_10_tv tv_10 0 7.2e-11
Rtr_3_11_tv tv_3 tv_11 0.075
Cp_11_tv tv_11 0 7.2e-11
Rtr_3_12_tv tv_3 tv_12 0.075
Cp_12_tv tv_12 0 7.2e-11
Rtr_4_13_tv tv_4 tv_13 0.1125
Cp_13_tv tv_13 0 4.32e-11
Rtr_4_14_tv tv_4 tv_14 0.1125
Cp_14_tv tv_14 0 4.32e-11
Rtr_4_15_tv tv_4 tv_15 0.1125
Cp_15_tv tv_15 0 4.32e-11
Rtr_5_16_tv tv_5 tv_16 0.1125
Cp_16_tv tv_16 0 4.32e-11
Rtr_5_17_tv tv_5 tv_17 0.1125
Cp_17_tv tv_17 0 4.32e-11
Rtr_5_18_tv tv_5 tv_18 0.1125
Cp_18_tv tv_18 0 4.32e-11
Rtr_6_19_tv tv_6 tv_19 0.1125
Cp_19_tv tv_19 0 4.32e-11
Rtr_6_20_tv tv_6 tv_20 0.1125
Cp_20_tv tv_20 0 4.32e-11
Rtr_6_21_tv tv_6 tv_21 0.1125
Cp_21_tv tv_21 0 4.32e-11
Rtr_7_22_tv tv_7 tv_22 0.1125
Cp_22_tv tv_22 0 4.32e-11
Rtr_7_23_tv tv_7 tv_23 0.1125
Cp_23_tv tv_23 0 4.32e-11
Rtr_7_24_tv tv_7 tv_24 0.1125
Cp_24_tv tv_24 0 4.32e-11
Rtr_8_25_tv tv_8 tv_25 0.1125
Cp_25_tv tv_25 0 4.32e-11
Rtr_8_26_tv tv_8 tv_26 0.1125
Cp_26_tv tv_26 0 4.32e-11
Rtr_8_27_tv tv_8 tv_27 0.1125
Cp_27_tv tv_27 0 4.32e-11
Rtr_9_28_tv tv_9 tv_28 0.1125
Cp_28_tv tv_28 0 4.32e-11
Rtr_9_29_tv tv_9 tv_29 0.1125
Cp_29_tv tv_29 0 4.32e-11
Rtr_9_30_tv tv_9 tv_30 0.1125
Cp_30_tv tv_30 0 4.32e-11
Rtr_10_31_tv tv_10 tv_31 0.1125
Cp_31_tv tv_31 0 4.32e-11
Rtr_10_32_tv tv_10 tv_32 0.1125
Cp_32_tv tv_32 0 4.32e-11
Rtr_10_33_tv tv_10 tv_33 0.1125
Cp_33_tv tv_33 0 4.32e-11
Rtr_11_34_tv tv_11 tv_34 0.1125
Cp_34_tv tv_34 0 4.32e-11
Rtr_11_35_tv tv_11 tv_35 0.1125
Cp_35_tv tv_35 0 4.32e-11
Rtr_11_36_tv tv_11 tv_36 0.1125
Cp_36_tv tv_36 0 4.32e-11
Rtr_12_37_tv tv_12 tv_37 0.1125
Cp_37_tv tv_37 0 4.32e-11
Rtr_12_38_tv tv_12 tv_38 0.1125
Cp_38_tv tv_38 0 4.32e-11
Rtr_12_39_tv tv_12 tv_39 0.1125
Cp_39_tv tv_39 0 4.32e-11
Rtr_13_40_tv tv_13 tv_40 0.16875
Cp_40_tv tv_40 0 2.592e-11
Rtr_13_41_tv tv_13 tv_41 0.16875
Cp_41_tv tv_41 0 2.592e-11
Rtr_13_42_tv tv_13 tv_42 0.16875
Cp_42_tv tv_42 0 2.592e-11
Rtr_14_43_tv tv_14 tv_43 0.16875
Cp_43_tv tv_43 0 2.592e-11
Rtr_14_44_tv tv_14 tv_44 0.16875
Cp_44_tv tv_44 0 2.592e-11
Rtr_14_45_tv tv_14 tv_45 0.16875
Cp_45_tv tv_45 0 2.592e-11
Rtr_15_46_tv tv_15 tv_46 0.16875
Cp_46_tv tv_46 0 2.592e-11
Rtr_15_47_tv tv_15 tv_47 0.16875
Cp_47_tv tv_47 0 2.592e-11
Rtr_15_48_tv tv_15 tv_48 0.16875
Cp_48_tv tv_48 0 2.592e-11
Rtr_16_49_tv tv_16 tv_49 0.16875
Cp_49_tv tv_49 0 2.592e-11
Rtr_16_50_tv tv_16 tv_50 0.16875
Cp_50_tv tv_50 0 2.592e-11
Rtr_16_51_tv tv_16 tv_51 0.16875
Cp_51_tv tv_51 0 2.592e-11
Rtr_17_52_tv tv_17 tv_52 0.16875
Cp_52_tv tv_52 0 2.592e-11
Rtr_17_53_tv tv_17 tv_53 0.16875
Cp_53_tv tv_53 0 2.592e-11
Rtr_17_54_tv tv_17 tv_54 0.16875
Cp_54_tv tv_54 0 2.592e-11
Rtr_18_55_tv tv_18 tv_55 0.16875
Cp_55_tv tv_55 0 2.592e-11
Rtr_18_56_tv tv_18 tv_56 0.16875
Cp_56_tv tv_56 0 2.592e-11
Rtr_18_57_tv tv_18 tv_57 0.16875
Cp_57_tv tv_57 0 2.592e-11
Rtr_19_58_tv tv_19 tv_58 0.16875
Cp_58_tv tv_58 0 2.592e-11
Rtr_19_59_tv tv_19 tv_59 0.16875
Cp_59_tv tv_59 0 2.592e-11
Rtr_19_60_tv tv_19 tv_60 0.16875
Cp_60_tv tv_60 0 2.592e-11
Rtr_20_61_tv tv_20 tv_61 0.16875
Cp_61_tv tv_61 0 2.592e-11
Rtr_20_62_tv tv_20 tv_62 0.16875
Cp_62_tv tv_62 0 2.592e-11
Rtr_20_63_tv tv_20 tv_63 0.16875
Cp_63_tv tv_63 0 2.592e-11
Rtr_21_64_tv tv_21 tv_64 0.16875
Cp_64_tv tv_64 0 2.592e-11
Rtr_21_65_tv tv_21 tv_65 0.16875
Cp_65_tv tv_65 0 2.592e-11
Rtr_21_66_tv tv_21 tv_66 0.16875
Cp_66_tv tv_66 0 2.592e-11
Rtr_22_67_tv tv_22 tv_67 0.16875
Cp_67_tv tv_67 0 2.592e-11
Rtr_22_68_tv tv_22 tv_68 0.16875
Cp_68_tv tv_68 0 2.592e-11
Rtr_22_69_tv tv_22 tv_69 0.16875
Cp_69_tv tv_69 0 2.592e-11
Rtr_23_70_tv tv_23 tv_70 0.16875
Cp_70_tv tv_70 0 2.592e-11
Rtr_23_71_tv tv_23 tv_71 0.16875
Cp_71_tv tv_71 0 2.592e-11
Rtr_23_72_tv tv_23 tv_72 0.16875
Cp_72_tv tv_72 0 2.592e-11
Rtr_24_73_tv tv_24 tv_73 0.16875
Cp_73_tv tv_73 0 2.592e-11
Rtr_24_74_tv tv_24 tv_74 0.16875
Cp_74_tv tv_74 0 2.592e-11
Rtr_24_75_tv tv_24 tv_75 0.16875
Cp_75_tv tv_75 0 2.592e-11
Rtr_25_76_tv tv_25 tv_76 0.16875
Cp_76_tv tv_76 0 2.592e-11
Rtr_25_77_tv tv_25 tv_77 0.16875
Cp_77_tv tv_77 0 2.592e-11
Rtr_25_78_tv tv_25 tv_78 0.16875
Cp_78_tv tv_78 0 2.592e-11
Rtr_26_79_tv tv_26 tv_79 0.16875
Cp_79_tv tv_79 0 2.592e-11
Rtr_26_80_tv tv_26 tv_80 0.16875
Cp_80_tv tv_80 0 2.592e-11
Rtr_26_81_tv tv_26 tv_81 0.16875
Cp_81_tv tv_81 0 2.592e-11
Rtr_27_82_tv tv_27 tv_82 0.16875
Cp_82_tv tv_82 0 2.592e-11
Rtr_27_83_tv tv_27 tv_83 0.16875
Cp_83_tv tv_83 0 2.592e-11
Rtr_27_84_tv tv_27 tv_84 0.16875
Cp_84_tv tv_84 0 2.592e-11
Rtr_28_85_tv tv_28 tv_85 0.16875
Cp_85_tv tv_85 0 2.592e-11
Rtr_28_86_tv tv_28 tv_86 0.16875
Cp_86_tv tv_86 0 2.592e-11
Rtr_28_87_tv tv_28 tv_87 0.16875
Cp_87_tv tv_87 0 2.592e-11
Rtr_29_88_tv tv_29 tv_88 0.16875
Cp_88_tv tv_88 0 2.592e-11
Rtr_29_89_tv tv_29 tv_89 0.16875
Cp_89_tv tv_89 0 2.592e-11
Rtr_29_90_tv tv_29 tv_90 0.16875
Cp_90_tv tv_90 0 2.592e-11
Rtr_30_91_tv tv_30 tv_91 0.16875
Cp_91_tv tv_91 0 2.592e-11
Rtr_30_92_tv tv_30 tv_92 0.16875
Cp_92_tv tv_92 0 2.592e-11
Rtr_30_93_tv tv_30 tv_93 0.16875
Cp_93_tv tv_93 0 2.592e-11
Rtr_31_94_tv tv_31 tv_94 0.16875
Cp_94_tv tv_94 0 2.592e-11
Rtr_31_95_tv tv_31 tv_95 0.16875
Cp_95_tv tv_95 0 2.592e-11
Rtr_31_96_tv tv_31 tv_96 0.16875
Cp_96_tv tv_96 0 2.592e-11
Rtr_32_97_tv tv_32 tv_97 0.16875
Cp_97_tv tv_97 0 2.592e-11
Rtr_32_98_tv tv_32 tv_98 0.16875
Cp_98_tv tv_98 0 2.592e-11
Rtr_32_99_tv tv_32 tv_99 0.16875
Cp_99_tv tv_99 0 2.592e-11
Rtr_33_100_tv tv_33 tv_100 0.16875
Cp_100_tv tv_100 0 2.592e-11
Rtr_33_101_tv tv_33 tv_101 0.16875
Cp_101_tv tv_101 0 2.592e-11
Rtr_33_102_tv tv_33 tv_102 0.16875
Cp_102_tv tv_102 0 2.592e-11
Rtr_34_103_tv tv_34 tv_103 0.16875
Cp_103_tv tv_103 0 2.592e-11
Rtr_34_104_tv tv_34 tv_104 0.16875
Cp_104_tv tv_104 0 2.592e-11
Rtr_34_105_tv tv_34 tv_105 0.16875
Cp_105_tv tv_105 0 2.592e-11
Rtr_35_106_tv tv_35 tv_106 0.16875
Cp_106_tv tv_106 0 2.592e-11
Rtr_35_107_tv tv_35 tv_107 0.16875
Cp_107_tv tv_107 0 2.592e-11
Rtr_35_108_tv tv_35 tv_108 0.16875
Cp_108_tv tv_108 0 2.592e-11
Rtr_36_109_tv tv_36 tv_109 0.16875
Cp_109_tv tv_109 0 2.592e-11
Rtr_36_110_tv tv_36 tv_110 0.16875
Cp_110_tv tv_110 0 2.592e-11
Rtr_36_111_tv tv_36 tv_111 0.16875
Cp_111_tv tv_111 0 2.592e-11
Rtr_37_112_tv tv_37 tv_112 0.16875
Cp_112_tv tv_112 0 2.592e-11
Rtr_37_113_tv tv_37 tv_113 0.16875
Cp_113_tv tv_113 0 2.592e-11
Rtr_37_114_tv tv_37 tv_114 0.16875
Cp_114_tv tv_114 0 2.592e-11
Rtr_38_115_tv tv_38 tv_115 0.16875
Cp_115_tv tv_115 0 2.592e-11
Rtr_38_116_tv tv_38 tv_116 0.16875
Cp_116_tv tv_116 0 2.592e-11
Rtr_38_117_tv tv_38 tv_117 0.16875
Cp_117_tv tv_117 0 2.592e-11
Rtr_39_118_tv tv_39 tv_118 0.16875
Cp_118_tv tv_118 0 2.592e-11
Rtr_39_119_tv tv_39 tv_119 0.16875
Cp_119_tv tv_119 0 2.592e-11
Rtr_39_120_tv tv_39 tv_120 0.16875
Cp_120_tv tv_120 0 2.592e-11
Rlm_1_2_tv tv_1 tv_2 0.2
Rlm_4_5_tv tv_4 tv_5 0.3
Rlm_7_8_tv tv_7 tv_8 0.3
Rlm_10_11_tv tv_10 tv_11 0.3
Rlm_13_14_tv tv_13 tv_14 0.45
Rlm_16_17_tv tv_16 tv_17 0.45
Rlm_19_20_tv tv_19 tv_20 0.45
Rlm_22_23_tv tv_22 tv_23 0.45
Rlm_25_26_tv tv_25 tv_26 0.45
Rlm_28_29_tv tv_28 tv_29 0.45
Rlm_31_32_tv tv_31 tv_32 0.45
Rlm_34_35_tv tv_34 tv_35 0.45
Rlm_37_38_tv tv_37 tv_38 0.45
Rlm_40_41_tv tv_40 tv_41 0.675
Rlm_43_44_tv tv_43 tv_44 0.675
Rlm_46_47_tv tv_46 tv_47 0.675
Rlm_49_50_tv tv_49 tv_50 0.675
Rlm_52_53_tv tv_52 tv_53 0.675
Rlm_55_56_tv tv_55 tv_56 0.675
Rlm_58_59_tv tv_58 tv_59 0.675
Rlm_61_62_tv tv_61 tv_62 0.675
Rlm_64_65_tv tv_64 tv_65 0.675
Rlm_67_68_tv tv_67 tv_68 0.675
Rlm_70_71_tv tv_70 tv_71 0.675
Rlm_73_74_tv tv_73 tv_74 0.675
Rlm_76_77_tv tv_76 tv_77 0.675
Rlm_79_80_tv tv_79 tv_80 0.675
Rlm_82_83_tv tv_82 tv_83 0.675
Rlm_85_86_tv tv_85 tv_86 0.675
Rlm_88_89_tv tv_88 tv_89 0.675
Rlm_91_92_tv tv_91 tv_92 0.675
Rlm_94_95_tv tv_94 tv_95 0.675
Rlm_97_98_tv tv_97 tv_98 0.675
Rlm_100_101_tv tv_100 tv_101 0.675
Rlm_103_104_tv tv_103 tv_104 0.675
Rlm_106_107_tv tv_106 tv_107 0.675
Rlm_109_110_tv tv_109 tv_110 0.675
Rlm_112_113_tv tv_112 tv_113 0.675
Rlm_115_116_tv tv_115 tv_116 0.675
Rlm_118_119_tv tv_118 tv_119 0.675
Ccpl_40_46_tv tv_40 tv_46 2e-11
Ccpl_46_52_tv tv_46 tv_52 2e-11
Ccpl_52_58_tv tv_52 tv_58 2e-11
Ccpl_58_64_tv tv_58 tv_64 2e-11
Ccpl_64_70_tv tv_64 tv_70 2e-11
Ccpl_70_76_tv tv_70 tv_76 2e-11
Ccpl_76_82_tv tv_76 tv_82 2e-11
Ccpl_82_88_tv tv_82 tv_88 2e-11
Ccpl_88_94_tv tv_88 tv_94 2e-11
Ccpl_94_100_tv tv_94 tv_100 2e-11
Ccpl_100_106_tv tv_100 tv_106 2e-11
Ccpl_106_112_tv tv_106 tv_112 2e-11
Rcpl_ts sw ts_0 5m
* tree-shaped synthetic PEX net: branch=3 depth=4, rtrace0=0.02 (x1.5/level), cplane0=2e-11 (x0.6/level), local-mesh-stride=3, coupling-caps=12
Cp_0_ts ts_0 0 2e-11
Rtr_0_1_ts ts_0 ts_1 0.02
Cp_1_ts ts_1 0 1.2e-11
Rtr_0_2_ts ts_0 ts_2 0.02
Cp_2_ts ts_2 0 1.2e-11
Rtr_0_3_ts ts_0 ts_3 0.02
Cp_3_ts ts_3 0 1.2e-11
Rtr_1_4_ts ts_1 ts_4 0.03
Cp_4_ts ts_4 0 7.2e-12
Rtr_1_5_ts ts_1 ts_5 0.03
Cp_5_ts ts_5 0 7.2e-12
Rtr_1_6_ts ts_1 ts_6 0.03
Cp_6_ts ts_6 0 7.2e-12
Rtr_2_7_ts ts_2 ts_7 0.03
Cp_7_ts ts_7 0 7.2e-12
Rtr_2_8_ts ts_2 ts_8 0.03
Cp_8_ts ts_8 0 7.2e-12
Rtr_2_9_ts ts_2 ts_9 0.03
Cp_9_ts ts_9 0 7.2e-12
Rtr_3_10_ts ts_3 ts_10 0.03
Cp_10_ts ts_10 0 7.2e-12
Rtr_3_11_ts ts_3 ts_11 0.03
Cp_11_ts ts_11 0 7.2e-12
Rtr_3_12_ts ts_3 ts_12 0.03
Cp_12_ts ts_12 0 7.2e-12
Rtr_4_13_ts ts_4 ts_13 0.045
Cp_13_ts ts_13 0 4.32e-12
Rtr_4_14_ts ts_4 ts_14 0.045
Cp_14_ts ts_14 0 4.32e-12
Rtr_4_15_ts ts_4 ts_15 0.045
Cp_15_ts ts_15 0 4.32e-12
Rtr_5_16_ts ts_5 ts_16 0.045
Cp_16_ts ts_16 0 4.32e-12
Rtr_5_17_ts ts_5 ts_17 0.045
Cp_17_ts ts_17 0 4.32e-12
Rtr_5_18_ts ts_5 ts_18 0.045
Cp_18_ts ts_18 0 4.32e-12
Rtr_6_19_ts ts_6 ts_19 0.045
Cp_19_ts ts_19 0 4.32e-12
Rtr_6_20_ts ts_6 ts_20 0.045
Cp_20_ts ts_20 0 4.32e-12
Rtr_6_21_ts ts_6 ts_21 0.045
Cp_21_ts ts_21 0 4.32e-12
Rtr_7_22_ts ts_7 ts_22 0.045
Cp_22_ts ts_22 0 4.32e-12
Rtr_7_23_ts ts_7 ts_23 0.045
Cp_23_ts ts_23 0 4.32e-12
Rtr_7_24_ts ts_7 ts_24 0.045
Cp_24_ts ts_24 0 4.32e-12
Rtr_8_25_ts ts_8 ts_25 0.045
Cp_25_ts ts_25 0 4.32e-12
Rtr_8_26_ts ts_8 ts_26 0.045
Cp_26_ts ts_26 0 4.32e-12
Rtr_8_27_ts ts_8 ts_27 0.045
Cp_27_ts ts_27 0 4.32e-12
Rtr_9_28_ts ts_9 ts_28 0.045
Cp_28_ts ts_28 0 4.32e-12
Rtr_9_29_ts ts_9 ts_29 0.045
Cp_29_ts ts_29 0 4.32e-12
Rtr_9_30_ts ts_9 ts_30 0.045
Cp_30_ts ts_30 0 4.32e-12
Rtr_10_31_ts ts_10 ts_31 0.045
Cp_31_ts ts_31 0 4.32e-12
Rtr_10_32_ts ts_10 ts_32 0.045
Cp_32_ts ts_32 0 4.32e-12
Rtr_10_33_ts ts_10 ts_33 0.045
Cp_33_ts ts_33 0 4.32e-12
Rtr_11_34_ts ts_11 ts_34 0.045
Cp_34_ts ts_34 0 4.32e-12
Rtr_11_35_ts ts_11 ts_35 0.045
Cp_35_ts ts_35 0 4.32e-12
Rtr_11_36_ts ts_11 ts_36 0.045
Cp_36_ts ts_36 0 4.32e-12
Rtr_12_37_ts ts_12 ts_37 0.045
Cp_37_ts ts_37 0 4.32e-12
Rtr_12_38_ts ts_12 ts_38 0.045
Cp_38_ts ts_38 0 4.32e-12
Rtr_12_39_ts ts_12 ts_39 0.045
Cp_39_ts ts_39 0 4.32e-12
Rtr_13_40_ts ts_13 ts_40 0.0675
Cp_40_ts ts_40 0 2.592e-12
Rtr_13_41_ts ts_13 ts_41 0.0675
Cp_41_ts ts_41 0 2.592e-12
Rtr_13_42_ts ts_13 ts_42 0.0675
Cp_42_ts ts_42 0 2.592e-12
Rtr_14_43_ts ts_14 ts_43 0.0675
Cp_43_ts ts_43 0 2.592e-12
Rtr_14_44_ts ts_14 ts_44 0.0675
Cp_44_ts ts_44 0 2.592e-12
Rtr_14_45_ts ts_14 ts_45 0.0675
Cp_45_ts ts_45 0 2.592e-12
Rtr_15_46_ts ts_15 ts_46 0.0675
Cp_46_ts ts_46 0 2.592e-12
Rtr_15_47_ts ts_15 ts_47 0.0675
Cp_47_ts ts_47 0 2.592e-12
Rtr_15_48_ts ts_15 ts_48 0.0675
Cp_48_ts ts_48 0 2.592e-12
Rtr_16_49_ts ts_16 ts_49 0.0675
Cp_49_ts ts_49 0 2.592e-12
Rtr_16_50_ts ts_16 ts_50 0.0675
Cp_50_ts ts_50 0 2.592e-12
Rtr_16_51_ts ts_16 ts_51 0.0675
Cp_51_ts ts_51 0 2.592e-12
Rtr_17_52_ts ts_17 ts_52 0.0675
Cp_52_ts ts_52 0 2.592e-12
Rtr_17_53_ts ts_17 ts_53 0.0675
Cp_53_ts ts_53 0 2.592e-12
Rtr_17_54_ts ts_17 ts_54 0.0675
Cp_54_ts ts_54 0 2.592e-12
Rtr_18_55_ts ts_18 ts_55 0.0675
Cp_55_ts ts_55 0 2.592e-12
Rtr_18_56_ts ts_18 ts_56 0.0675
Cp_56_ts ts_56 0 2.592e-12
Rtr_18_57_ts ts_18 ts_57 0.0675
Cp_57_ts ts_57 0 2.592e-12
Rtr_19_58_ts ts_19 ts_58 0.0675
Cp_58_ts ts_58 0 2.592e-12
Rtr_19_59_ts ts_19 ts_59 0.0675
Cp_59_ts ts_59 0 2.592e-12
Rtr_19_60_ts ts_19 ts_60 0.0675
Cp_60_ts ts_60 0 2.592e-12
Rtr_20_61_ts ts_20 ts_61 0.0675
Cp_61_ts ts_61 0 2.592e-12
Rtr_20_62_ts ts_20 ts_62 0.0675
Cp_62_ts ts_62 0 2.592e-12
Rtr_20_63_ts ts_20 ts_63 0.0675
Cp_63_ts ts_63 0 2.592e-12
Rtr_21_64_ts ts_21 ts_64 0.0675
Cp_64_ts ts_64 0 2.592e-12
Rtr_21_65_ts ts_21 ts_65 0.0675
Cp_65_ts ts_65 0 2.592e-12
Rtr_21_66_ts ts_21 ts_66 0.0675
Cp_66_ts ts_66 0 2.592e-12
Rtr_22_67_ts ts_22 ts_67 0.0675
Cp_67_ts ts_67 0 2.592e-12
Rtr_22_68_ts ts_22 ts_68 0.0675
Cp_68_ts ts_68 0 2.592e-12
Rtr_22_69_ts ts_22 ts_69 0.0675
Cp_69_ts ts_69 0 2.592e-12
Rtr_23_70_ts ts_23 ts_70 0.0675
Cp_70_ts ts_70 0 2.592e-12
Rtr_23_71_ts ts_23 ts_71 0.0675
Cp_71_ts ts_71 0 2.592e-12
Rtr_23_72_ts ts_23 ts_72 0.0675
Cp_72_ts ts_72 0 2.592e-12
Rtr_24_73_ts ts_24 ts_73 0.0675
Cp_73_ts ts_73 0 2.592e-12
Rtr_24_74_ts ts_24 ts_74 0.0675
Cp_74_ts ts_74 0 2.592e-12
Rtr_24_75_ts ts_24 ts_75 0.0675
Cp_75_ts ts_75 0 2.592e-12
Rtr_25_76_ts ts_25 ts_76 0.0675
Cp_76_ts ts_76 0 2.592e-12
Rtr_25_77_ts ts_25 ts_77 0.0675
Cp_77_ts ts_77 0 2.592e-12
Rtr_25_78_ts ts_25 ts_78 0.0675
Cp_78_ts ts_78 0 2.592e-12
Rtr_26_79_ts ts_26 ts_79 0.0675
Cp_79_ts ts_79 0 2.592e-12
Rtr_26_80_ts ts_26 ts_80 0.0675
Cp_80_ts ts_80 0 2.592e-12
Rtr_26_81_ts ts_26 ts_81 0.0675
Cp_81_ts ts_81 0 2.592e-12
Rtr_27_82_ts ts_27 ts_82 0.0675
Cp_82_ts ts_82 0 2.592e-12
Rtr_27_83_ts ts_27 ts_83 0.0675
Cp_83_ts ts_83 0 2.592e-12
Rtr_27_84_ts ts_27 ts_84 0.0675
Cp_84_ts ts_84 0 2.592e-12
Rtr_28_85_ts ts_28 ts_85 0.0675
Cp_85_ts ts_85 0 2.592e-12
Rtr_28_86_ts ts_28 ts_86 0.0675
Cp_86_ts ts_86 0 2.592e-12
Rtr_28_87_ts ts_28 ts_87 0.0675
Cp_87_ts ts_87 0 2.592e-12
Rtr_29_88_ts ts_29 ts_88 0.0675
Cp_88_ts ts_88 0 2.592e-12
Rtr_29_89_ts ts_29 ts_89 0.0675
Cp_89_ts ts_89 0 2.592e-12
Rtr_29_90_ts ts_29 ts_90 0.0675
Cp_90_ts ts_90 0 2.592e-12
Rtr_30_91_ts ts_30 ts_91 0.0675
Cp_91_ts ts_91 0 2.592e-12
Rtr_30_92_ts ts_30 ts_92 0.0675
Cp_92_ts ts_92 0 2.592e-12
Rtr_30_93_ts ts_30 ts_93 0.0675
Cp_93_ts ts_93 0 2.592e-12
Rtr_31_94_ts ts_31 ts_94 0.0675
Cp_94_ts ts_94 0 2.592e-12
Rtr_31_95_ts ts_31 ts_95 0.0675
Cp_95_ts ts_95 0 2.592e-12
Rtr_31_96_ts ts_31 ts_96 0.0675
Cp_96_ts ts_96 0 2.592e-12
Rtr_32_97_ts ts_32 ts_97 0.0675
Cp_97_ts ts_97 0 2.592e-12
Rtr_32_98_ts ts_32 ts_98 0.0675
Cp_98_ts ts_98 0 2.592e-12
Rtr_32_99_ts ts_32 ts_99 0.0675
Cp_99_ts ts_99 0 2.592e-12
Rtr_33_100_ts ts_33 ts_100 0.0675
Cp_100_ts ts_100 0 2.592e-12
Rtr_33_101_ts ts_33 ts_101 0.0675
Cp_101_ts ts_101 0 2.592e-12
Rtr_33_102_ts ts_33 ts_102 0.0675
Cp_102_ts ts_102 0 2.592e-12
Rtr_34_103_ts ts_34 ts_103 0.0675
Cp_103_ts ts_103 0 2.592e-12
Rtr_34_104_ts ts_34 ts_104 0.0675
Cp_104_ts ts_104 0 2.592e-12
Rtr_34_105_ts ts_34 ts_105 0.0675
Cp_105_ts ts_105 0 2.592e-12
Rtr_35_106_ts ts_35 ts_106 0.0675
Cp_106_ts ts_106 0 2.592e-12
Rtr_35_107_ts ts_35 ts_107 0.0675
Cp_107_ts ts_107 0 2.592e-12
Rtr_35_108_ts ts_35 ts_108 0.0675
Cp_108_ts ts_108 0 2.592e-12
Rtr_36_109_ts ts_36 ts_109 0.0675
Cp_109_ts ts_109 0 2.592e-12
Rtr_36_110_ts ts_36 ts_110 0.0675
Cp_110_ts ts_110 0 2.592e-12
Rtr_36_111_ts ts_36 ts_111 0.0675
Cp_111_ts ts_111 0 2.592e-12
Rtr_37_112_ts ts_37 ts_112 0.0675
Cp_112_ts ts_112 0 2.592e-12
Rtr_37_113_ts ts_37 ts_113 0.0675
Cp_113_ts ts_113 0 2.592e-12
Rtr_37_114_ts ts_37 ts_114 0.0675
Cp_114_ts ts_114 0 2.592e-12
Rtr_38_115_ts ts_38 ts_115 0.0675
Cp_115_ts ts_115 0 2.592e-12
Rtr_38_116_ts ts_38 ts_116 0.0675
Cp_116_ts ts_116 0 2.592e-12
Rtr_38_117_ts ts_38 ts_117 0.0675
Cp_117_ts ts_117 0 2.592e-12
Rtr_39_118_ts ts_39 ts_118 0.0675
Cp_118_ts ts_118 0 2.592e-12
Rtr_39_119_ts ts_39 ts_119 0.0675
Cp_119_ts ts_119 0 2.592e-12
Rtr_39_120_ts ts_39 ts_120 0.0675
Cp_120_ts ts_120 0 2.592e-12
Rlm_1_2_ts ts_1 ts_2 0.08
Rlm_4_5_ts ts_4 ts_5 0.12
Rlm_7_8_ts ts_7 ts_8 0.12
Rlm_10_11_ts ts_10 ts_11 0.12
Rlm_13_14_ts ts_13 ts_14 0.18
Rlm_16_17_ts ts_16 ts_17 0.18
Rlm_19_20_ts ts_19 ts_20 0.18
Rlm_22_23_ts ts_22 ts_23 0.18
Rlm_25_26_ts ts_25 ts_26 0.18
Rlm_28_29_ts ts_28 ts_29 0.18
Rlm_31_32_ts ts_31 ts_32 0.18
Rlm_34_35_ts ts_34 ts_35 0.18
Rlm_37_38_ts ts_37 ts_38 0.18
Rlm_40_41_ts ts_40 ts_41 0.27
Rlm_43_44_ts ts_43 ts_44 0.27
Rlm_46_47_ts ts_46 ts_47 0.27
Rlm_49_50_ts ts_49 ts_50 0.27
Rlm_52_53_ts ts_52 ts_53 0.27
Rlm_55_56_ts ts_55 ts_56 0.27
Rlm_58_59_ts ts_58 ts_59 0.27
Rlm_61_62_ts ts_61 ts_62 0.27
Rlm_64_65_ts ts_64 ts_65 0.27
Rlm_67_68_ts ts_67 ts_68 0.27
Rlm_70_71_ts ts_70 ts_71 0.27
Rlm_73_74_ts ts_73 ts_74 0.27
Rlm_76_77_ts ts_76 ts_77 0.27
Rlm_79_80_ts ts_79 ts_80 0.27
Rlm_82_83_ts ts_82 ts_83 0.27
Rlm_85_86_ts ts_85 ts_86 0.27
Rlm_88_89_ts ts_88 ts_89 0.27
Rlm_91_92_ts ts_91 ts_92 0.27
Rlm_94_95_ts ts_94 ts_95 0.27
Rlm_97_98_ts ts_97 ts_98 0.27
Rlm_100_101_ts ts_100 ts_101 0.27
Rlm_103_104_ts ts_103 ts_104 0.27
Rlm_106_107_ts ts_106 ts_107 0.27
Rlm_109_110_ts ts_109 ts_110 0.27
Rlm_112_113_ts ts_112 ts_113 0.27
Rlm_115_116_ts ts_115 ts_116 0.27
Rlm_118_119_ts ts_118 ts_119 0.27
Ccpl_40_46_ts ts_40 ts_46 2e-12
Ccpl_46_52_ts ts_46 ts_52 2e-12
Ccpl_52_58_ts ts_52 ts_58 2e-12
Ccpl_58_64_ts ts_58 ts_64 2e-12
Ccpl_64_70_ts ts_64 ts_70 2e-12
Ccpl_70_76_ts ts_70 ts_76 2e-12
Ccpl_76_82_ts ts_76 ts_82 2e-12
Ccpl_82_88_ts ts_82 ts_88 2e-12
Ccpl_88_94_ts ts_88 ts_94 2e-12
Ccpl_94_100_ts ts_94 ts_100 2e-12
Ccpl_100_106_ts ts_100 ts_106 2e-12
Ccpl_106_112_ts ts_106 ts_112 2e-12
Rcpl_tg ghs tg_0 0.5
* tree-shaped synthetic PEX net: branch=3 depth=4, rtrace0=0.5 (x1.5/level), cplane0=2e-12 (x0.6/level), local-mesh-stride=3, coupling-caps=12
Cp_0_tg tg_0 0 2e-12
Rtr_0_1_tg tg_0 tg_1 0.5
Cp_1_tg tg_1 0 1.2e-12
Rtr_0_2_tg tg_0 tg_2 0.5
Cp_2_tg tg_2 0 1.2e-12
Rtr_0_3_tg tg_0 tg_3 0.5
Cp_3_tg tg_3 0 1.2e-12
Rtr_1_4_tg tg_1 tg_4 0.75
Cp_4_tg tg_4 0 7.2e-13
Rtr_1_5_tg tg_1 tg_5 0.75
Cp_5_tg tg_5 0 7.2e-13
Rtr_1_6_tg tg_1 tg_6 0.75
Cp_6_tg tg_6 0 7.2e-13
Rtr_2_7_tg tg_2 tg_7 0.75
Cp_7_tg tg_7 0 7.2e-13
Rtr_2_8_tg tg_2 tg_8 0.75
Cp_8_tg tg_8 0 7.2e-13
Rtr_2_9_tg tg_2 tg_9 0.75
Cp_9_tg tg_9 0 7.2e-13
Rtr_3_10_tg tg_3 tg_10 0.75
Cp_10_tg tg_10 0 7.2e-13
Rtr_3_11_tg tg_3 tg_11 0.75
Cp_11_tg tg_11 0 7.2e-13
Rtr_3_12_tg tg_3 tg_12 0.75
Cp_12_tg tg_12 0 7.2e-13
Rtr_4_13_tg tg_4 tg_13 1.125
Cp_13_tg tg_13 0 4.32e-13
Rtr_4_14_tg tg_4 tg_14 1.125
Cp_14_tg tg_14 0 4.32e-13
Rtr_4_15_tg tg_4 tg_15 1.125
Cp_15_tg tg_15 0 4.32e-13
Rtr_5_16_tg tg_5 tg_16 1.125
Cp_16_tg tg_16 0 4.32e-13
Rtr_5_17_tg tg_5 tg_17 1.125
Cp_17_tg tg_17 0 4.32e-13
Rtr_5_18_tg tg_5 tg_18 1.125
Cp_18_tg tg_18 0 4.32e-13
Rtr_6_19_tg tg_6 tg_19 1.125
Cp_19_tg tg_19 0 4.32e-13
Rtr_6_20_tg tg_6 tg_20 1.125
Cp_20_tg tg_20 0 4.32e-13
Rtr_6_21_tg tg_6 tg_21 1.125
Cp_21_tg tg_21 0 4.32e-13
Rtr_7_22_tg tg_7 tg_22 1.125
Cp_22_tg tg_22 0 4.32e-13
Rtr_7_23_tg tg_7 tg_23 1.125
Cp_23_tg tg_23 0 4.32e-13
Rtr_7_24_tg tg_7 tg_24 1.125
Cp_24_tg tg_24 0 4.32e-13
Rtr_8_25_tg tg_8 tg_25 1.125
Cp_25_tg tg_25 0 4.32e-13
Rtr_8_26_tg tg_8 tg_26 1.125
Cp_26_tg tg_26 0 4.32e-13
Rtr_8_27_tg tg_8 tg_27 1.125
Cp_27_tg tg_27 0 4.32e-13
Rtr_9_28_tg tg_9 tg_28 1.125
Cp_28_tg tg_28 0 4.32e-13
Rtr_9_29_tg tg_9 tg_29 1.125
Cp_29_tg tg_29 0 4.32e-13
Rtr_9_30_tg tg_9 tg_30 1.125
Cp_30_tg tg_30 0 4.32e-13
Rtr_10_31_tg tg_10 tg_31 1.125
Cp_31_tg tg_31 0 4.32e-13
Rtr_10_32_tg tg_10 tg_32 1.125
Cp_32_tg tg_32 0 4.32e-13
Rtr_10_33_tg tg_10 tg_33 1.125
Cp_33_tg tg_33 0 4.32e-13
Rtr_11_34_tg tg_11 tg_34 1.125
Cp_34_tg tg_34 0 4.32e-13
Rtr_11_35_tg tg_11 tg_35 1.125
Cp_35_tg tg_35 0 4.32e-13
Rtr_11_36_tg tg_11 tg_36 1.125
Cp_36_tg tg_36 0 4.32e-13
Rtr_12_37_tg tg_12 tg_37 1.125
Cp_37_tg tg_37 0 4.32e-13
Rtr_12_38_tg tg_12 tg_38 1.125
Cp_38_tg tg_38 0 4.32e-13
Rtr_12_39_tg tg_12 tg_39 1.125
Cp_39_tg tg_39 0 4.32e-13
Rtr_13_40_tg tg_13 tg_40 1.6875
Cp_40_tg tg_40 0 2.592e-13
Rtr_13_41_tg tg_13 tg_41 1.6875
Cp_41_tg tg_41 0 2.592e-13
Rtr_13_42_tg tg_13 tg_42 1.6875
Cp_42_tg tg_42 0 2.592e-13
Rtr_14_43_tg tg_14 tg_43 1.6875
Cp_43_tg tg_43 0 2.592e-13
Rtr_14_44_tg tg_14 tg_44 1.6875
Cp_44_tg tg_44 0 2.592e-13
Rtr_14_45_tg tg_14 tg_45 1.6875
Cp_45_tg tg_45 0 2.592e-13
Rtr_15_46_tg tg_15 tg_46 1.6875
Cp_46_tg tg_46 0 2.592e-13
Rtr_15_47_tg tg_15 tg_47 1.6875
Cp_47_tg tg_47 0 2.592e-13
Rtr_15_48_tg tg_15 tg_48 1.6875
Cp_48_tg tg_48 0 2.592e-13
Rtr_16_49_tg tg_16 tg_49 1.6875
Cp_49_tg tg_49 0 2.592e-13
Rtr_16_50_tg tg_16 tg_50 1.6875
Cp_50_tg tg_50 0 2.592e-13
Rtr_16_51_tg tg_16 tg_51 1.6875
Cp_51_tg tg_51 0 2.592e-13
Rtr_17_52_tg tg_17 tg_52 1.6875
Cp_52_tg tg_52 0 2.592e-13
Rtr_17_53_tg tg_17 tg_53 1.6875
Cp_53_tg tg_53 0 2.592e-13
Rtr_17_54_tg tg_17 tg_54 1.6875
Cp_54_tg tg_54 0 2.592e-13
Rtr_18_55_tg tg_18 tg_55 1.6875
Cp_55_tg tg_55 0 2.592e-13
Rtr_18_56_tg tg_18 tg_56 1.6875
Cp_56_tg tg_56 0 2.592e-13
Rtr_18_57_tg tg_18 tg_57 1.6875
Cp_57_tg tg_57 0 2.592e-13
Rtr_19_58_tg tg_19 tg_58 1.6875
Cp_58_tg tg_58 0 2.592e-13
Rtr_19_59_tg tg_19 tg_59 1.6875
Cp_59_tg tg_59 0 2.592e-13
Rtr_19_60_tg tg_19 tg_60 1.6875
Cp_60_tg tg_60 0 2.592e-13
Rtr_20_61_tg tg_20 tg_61 1.6875
Cp_61_tg tg_61 0 2.592e-13
Rtr_20_62_tg tg_20 tg_62 1.6875
Cp_62_tg tg_62 0 2.592e-13
Rtr_20_63_tg tg_20 tg_63 1.6875
Cp_63_tg tg_63 0 2.592e-13
Rtr_21_64_tg tg_21 tg_64 1.6875
Cp_64_tg tg_64 0 2.592e-13
Rtr_21_65_tg tg_21 tg_65 1.6875
Cp_65_tg tg_65 0 2.592e-13
Rtr_21_66_tg tg_21 tg_66 1.6875
Cp_66_tg tg_66 0 2.592e-13
Rtr_22_67_tg tg_22 tg_67 1.6875
Cp_67_tg tg_67 0 2.592e-13
Rtr_22_68_tg tg_22 tg_68 1.6875
Cp_68_tg tg_68 0 2.592e-13
Rtr_22_69_tg tg_22 tg_69 1.6875
Cp_69_tg tg_69 0 2.592e-13
Rtr_23_70_tg tg_23 tg_70 1.6875
Cp_70_tg tg_70 0 2.592e-13
Rtr_23_71_tg tg_23 tg_71 1.6875
Cp_71_tg tg_71 0 2.592e-13
Rtr_23_72_tg tg_23 tg_72 1.6875
Cp_72_tg tg_72 0 2.592e-13
Rtr_24_73_tg tg_24 tg_73 1.6875
Cp_73_tg tg_73 0 2.592e-13
Rtr_24_74_tg tg_24 tg_74 1.6875
Cp_74_tg tg_74 0 2.592e-13
Rtr_24_75_tg tg_24 tg_75 1.6875
Cp_75_tg tg_75 0 2.592e-13
Rtr_25_76_tg tg_25 tg_76 1.6875
Cp_76_tg tg_76 0 2.592e-13
Rtr_25_77_tg tg_25 tg_77 1.6875
Cp_77_tg tg_77 0 2.592e-13
Rtr_25_78_tg tg_25 tg_78 1.6875
Cp_78_tg tg_78 0 2.592e-13
Rtr_26_79_tg tg_26 tg_79 1.6875
Cp_79_tg tg_79 0 2.592e-13
Rtr_26_80_tg tg_26 tg_80 1.6875
Cp_80_tg tg_80 0 2.592e-13
Rtr_26_81_tg tg_26 tg_81 1.6875
Cp_81_tg tg_81 0 2.592e-13
Rtr_27_82_tg tg_27 tg_82 1.6875
Cp_82_tg tg_82 0 2.592e-13
Rtr_27_83_tg tg_27 tg_83 1.6875
Cp_83_tg tg_83 0 2.592e-13
Rtr_27_84_tg tg_27 tg_84 1.6875
Cp_84_tg tg_84 0 2.592e-13
Rtr_28_85_tg tg_28 tg_85 1.6875
Cp_85_tg tg_85 0 2.592e-13
Rtr_28_86_tg tg_28 tg_86 1.6875
Cp_86_tg tg_86 0 2.592e-13
Rtr_28_87_tg tg_28 tg_87 1.6875
Cp_87_tg tg_87 0 2.592e-13
Rtr_29_88_tg tg_29 tg_88 1.6875
Cp_88_tg tg_88 0 2.592e-13
Rtr_29_89_tg tg_29 tg_89 1.6875
Cp_89_tg tg_89 0 2.592e-13
Rtr_29_90_tg tg_29 tg_90 1.6875
Cp_90_tg tg_90 0 2.592e-13
Rtr_30_91_tg tg_30 tg_91 1.6875
Cp_91_tg tg_91 0 2.592e-13
Rtr_30_92_tg tg_30 tg_92 1.6875
Cp_92_tg tg_92 0 2.592e-13
Rtr_30_93_tg tg_30 tg_93 1.6875
Cp_93_tg tg_93 0 2.592e-13
Rtr_31_94_tg tg_31 tg_94 1.6875
Cp_94_tg tg_94 0 2.592e-13
Rtr_31_95_tg tg_31 tg_95 1.6875
Cp_95_tg tg_95 0 2.592e-13
Rtr_31_96_tg tg_31 tg_96 1.6875
Cp_96_tg tg_96 0 2.592e-13
Rtr_32_97_tg tg_32 tg_97 1.6875
Cp_97_tg tg_97 0 2.592e-13
Rtr_32_98_tg tg_32 tg_98 1.6875
Cp_98_tg tg_98 0 2.592e-13
Rtr_32_99_tg tg_32 tg_99 1.6875
Cp_99_tg tg_99 0 2.592e-13
Rtr_33_100_tg tg_33 tg_100 1.6875
Cp_100_tg tg_100 0 2.592e-13
Rtr_33_101_tg tg_33 tg_101 1.6875
Cp_101_tg tg_101 0 2.592e-13
Rtr_33_102_tg tg_33 tg_102 1.6875
Cp_102_tg tg_102 0 2.592e-13
Rtr_34_103_tg tg_34 tg_103 1.6875
Cp_103_tg tg_103 0 2.592e-13
Rtr_34_104_tg tg_34 tg_104 1.6875
Cp_104_tg tg_104 0 2.592e-13
Rtr_34_105_tg tg_34 tg_105 1.6875
Cp_105_tg tg_105 0 2.592e-13
Rtr_35_106_tg tg_35 tg_106 1.6875
Cp_106_tg tg_106 0 2.592e-13
Rtr_35_107_tg tg_35 tg_107 1.6875
Cp_107_tg tg_107 0 2.592e-13
Rtr_35_108_tg tg_35 tg_108 1.6875
Cp_108_tg tg_108 0 2.592e-13
Rtr_36_109_tg tg_36 tg_109 1.6875
Cp_109_tg tg_109 0 2.592e-13
Rtr_36_110_tg tg_36 tg_110 1.6875
Cp_110_tg tg_110 0 2.592e-13
Rtr_36_111_tg tg_36 tg_111 1.6875
Cp_111_tg tg_111 0 2.592e-13
Rtr_37_112_tg tg_37 tg_112 1.6875
Cp_112_tg tg_112 0 2.592e-13
Rtr_37_113_tg tg_37 tg_113 1.6875
Cp_113_tg tg_113 0 2.592e-13
Rtr_37_114_tg tg_37 tg_114 1.6875
Cp_114_tg tg_114 0 2.592e-13
Rtr_38_115_tg tg_38 tg_115 1.6875
Cp_115_tg tg_115 0 2.592e-13
Rtr_38_116_tg tg_38 tg_116 1.6875
Cp_116_tg tg_116 0 2.592e-13
Rtr_38_117_tg tg_38 tg_117 1.6875
Cp_117_tg tg_117 0 2.592e-13
Rtr_39_118_tg tg_39 tg_118 1.6875
Cp_118_tg tg_118 0 2.592e-13
Rtr_39_119_tg tg_39 tg_119 1.6875
Cp_119_tg tg_119 0 2.592e-13
Rtr_39_120_tg tg_39 tg_120 1.6875
Cp_120_tg tg_120 0 2.592e-13
Rlm_1_2_tg tg_1 tg_2 2
Rlm_4_5_tg tg_4 tg_5 3
Rlm_7_8_tg tg_7 tg_8 3
Rlm_10_11_tg tg_10 tg_11 3
Rlm_13_14_tg tg_13 tg_14 4.5
Rlm_16_17_tg tg_16 tg_17 4.5
Rlm_19_20_tg tg_19 tg_20 4.5
Rlm_22_23_tg tg_22 tg_23 4.5
Rlm_25_26_tg tg_25 tg_26 4.5
Rlm_28_29_tg tg_28 tg_29 4.5
Rlm_31_32_tg tg_31 tg_32 4.5
Rlm_34_35_tg tg_34 tg_35 4.5
Rlm_37_38_tg tg_37 tg_38 4.5
Rlm_40_41_tg tg_40 tg_41 6.75
Rlm_43_44_tg tg_43 tg_44 6.75
Rlm_46_47_tg tg_46 tg_47 6.75
Rlm_49_50_tg tg_49 tg_50 6.75
Rlm_52_53_tg tg_52 tg_53 6.75
Rlm_55_56_tg tg_55 tg_56 6.75
Rlm_58_59_tg tg_58 tg_59 6.75
Rlm_61_62_tg tg_61 tg_62 6.75
Rlm_64_65_tg tg_64 tg_65 6.75
Rlm_67_68_tg tg_67 tg_68 6.75
Rlm_70_71_tg tg_70 tg_71 6.75
Rlm_73_74_tg tg_73 tg_74 6.75
Rlm_76_77_tg tg_76 tg_77 6.75
Rlm_79_80_tg tg_79 tg_80 6.75
Rlm_82_83_tg tg_82 tg_83 6.75
Rlm_85_86_tg tg_85 tg_86 6.75
Rlm_88_89_tg tg_88 tg_89 6.75
Rlm_91_92_tg tg_91 tg_92 6.75
Rlm_94_95_tg tg_94 tg_95 6.75
Rlm_97_98_tg tg_97 tg_98 6.75
Rlm_100_101_tg tg_100 tg_101 6.75
Rlm_103_104_tg tg_103 tg_104 6.75
Rlm_106_107_tg tg_106 tg_107 6.75
Rlm_109_110_tg tg_109 tg_110 6.75
Rlm_112_113_tg tg_112 tg_113 6.75
Rlm_115_116_tg tg_115 tg_116 6.75
Rlm_118_119_tg tg_118 tg_119 6.75
Ccpl_40_46_tg tg_40 tg_46 2e-13
Ccpl_46_52_tg tg_46 tg_52 2e-13
Ccpl_52_58_tg tg_52 tg_58 2e-13
Ccpl_58_64_tg tg_58 tg_64 2e-13
Ccpl_64_70_tg tg_64 tg_70 2e-13
Ccpl_70_76_tg tg_70 tg_76 2e-13
Ccpl_76_82_tg tg_76 tg_82 2e-13
Ccpl_82_88_tg tg_82 tg_88 2e-13
Ccpl_88_94_tg tg_88 tg_94 2e-13
Ccpl_94_100_tg tg_94 tg_100 2e-13
Ccpl_100_106_tg tg_100 tg_106 2e-13
Ccpl_106_112_tg tg_106 tg_112 2e-13
* 399 parasitic capacitors, 480 parasitic resistors

.control
set filetype=ascii
save v(vout) v(opout) v(sw) i(L1) i(Vin)
tran 2n 400u 0 uic
meas tran vout_avg AVG v(vout) FROM=380u TO=400u
meas tran vout_max MAX v(vout) FROM=390u TO=400u
meas tran vout_min MIN v(vout) FROM=390u TO=400u
print vout_avg vout_max vout_min
.endc
.end
