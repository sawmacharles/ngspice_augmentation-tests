* R1b two-stage Miller amplifier with a reverse path, gain of 2 (ngspice_augmentation, card #450, 2026-09-27)
* Linear. Cf (vn -> n1) and Cc (n1 -> oa) give reverse transmission around the break, so Y12 != 0
* and Tian, Middlebrook and single-injection results differ. Reference: two-port Y parameters of the
* broken loop, measured by tests/test_stb.py with port sources in place of XP.
* Probe XP breaks the loop between the amplifier output oa (upstream, b) and the load node ol (downstream, a).
.param gm1=1m r1o=1Meg c1=0.2p gm2=5m r2o=50k cc=1p ro1=20k ro2=20k cl=5p cin=0.5p cf=0.1p
.include ../stb/lgprobe.lib
Vp vp 0 DC 0 AC 0
G1 n1 0 vp vn {gm1}
R1o n1 0 {r1o}
C1 n1 0 {c1}
G2 oa 0 n1 0 {gm2}
R2o oa 0 {r2o}
Cc n1 oa {cc}
XP ol oa lgprobe
CL ol 0 {cl}
Rf1 ol vn {ro1}
Rf2 vn 0 {ro2}
Cin vn 0 {cin}
Cf vn n1 {cf}
.end
